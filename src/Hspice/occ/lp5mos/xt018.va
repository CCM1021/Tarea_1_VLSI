//xt018 Occ file V12.1.3 for hSpice build by X-Fab
`include "discipline.h"
`include "constants.h"

`define msgLimit 25

module rmOccErr;
    parameter maxEv_flg=0;
    parameter errFileName="./occ.err";
    integer outfile;
analog begin
   @(initial_step) begin
     outfile=$fopen("./lastErrFile.loc","w");
     $fwrite(outfile, "%s\n",errFileName);
     $fclose(outfile);
     outfile=$fopen(errFileName,"w");
  if(( maxEv_flg!=0 ))  begin
    $fwrite(outfile, "\n");
    $strobe("");
    $strobe( "*** The number of errors is limited to 25.");
    $strobe( "*** For another value place a parameter definition maxEv\n");
    $strobe( "*** with the new value after the model and occ definitions.");
    $strobe( "");
  end
    $fwrite(outfile, "\n");
    $fwrite(outfile, "Required OCV version : V 1.0.4\n");
    $fwrite(outfile, "\n");
     $fwrite(outfile, "Operating condition error file \n\n");
     $fwrite(outfile,"Dev            OC-   \n");
     $fwrite(outfile,"              Para    Event        Limit                                  Time        Instance\n\n");
     $fclose(outfile);

   end
   @(final_step) begin
     outfile=$fopen(errFileName,"a");

     $fwrite(outfile, "\n\nSimulation end: %7.4r \n",$abstime);
     $fwrite(outfile, "\nEnd of operating condition error file\n");
     $fclose(outfile);

   end
end
endmodule

// Verilog-A OC Watch for device ne Parameters  VGS VGD VDS VDB VSB
module ne_ahdl(D,G,S,B);
parameter tstep_occ=100n;
parameter errFileName="./occ.err";
parameter maxEv = 25;
parameter maxEv_flg = 0;
inout D,G,S,B;
electrical D,G,S,B;

integer outfile;
real V_S_B;
real V_D_B;
real V_D_S;
real V_G_D;
real V_G_S;
real VGS;
integer VGS_retc;
integer VGS_cnt;
real VGD;
integer VGD_retc;
integer VGD_cnt;
real VDS;
integer VDS_retc;
integer VDS_cnt;
real VDB;
integer VDB_retc;
integer VDB_cnt;
real VSB;
integer VSB_retc;
integer VSB_cnt;

analog begin
   $bound_step( tstep_occ );
   @(initial_step) begin
      VGS_retc=0;
      VGS_cnt = maxEv;
      VGD_retc=0;
      VGD_cnt = maxEv;
      VDS_retc=0;
      VDS_cnt = maxEv;
      VDB_retc=0;
      VDB_cnt = maxEv;
      VSB_retc=0;
      VSB_cnt = maxEv;
   end
   V_S_B = V(S,B);
   V_D_B = V(D,B);
   V_D_S = V(D,S);
   V_G_D = V(G,D);
   V_G_S = V(G,S);

//      VGS
   VGS = V_G_S;
   if((VGS_cnt>0) || ( maxEv_flg==0 ))   begin
      if( (VGS < -1.98) && (VGS_retc!=-1))
      begin
        outfile=$fopen(errFileName,"a");
        $strobe("ne            VGS     leaving   OCA (  .. -1.980 V ) at %7.4r  %M", $abstime );
        $fwrite(outfile,"ne            VGS     leaving   OCA (  .. -1.980 V ) at %7.4r  %M\n", $abstime );
        VGS_retc=-1;
        VGS_cnt=VGS_cnt-1;
        $fclose(outfile);
      end
      if((VGS >= -1.98) &&  (VGS <= 1.98) && (VGS_retc!=0))
      begin
        outfile=$fopen(errFileName,"a");
        $strobe("ne            VGS     entering SOCA ( -1.980 V .. 1.980 V ) at %7.4r  %M", $abstime );
        $fwrite(outfile,"ne            VGS     entering SOCA ( -1.980 V .. 1.980 V ) at %7.4r  %M\n", $abstime );
        VGS_retc=0;
        VGS_cnt=VGS_cnt-1;
        $fclose(outfile);
      end
      if((VGS > 1.98) &&  (VGS_retc!=1))
      begin
        outfile=$fopen(errFileName,"a");
        $strobe("ne            VGS     leaving   OCA ( 1.980 V ..  ) at %7.4r  %M", $abstime );
        $fwrite(outfile,"ne            VGS     leaving   OCA ( 1.980 V ..  ) at %7.4r  %M\n", $abstime );
        VGS_retc=1;
        VGS_cnt=VGS_cnt-1;
        $fclose(outfile);
      end
   end
   else
   begin
      if(VGS_cnt==0)
      begin
        outfile=$fopen(errFileName,"a");
        $strobe("ne            VGS     error limit ( %d ) reached at %7.4r  %M", maxEv, $abstime );
        $fwrite(outfile,"ne            VGS     error limit ( %d ) reached at %7.4r  %M\n", maxEv, $abstime );
        VGS_cnt=VGS_cnt-1;
        $fclose(outfile);
      end
   end

//      VGD
   VGD = V_G_D;
   if((VGD_cnt>0) || ( maxEv_flg==0 ))   begin
      if( (VGD < -1.98) && (VGD_retc!=-1))
      begin
        outfile=$fopen(errFileName,"a");
        $strobe("ne            VGD     leaving   OCA (  .. -1.980 V ) at %7.4r  %M", $abstime );
        $fwrite(outfile,"ne            VGD     leaving   OCA (  .. -1.980 V ) at %7.4r  %M\n", $abstime );
        VGD_retc=-1;
        VGD_cnt=VGD_cnt-1;
        $fclose(outfile);
      end
      if((VGD >= -1.98) &&  (VGD <= 1.98) && (VGD_retc!=0))
      begin
        outfile=$fopen(errFileName,"a");
        $strobe("ne            VGD     entering SOCA ( -1.980 V .. 1.980 V ) at %7.4r  %M", $abstime );
        $fwrite(outfile,"ne            VGD     entering SOCA ( -1.980 V .. 1.980 V ) at %7.4r  %M\n", $abstime );
        VGD_retc=0;
        VGD_cnt=VGD_cnt-1;
        $fclose(outfile);
      end
      if((VGD > 1.98) &&  (VGD_retc!=1))
      begin
        outfile=$fopen(errFileName,"a");
        $strobe("ne            VGD     leaving   OCA ( 1.980 V ..  ) at %7.4r  %M", $abstime );
        $fwrite(outfile,"ne            VGD     leaving   OCA ( 1.980 V ..  ) at %7.4r  %M\n", $abstime );
        VGD_retc=1;
        VGD_cnt=VGD_cnt-1;
        $fclose(outfile);
      end
   end
   else
   begin
      if(VGD_cnt==0)
      begin
        outfile=$fopen(errFileName,"a");
        $strobe("ne            VGD     error limit ( %d ) reached at %7.4r  %M", maxEv, $abstime );
        $fwrite(outfile,"ne            VGD     error limit ( %d ) reached at %7.4r  %M\n", maxEv, $abstime );
        VGD_cnt=VGD_cnt-1;
        $fclose(outfile);
      end
   end

//      VDS
   VDS = V_D_S;
   if((VDS_cnt>0) || ( maxEv_flg==0 ))   begin
      if( (VDS < -1.98) && (VDS_retc!=-1))
      begin
        outfile=$fopen(errFileName,"a");
        $strobe("ne            VDS     leaving   OCA (  .. -1.980 V ) at %7.4r  %M", $abstime );
        $fwrite(outfile,"ne            VDS     leaving   OCA (  .. -1.980 V ) at %7.4r  %M\n", $abstime );
        VDS_retc=-1;
        VDS_cnt=VDS_cnt-1;
        $fclose(outfile);
      end
      if((VDS >= -1.98) &&  (VDS <= 1.98) && (VDS_retc!=0))
      begin
        outfile=$fopen(errFileName,"a");
        $strobe("ne            VDS     entering SOCA ( -1.980 V .. 1.980 V ) at %7.4r  %M", $abstime );
        $fwrite(outfile,"ne            VDS     entering SOCA ( -1.980 V .. 1.980 V ) at %7.4r  %M\n", $abstime );
        VDS_retc=0;
        VDS_cnt=VDS_cnt-1;
        $fclose(outfile);
      end
      if((VDS > 1.98) &&  (VDS_retc!=1))
      begin
        outfile=$fopen(errFileName,"a");
        $strobe("ne            VDS     leaving   OCA ( 1.980 V ..  ) at %7.4r  %M", $abstime );
        $fwrite(outfile,"ne            VDS     leaving   OCA ( 1.980 V ..  ) at %7.4r  %M\n", $abstime );
        VDS_retc=1;
        VDS_cnt=VDS_cnt-1;
        $fclose(outfile);
      end
   end
   else
   begin
      if(VDS_cnt==0)
      begin
        outfile=$fopen(errFileName,"a");
        $strobe("ne            VDS     error limit ( %d ) reached at %7.4r  %M", maxEv, $abstime );
        $fwrite(outfile,"ne            VDS     error limit ( %d ) reached at %7.4r  %M\n", maxEv, $abstime );
        VDS_cnt=VDS_cnt-1;
        $fclose(outfile);
      end
   end

//      VDB
   VDB = V_D_B;
   if((VDB_cnt>0) || ( maxEv_flg==0 ))   begin
      if( (VDB < -0.1) && (VDB_retc!=-1))
      begin
        outfile=$fopen(errFileName,"a");
        $strobe("ne            VDB     leaving   OCA (  .. -0.100 V ) at %7.4r  %M", $abstime );
        $fwrite(outfile,"ne            VDB     leaving   OCA (  .. -0.100 V ) at %7.4r  %M\n", $abstime );
        VDB_retc=-1;
        VDB_cnt=VDB_cnt-1;
        $fclose(outfile);
      end
      if((VDB >= -0.1) &&  (VDB <= 1.98) && (VDB_retc!=0))
      begin
        outfile=$fopen(errFileName,"a");
        $strobe("ne            VDB     entering SOCA ( -0.100 V .. 1.980 V ) at %7.4r  %M", $abstime );
        $fwrite(outfile,"ne            VDB     entering SOCA ( -0.100 V .. 1.980 V ) at %7.4r  %M\n", $abstime );
        VDB_retc=0;
        VDB_cnt=VDB_cnt-1;
        $fclose(outfile);
      end
      if((VDB > 1.98) &&  (VDB_retc!=1))
      begin
        outfile=$fopen(errFileName,"a");
        $strobe("ne            VDB     leaving   OCA ( 1.980 V ..  ) at %7.4r  %M", $abstime );
        $fwrite(outfile,"ne            VDB     leaving   OCA ( 1.980 V ..  ) at %7.4r  %M\n", $abstime );
        VDB_retc=1;
        VDB_cnt=VDB_cnt-1;
        $fclose(outfile);
      end
   end
   else
   begin
      if(VDB_cnt==0)
      begin
        outfile=$fopen(errFileName,"a");
        $strobe("ne            VDB     error limit ( %d ) reached at %7.4r  %M", maxEv, $abstime );
        $fwrite(outfile,"ne            VDB     error limit ( %d ) reached at %7.4r  %M\n", maxEv, $abstime );
        VDB_cnt=VDB_cnt-1;
        $fclose(outfile);
      end
   end

//      VSB
   VSB = V_S_B;
   if((VSB_cnt>0) || ( maxEv_flg==0 ))   begin
      if( (VSB < -0.1) && (VSB_retc!=-1))
      begin
        outfile=$fopen(errFileName,"a");
        $strobe("ne            VSB     leaving   OCA (  .. -0.100 V ) at %7.4r  %M", $abstime );
        $fwrite(outfile,"ne            VSB     leaving   OCA (  .. -0.100 V ) at %7.4r  %M\n", $abstime );
        VSB_retc=-1;
        VSB_cnt=VSB_cnt-1;
        $fclose(outfile);
      end
      if((VSB >= -0.1) &&  (VSB <= 1.98) && (VSB_retc!=0))
      begin
        outfile=$fopen(errFileName,"a");
        $strobe("ne            VSB     entering SOCA ( -0.100 V .. 1.980 V ) at %7.4r  %M", $abstime );
        $fwrite(outfile,"ne            VSB     entering SOCA ( -0.100 V .. 1.980 V ) at %7.4r  %M\n", $abstime );
        VSB_retc=0;
        VSB_cnt=VSB_cnt-1;
        $fclose(outfile);
      end
      if((VSB > 1.98) &&  (VSB_retc!=1))
      begin
        outfile=$fopen(errFileName,"a");
        $strobe("ne            VSB     leaving   OCA ( 1.980 V ..  ) at %7.4r  %M", $abstime );
        $fwrite(outfile,"ne            VSB     leaving   OCA ( 1.980 V ..  ) at %7.4r  %M\n", $abstime );
        VSB_retc=1;
        VSB_cnt=VSB_cnt-1;
        $fclose(outfile);
      end
   end
   else
   begin
      if(VSB_cnt==0)
      begin
        outfile=$fopen(errFileName,"a");
        $strobe("ne            VSB     error limit ( %d ) reached at %7.4r  %M", maxEv, $abstime );
        $fwrite(outfile,"ne            VSB     error limit ( %d ) reached at %7.4r  %M\n", maxEv, $abstime );
        VSB_cnt=VSB_cnt-1;
        $fclose(outfile);
      end
   end

end // analog
endmodule // ne

// Verilog-A OC Watch for device nn Parameters  VGS VGD VDS VDB VSB
module nn_ahdl(D,G,S,B);
parameter tstep_occ=100n;
parameter errFileName="./occ.err";
parameter maxEv = 25;
parameter maxEv_flg = 0;
inout D,G,S,B;
electrical D,G,S,B;

integer outfile;
real V_S_B;
real V_D_B;
real V_D_S;
real V_G_D;
real V_G_S;
real VGS;
integer VGS_retc;
integer VGS_cnt;
real VGD;
integer VGD_retc;
integer VGD_cnt;
real VDS;
integer VDS_retc;
integer VDS_cnt;
real VDB;
integer VDB_retc;
integer VDB_cnt;
real VSB;
integer VSB_retc;
integer VSB_cnt;

analog begin
   $bound_step( tstep_occ );
   @(initial_step) begin
      VGS_retc=0;
      VGS_cnt = maxEv;
      VGD_retc=0;
      VGD_cnt = maxEv;
      VDS_retc=0;
      VDS_cnt = maxEv;
      VDB_retc=0;
      VDB_cnt = maxEv;
      VSB_retc=0;
      VSB_cnt = maxEv;
   end
   V_S_B = V(S,B);
   V_D_B = V(D,B);
   V_D_S = V(D,S);
   V_G_D = V(G,D);
   V_G_S = V(G,S);

//      VGS
   VGS = V_G_S;
   if((VGS_cnt>0) || ( maxEv_flg==0 ))   begin
      if( (VGS < -1.98) && (VGS_retc!=-1))
      begin
        outfile=$fopen(errFileName,"a");
        $strobe("nn            VGS     leaving   OCA (  .. -1.980 V ) at %7.4r  %M", $abstime );
        $fwrite(outfile,"nn            VGS     leaving   OCA (  .. -1.980 V ) at %7.4r  %M\n", $abstime );
        VGS_retc=-1;
        VGS_cnt=VGS_cnt-1;
        $fclose(outfile);
      end
      if((VGS >= -1.98) &&  (VGS <= 1.98) && (VGS_retc!=0))
      begin
        outfile=$fopen(errFileName,"a");
        $strobe("nn            VGS     entering SOCA ( -1.980 V .. 1.980 V ) at %7.4r  %M", $abstime );
        $fwrite(outfile,"nn            VGS     entering SOCA ( -1.980 V .. 1.980 V ) at %7.4r  %M\n", $abstime );
        VGS_retc=0;
        VGS_cnt=VGS_cnt-1;
        $fclose(outfile);
      end
      if((VGS > 1.98) &&  (VGS_retc!=1))
      begin
        outfile=$fopen(errFileName,"a");
        $strobe("nn            VGS     leaving   OCA ( 1.980 V ..  ) at %7.4r  %M", $abstime );
        $fwrite(outfile,"nn            VGS     leaving   OCA ( 1.980 V ..  ) at %7.4r  %M\n", $abstime );
        VGS_retc=1;
        VGS_cnt=VGS_cnt-1;
        $fclose(outfile);
      end
   end
   else
   begin
      if(VGS_cnt==0)
      begin
        outfile=$fopen(errFileName,"a");
        $strobe("nn            VGS     error limit ( %d ) reached at %7.4r  %M", maxEv, $abstime );
        $fwrite(outfile,"nn            VGS     error limit ( %d ) reached at %7.4r  %M\n", maxEv, $abstime );
        VGS_cnt=VGS_cnt-1;
        $fclose(outfile);
      end
   end

//      VGD
   VGD = V_G_D;
   if((VGD_cnt>0) || ( maxEv_flg==0 ))   begin
      if( (VGD < -1.98) && (VGD_retc!=-1))
      begin
        outfile=$fopen(errFileName,"a");
        $strobe("nn            VGD     leaving   OCA (  .. -1.980 V ) at %7.4r  %M", $abstime );
        $fwrite(outfile,"nn            VGD     leaving   OCA (  .. -1.980 V ) at %7.4r  %M\n", $abstime );
        VGD_retc=-1;
        VGD_cnt=VGD_cnt-1;
        $fclose(outfile);
      end
      if((VGD >= -1.98) &&  (VGD <= 1.98) && (VGD_retc!=0))
      begin
        outfile=$fopen(errFileName,"a");
        $strobe("nn            VGD     entering SOCA ( -1.980 V .. 1.980 V ) at %7.4r  %M", $abstime );
        $fwrite(outfile,"nn            VGD     entering SOCA ( -1.980 V .. 1.980 V ) at %7.4r  %M\n", $abstime );
        VGD_retc=0;
        VGD_cnt=VGD_cnt-1;
        $fclose(outfile);
      end
      if((VGD > 1.98) &&  (VGD_retc!=1))
      begin
        outfile=$fopen(errFileName,"a");
        $strobe("nn            VGD     leaving   OCA ( 1.980 V ..  ) at %7.4r  %M", $abstime );
        $fwrite(outfile,"nn            VGD     leaving   OCA ( 1.980 V ..  ) at %7.4r  %M\n", $abstime );
        VGD_retc=1;
        VGD_cnt=VGD_cnt-1;
        $fclose(outfile);
      end
   end
   else
   begin
      if(VGD_cnt==0)
      begin
        outfile=$fopen(errFileName,"a");
        $strobe("nn            VGD     error limit ( %d ) reached at %7.4r  %M", maxEv, $abstime );
        $fwrite(outfile,"nn            VGD     error limit ( %d ) reached at %7.4r  %M\n", maxEv, $abstime );
        VGD_cnt=VGD_cnt-1;
        $fclose(outfile);
      end
   end

//      VDS
   VDS = V_D_S;
   if((VDS_cnt>0) || ( maxEv_flg==0 ))   begin
      if( (VDS < -1.98) && (VDS_retc!=-1))
      begin
        outfile=$fopen(errFileName,"a");
        $strobe("nn            VDS     leaving   OCA (  .. -1.980 V ) at %7.4r  %M", $abstime );
        $fwrite(outfile,"nn            VDS     leaving   OCA (  .. -1.980 V ) at %7.4r  %M\n", $abstime );
        VDS_retc=-1;
        VDS_cnt=VDS_cnt-1;
        $fclose(outfile);
      end
      if((VDS >= -1.98) &&  (VDS <= 1.98) && (VDS_retc!=0))
      begin
        outfile=$fopen(errFileName,"a");
        $strobe("nn            VDS     entering SOCA ( -1.980 V .. 1.980 V ) at %7.4r  %M", $abstime );
        $fwrite(outfile,"nn            VDS     entering SOCA ( -1.980 V .. 1.980 V ) at %7.4r  %M\n", $abstime );
        VDS_retc=0;
        VDS_cnt=VDS_cnt-1;
        $fclose(outfile);
      end
      if((VDS > 1.98) &&  (VDS_retc!=1))
      begin
        outfile=$fopen(errFileName,"a");
        $strobe("nn            VDS     leaving   OCA ( 1.980 V ..  ) at %7.4r  %M", $abstime );
        $fwrite(outfile,"nn            VDS     leaving   OCA ( 1.980 V ..  ) at %7.4r  %M\n", $abstime );
        VDS_retc=1;
        VDS_cnt=VDS_cnt-1;
        $fclose(outfile);
      end
   end
   else
   begin
      if(VDS_cnt==0)
      begin
        outfile=$fopen(errFileName,"a");
        $strobe("nn            VDS     error limit ( %d ) reached at %7.4r  %M", maxEv, $abstime );
        $fwrite(outfile,"nn            VDS     error limit ( %d ) reached at %7.4r  %M\n", maxEv, $abstime );
        VDS_cnt=VDS_cnt-1;
        $fclose(outfile);
      end
   end

//      VDB
   VDB = V_D_B;
   if((VDB_cnt>0) || ( maxEv_flg==0 ))   begin
      if( (VDB < -0.1) && (VDB_retc!=-1))
      begin
        outfile=$fopen(errFileName,"a");
        $strobe("nn            VDB     leaving   OCA (  .. -0.100 V ) at %7.4r  %M", $abstime );
        $fwrite(outfile,"nn            VDB     leaving   OCA (  .. -0.100 V ) at %7.4r  %M\n", $abstime );
        VDB_retc=-1;
        VDB_cnt=VDB_cnt-1;
        $fclose(outfile);
      end
      if((VDB >= -0.1) &&  (VDB <= 1.98) && (VDB_retc!=0))
      begin
        outfile=$fopen(errFileName,"a");
        $strobe("nn            VDB     entering SOCA ( -0.100 V .. 1.980 V ) at %7.4r  %M", $abstime );
        $fwrite(outfile,"nn            VDB     entering SOCA ( -0.100 V .. 1.980 V ) at %7.4r  %M\n", $abstime );
        VDB_retc=0;
        VDB_cnt=VDB_cnt-1;
        $fclose(outfile);
      end
      if((VDB > 1.98) &&  (VDB_retc!=1))
      begin
        outfile=$fopen(errFileName,"a");
        $strobe("nn            VDB     leaving   OCA ( 1.980 V ..  ) at %7.4r  %M", $abstime );
        $fwrite(outfile,"nn            VDB     leaving   OCA ( 1.980 V ..  ) at %7.4r  %M\n", $abstime );
        VDB_retc=1;
        VDB_cnt=VDB_cnt-1;
        $fclose(outfile);
      end
   end
   else
   begin
      if(VDB_cnt==0)
      begin
        outfile=$fopen(errFileName,"a");
        $strobe("nn            VDB     error limit ( %d ) reached at %7.4r  %M", maxEv, $abstime );
        $fwrite(outfile,"nn            VDB     error limit ( %d ) reached at %7.4r  %M\n", maxEv, $abstime );
        VDB_cnt=VDB_cnt-1;
        $fclose(outfile);
      end
   end

//      VSB
   VSB = V_S_B;
   if((VSB_cnt>0) || ( maxEv_flg==0 ))   begin
      if( (VSB < -0.1) && (VSB_retc!=-1))
      begin
        outfile=$fopen(errFileName,"a");
        $strobe("nn            VSB     leaving   OCA (  .. -0.100 V ) at %7.4r  %M", $abstime );
        $fwrite(outfile,"nn            VSB     leaving   OCA (  .. -0.100 V ) at %7.4r  %M\n", $abstime );
        VSB_retc=-1;
        VSB_cnt=VSB_cnt-1;
        $fclose(outfile);
      end
      if((VSB >= -0.1) &&  (VSB <= 1.98) && (VSB_retc!=0))
      begin
        outfile=$fopen(errFileName,"a");
        $strobe("nn            VSB     entering SOCA ( -0.100 V .. 1.980 V ) at %7.4r  %M", $abstime );
        $fwrite(outfile,"nn            VSB     entering SOCA ( -0.100 V .. 1.980 V ) at %7.4r  %M\n", $abstime );
        VSB_retc=0;
        VSB_cnt=VSB_cnt-1;
        $fclose(outfile);
      end
      if((VSB > 1.98) &&  (VSB_retc!=1))
      begin
        outfile=$fopen(errFileName,"a");
        $strobe("nn            VSB     leaving   OCA ( 1.980 V ..  ) at %7.4r  %M", $abstime );
        $fwrite(outfile,"nn            VSB     leaving   OCA ( 1.980 V ..  ) at %7.4r  %M\n", $abstime );
        VSB_retc=1;
        VSB_cnt=VSB_cnt-1;
        $fclose(outfile);
      end
   end
   else
   begin
      if(VSB_cnt==0)
      begin
        outfile=$fopen(errFileName,"a");
        $strobe("nn            VSB     error limit ( %d ) reached at %7.4r  %M", maxEv, $abstime );
        $fwrite(outfile,"nn            VSB     error limit ( %d ) reached at %7.4r  %M\n", maxEv, $abstime );
        VSB_cnt=VSB_cnt-1;
        $fclose(outfile);
      end
   end

end // analog
endmodule // nn

// Verilog-A OC Watch for device nel Parameters  VGS VGD VDS VDB VSB
module nel_ahdl(D,G,S,B);
parameter tstep_occ=100n;
parameter errFileName="./occ.err";
parameter maxEv = 25;
parameter maxEv_flg = 0;
inout D,G,S,B;
electrical D,G,S,B;

integer outfile;
real V_S_B;
real V_D_B;
real V_D_S;
real V_G_D;
real V_G_S;
real VGS;
integer VGS_retc;
integer VGS_cnt;
real VGD;
integer VGD_retc;
integer VGD_cnt;
real VDS;
integer VDS_retc;
integer VDS_cnt;
real VDB;
integer VDB_retc;
integer VDB_cnt;
real VSB;
integer VSB_retc;
integer VSB_cnt;

analog begin
   $bound_step( tstep_occ );
   @(initial_step) begin
      VGS_retc=0;
      VGS_cnt = maxEv;
      VGD_retc=0;
      VGD_cnt = maxEv;
      VDS_retc=0;
      VDS_cnt = maxEv;
      VDB_retc=0;
      VDB_cnt = maxEv;
      VSB_retc=0;
      VSB_cnt = maxEv;
   end
   V_S_B = V(S,B);
   V_D_B = V(D,B);
   V_D_S = V(D,S);
   V_G_D = V(G,D);
   V_G_S = V(G,S);

//      VGS
   VGS = V_G_S;
   if((VGS_cnt>0) || ( maxEv_flg==0 ))   begin
      if( (VGS < -1.98) && (VGS_retc!=-1))
      begin
        outfile=$fopen(errFileName,"a");
        $strobe("nel           VGS     leaving   OCA (  .. -1.980 V ) at %7.4r  %M", $abstime );
        $fwrite(outfile,"nel           VGS     leaving   OCA (  .. -1.980 V ) at %7.4r  %M\n", $abstime );
        VGS_retc=-1;
        VGS_cnt=VGS_cnt-1;
        $fclose(outfile);
      end
      if((VGS >= -1.98) &&  (VGS <= 1.98) && (VGS_retc!=0))
      begin
        outfile=$fopen(errFileName,"a");
        $strobe("nel           VGS     entering SOCA ( -1.980 V .. 1.980 V ) at %7.4r  %M", $abstime );
        $fwrite(outfile,"nel           VGS     entering SOCA ( -1.980 V .. 1.980 V ) at %7.4r  %M\n", $abstime );
        VGS_retc=0;
        VGS_cnt=VGS_cnt-1;
        $fclose(outfile);
      end
      if((VGS > 1.98) &&  (VGS_retc!=1))
      begin
        outfile=$fopen(errFileName,"a");
        $strobe("nel           VGS     leaving   OCA ( 1.980 V ..  ) at %7.4r  %M", $abstime );
        $fwrite(outfile,"nel           VGS     leaving   OCA ( 1.980 V ..  ) at %7.4r  %M\n", $abstime );
        VGS_retc=1;
        VGS_cnt=VGS_cnt-1;
        $fclose(outfile);
      end
   end
   else
   begin
      if(VGS_cnt==0)
      begin
        outfile=$fopen(errFileName,"a");
        $strobe("nel           VGS     error limit ( %d ) reached at %7.4r  %M", maxEv, $abstime );
        $fwrite(outfile,"nel           VGS     error limit ( %d ) reached at %7.4r  %M\n", maxEv, $abstime );
        VGS_cnt=VGS_cnt-1;
        $fclose(outfile);
      end
   end

//      VGD
   VGD = V_G_D;
   if((VGD_cnt>0) || ( maxEv_flg==0 ))   begin
      if( (VGD < -1.98) && (VGD_retc!=-1))
      begin
        outfile=$fopen(errFileName,"a");
        $strobe("nel           VGD     leaving   OCA (  .. -1.980 V ) at %7.4r  %M", $abstime );
        $fwrite(outfile,"nel           VGD     leaving   OCA (  .. -1.980 V ) at %7.4r  %M\n", $abstime );
        VGD_retc=-1;
        VGD_cnt=VGD_cnt-1;
        $fclose(outfile);
      end
      if((VGD >= -1.98) &&  (VGD <= 1.98) && (VGD_retc!=0))
      begin
        outfile=$fopen(errFileName,"a");
        $strobe("nel           VGD     entering SOCA ( -1.980 V .. 1.980 V ) at %7.4r  %M", $abstime );
        $fwrite(outfile,"nel           VGD     entering SOCA ( -1.980 V .. 1.980 V ) at %7.4r  %M\n", $abstime );
        VGD_retc=0;
        VGD_cnt=VGD_cnt-1;
        $fclose(outfile);
      end
      if((VGD > 1.98) &&  (VGD_retc!=1))
      begin
        outfile=$fopen(errFileName,"a");
        $strobe("nel           VGD     leaving   OCA ( 1.980 V ..  ) at %7.4r  %M", $abstime );
        $fwrite(outfile,"nel           VGD     leaving   OCA ( 1.980 V ..  ) at %7.4r  %M\n", $abstime );
        VGD_retc=1;
        VGD_cnt=VGD_cnt-1;
        $fclose(outfile);
      end
   end
   else
   begin
      if(VGD_cnt==0)
      begin
        outfile=$fopen(errFileName,"a");
        $strobe("nel           VGD     error limit ( %d ) reached at %7.4r  %M", maxEv, $abstime );
        $fwrite(outfile,"nel           VGD     error limit ( %d ) reached at %7.4r  %M\n", maxEv, $abstime );
        VGD_cnt=VGD_cnt-1;
        $fclose(outfile);
      end
   end

//      VDS
   VDS = V_D_S;
   if((VDS_cnt>0) || ( maxEv_flg==0 ))   begin
      if( (VDS < -1.98) && (VDS_retc!=-1))
      begin
        outfile=$fopen(errFileName,"a");
        $strobe("nel           VDS     leaving   OCA (  .. -1.980 V ) at %7.4r  %M", $abstime );
        $fwrite(outfile,"nel           VDS     leaving   OCA (  .. -1.980 V ) at %7.4r  %M\n", $abstime );
        VDS_retc=-1;
        VDS_cnt=VDS_cnt-1;
        $fclose(outfile);
      end
      if((VDS >= -1.98) &&  (VDS <= 1.98) && (VDS_retc!=0))
      begin
        outfile=$fopen(errFileName,"a");
        $strobe("nel           VDS     entering SOCA ( -1.980 V .. 1.980 V ) at %7.4r  %M", $abstime );
        $fwrite(outfile,"nel           VDS     entering SOCA ( -1.980 V .. 1.980 V ) at %7.4r  %M\n", $abstime );
        VDS_retc=0;
        VDS_cnt=VDS_cnt-1;
        $fclose(outfile);
      end
      if((VDS > 1.98) &&  (VDS_retc!=1))
      begin
        outfile=$fopen(errFileName,"a");
        $strobe("nel           VDS     leaving   OCA ( 1.980 V ..  ) at %7.4r  %M", $abstime );
        $fwrite(outfile,"nel           VDS     leaving   OCA ( 1.980 V ..  ) at %7.4r  %M\n", $abstime );
        VDS_retc=1;
        VDS_cnt=VDS_cnt-1;
        $fclose(outfile);
      end
   end
   else
   begin
      if(VDS_cnt==0)
      begin
        outfile=$fopen(errFileName,"a");
        $strobe("nel           VDS     error limit ( %d ) reached at %7.4r  %M", maxEv, $abstime );
        $fwrite(outfile,"nel           VDS     error limit ( %d ) reached at %7.4r  %M\n", maxEv, $abstime );
        VDS_cnt=VDS_cnt-1;
        $fclose(outfile);
      end
   end

//      VDB
   VDB = V_D_B;
   if((VDB_cnt>0) || ( maxEv_flg==0 ))   begin
      if( (VDB < -0.1) && (VDB_retc!=-1))
      begin
        outfile=$fopen(errFileName,"a");
        $strobe("nel           VDB     leaving   OCA (  .. -0.100 V ) at %7.4r  %M", $abstime );
        $fwrite(outfile,"nel           VDB     leaving   OCA (  .. -0.100 V ) at %7.4r  %M\n", $abstime );
        VDB_retc=-1;
        VDB_cnt=VDB_cnt-1;
        $fclose(outfile);
      end
      if((VDB >= -0.1) &&  (VDB <= 1.98) && (VDB_retc!=0))
      begin
        outfile=$fopen(errFileName,"a");
        $strobe("nel           VDB     entering SOCA ( -0.100 V .. 1.980 V ) at %7.4r  %M", $abstime );
        $fwrite(outfile,"nel           VDB     entering SOCA ( -0.100 V .. 1.980 V ) at %7.4r  %M\n", $abstime );
        VDB_retc=0;
        VDB_cnt=VDB_cnt-1;
        $fclose(outfile);
      end
      if((VDB > 1.98) &&  (VDB_retc!=1))
      begin
        outfile=$fopen(errFileName,"a");
        $strobe("nel           VDB     leaving   OCA ( 1.980 V ..  ) at %7.4r  %M", $abstime );
        $fwrite(outfile,"nel           VDB     leaving   OCA ( 1.980 V ..  ) at %7.4r  %M\n", $abstime );
        VDB_retc=1;
        VDB_cnt=VDB_cnt-1;
        $fclose(outfile);
      end
   end
   else
   begin
      if(VDB_cnt==0)
      begin
        outfile=$fopen(errFileName,"a");
        $strobe("nel           VDB     error limit ( %d ) reached at %7.4r  %M", maxEv, $abstime );
        $fwrite(outfile,"nel           VDB     error limit ( %d ) reached at %7.4r  %M\n", maxEv, $abstime );
        VDB_cnt=VDB_cnt-1;
        $fclose(outfile);
      end
   end

//      VSB
   VSB = V_S_B;
   if((VSB_cnt>0) || ( maxEv_flg==0 ))   begin
      if( (VSB < -0.1) && (VSB_retc!=-1))
      begin
        outfile=$fopen(errFileName,"a");
        $strobe("nel           VSB     leaving   OCA (  .. -0.100 V ) at %7.4r  %M", $abstime );
        $fwrite(outfile,"nel           VSB     leaving   OCA (  .. -0.100 V ) at %7.4r  %M\n", $abstime );
        VSB_retc=-1;
        VSB_cnt=VSB_cnt-1;
        $fclose(outfile);
      end
      if((VSB >= -0.1) &&  (VSB <= 1.98) && (VSB_retc!=0))
      begin
        outfile=$fopen(errFileName,"a");
        $strobe("nel           VSB     entering SOCA ( -0.100 V .. 1.980 V ) at %7.4r  %M", $abstime );
        $fwrite(outfile,"nel           VSB     entering SOCA ( -0.100 V .. 1.980 V ) at %7.4r  %M\n", $abstime );
        VSB_retc=0;
        VSB_cnt=VSB_cnt-1;
        $fclose(outfile);
      end
      if((VSB > 1.98) &&  (VSB_retc!=1))
      begin
        outfile=$fopen(errFileName,"a");
        $strobe("nel           VSB     leaving   OCA ( 1.980 V ..  ) at %7.4r  %M", $abstime );
        $fwrite(outfile,"nel           VSB     leaving   OCA ( 1.980 V ..  ) at %7.4r  %M\n", $abstime );
        VSB_retc=1;
        VSB_cnt=VSB_cnt-1;
        $fclose(outfile);
      end
   end
   else
   begin
      if(VSB_cnt==0)
      begin
        outfile=$fopen(errFileName,"a");
        $strobe("nel           VSB     error limit ( %d ) reached at %7.4r  %M", maxEv, $abstime );
        $fwrite(outfile,"nel           VSB     error limit ( %d ) reached at %7.4r  %M\n", maxEv, $abstime );
        VSB_cnt=VSB_cnt-1;
        $fclose(outfile);
      end
   end

end // analog
endmodule // nel

// Verilog-A OC Watch for device nesvt Parameters  VGS VGD VDS VDB VSB
module nesvt_ahdl(D,G,S,B);
parameter tstep_occ=100n;
parameter errFileName="./occ.err";
parameter maxEv = 25;
parameter maxEv_flg = 0;
inout D,G,S,B;
electrical D,G,S,B;

integer outfile;
real V_S_B;
real V_D_B;
real V_D_S;
real V_G_D;
real V_G_S;
real VGS;
integer VGS_retc;
integer VGS_cnt;
real VGD;
integer VGD_retc;
integer VGD_cnt;
real VDS;
integer VDS_retc;
integer VDS_cnt;
real VDB;
integer VDB_retc;
integer VDB_cnt;
real VSB;
integer VSB_retc;
integer VSB_cnt;

analog begin
   $bound_step( tstep_occ );
   @(initial_step) begin
      VGS_retc=0;
      VGS_cnt = maxEv;
      VGD_retc=0;
      VGD_cnt = maxEv;
      VDS_retc=0;
      VDS_cnt = maxEv;
      VDB_retc=0;
      VDB_cnt = maxEv;
      VSB_retc=0;
      VSB_cnt = maxEv;
   end
   V_S_B = V(S,B);
   V_D_B = V(D,B);
   V_D_S = V(D,S);
   V_G_D = V(G,D);
   V_G_S = V(G,S);

//      VGS
   VGS = V_G_S;
   if((VGS_cnt>0) || ( maxEv_flg==0 ))   begin
      if( (VGS < -1.98) && (VGS_retc!=-1))
      begin
        outfile=$fopen(errFileName,"a");
        $strobe("nesvt         VGS     leaving   OCA (  .. -1.980 V ) at %7.4r  %M", $abstime );
        $fwrite(outfile,"nesvt         VGS     leaving   OCA (  .. -1.980 V ) at %7.4r  %M\n", $abstime );
        VGS_retc=-1;
        VGS_cnt=VGS_cnt-1;
        $fclose(outfile);
      end
      if((VGS >= -1.98) &&  (VGS <= 1.98) && (VGS_retc!=0))
      begin
        outfile=$fopen(errFileName,"a");
        $strobe("nesvt         VGS     entering SOCA ( -1.980 V .. 1.980 V ) at %7.4r  %M", $abstime );
        $fwrite(outfile,"nesvt         VGS     entering SOCA ( -1.980 V .. 1.980 V ) at %7.4r  %M\n", $abstime );
        VGS_retc=0;
        VGS_cnt=VGS_cnt-1;
        $fclose(outfile);
      end
      if((VGS > 1.98) &&  (VGS_retc!=1))
      begin
        outfile=$fopen(errFileName,"a");
        $strobe("nesvt         VGS     leaving   OCA ( 1.980 V ..  ) at %7.4r  %M", $abstime );
        $fwrite(outfile,"nesvt         VGS     leaving   OCA ( 1.980 V ..  ) at %7.4r  %M\n", $abstime );
        VGS_retc=1;
        VGS_cnt=VGS_cnt-1;
        $fclose(outfile);
      end
   end
   else
   begin
      if(VGS_cnt==0)
      begin
        outfile=$fopen(errFileName,"a");
        $strobe("nesvt         VGS     error limit ( %d ) reached at %7.4r  %M", maxEv, $abstime );
        $fwrite(outfile,"nesvt         VGS     error limit ( %d ) reached at %7.4r  %M\n", maxEv, $abstime );
        VGS_cnt=VGS_cnt-1;
        $fclose(outfile);
      end
   end

//      VGD
   VGD = V_G_D;
   if((VGD_cnt>0) || ( maxEv_flg==0 ))   begin
      if( (VGD < -1.98) && (VGD_retc!=-1))
      begin
        outfile=$fopen(errFileName,"a");
        $strobe("nesvt         VGD     leaving   OCA (  .. -1.980 V ) at %7.4r  %M", $abstime );
        $fwrite(outfile,"nesvt         VGD     leaving   OCA (  .. -1.980 V ) at %7.4r  %M\n", $abstime );
        VGD_retc=-1;
        VGD_cnt=VGD_cnt-1;
        $fclose(outfile);
      end
      if((VGD >= -1.98) &&  (VGD <= 1.98) && (VGD_retc!=0))
      begin
        outfile=$fopen(errFileName,"a");
        $strobe("nesvt         VGD     entering SOCA ( -1.980 V .. 1.980 V ) at %7.4r  %M", $abstime );
        $fwrite(outfile,"nesvt         VGD     entering SOCA ( -1.980 V .. 1.980 V ) at %7.4r  %M\n", $abstime );
        VGD_retc=0;
        VGD_cnt=VGD_cnt-1;
        $fclose(outfile);
      end
      if((VGD > 1.98) &&  (VGD_retc!=1))
      begin
        outfile=$fopen(errFileName,"a");
        $strobe("nesvt         VGD     leaving   OCA ( 1.980 V ..  ) at %7.4r  %M", $abstime );
        $fwrite(outfile,"nesvt         VGD     leaving   OCA ( 1.980 V ..  ) at %7.4r  %M\n", $abstime );
        VGD_retc=1;
        VGD_cnt=VGD_cnt-1;
        $fclose(outfile);
      end
   end
   else
   begin
      if(VGD_cnt==0)
      begin
        outfile=$fopen(errFileName,"a");
        $strobe("nesvt         VGD     error limit ( %d ) reached at %7.4r  %M", maxEv, $abstime );
        $fwrite(outfile,"nesvt         VGD     error limit ( %d ) reached at %7.4r  %M\n", maxEv, $abstime );
        VGD_cnt=VGD_cnt-1;
        $fclose(outfile);
      end
   end

//      VDS
   VDS = V_D_S;
   if((VDS_cnt>0) || ( maxEv_flg==0 ))   begin
      if( (VDS < -1.98) && (VDS_retc!=-1))
      begin
        outfile=$fopen(errFileName,"a");
        $strobe("nesvt         VDS     leaving   OCA (  .. -1.980 V ) at %7.4r  %M", $abstime );
        $fwrite(outfile,"nesvt         VDS     leaving   OCA (  .. -1.980 V ) at %7.4r  %M\n", $abstime );
        VDS_retc=-1;
        VDS_cnt=VDS_cnt-1;
        $fclose(outfile);
      end
      if((VDS >= -1.98) &&  (VDS <= 1.98) && (VDS_retc!=0))
      begin
        outfile=$fopen(errFileName,"a");
        $strobe("nesvt         VDS     entering SOCA ( -1.980 V .. 1.980 V ) at %7.4r  %M", $abstime );
        $fwrite(outfile,"nesvt         VDS     entering SOCA ( -1.980 V .. 1.980 V ) at %7.4r  %M\n", $abstime );
        VDS_retc=0;
        VDS_cnt=VDS_cnt-1;
        $fclose(outfile);
      end
      if((VDS > 1.98) &&  (VDS_retc!=1))
      begin
        outfile=$fopen(errFileName,"a");
        $strobe("nesvt         VDS     leaving   OCA ( 1.980 V ..  ) at %7.4r  %M", $abstime );
        $fwrite(outfile,"nesvt         VDS     leaving   OCA ( 1.980 V ..  ) at %7.4r  %M\n", $abstime );
        VDS_retc=1;
        VDS_cnt=VDS_cnt-1;
        $fclose(outfile);
      end
   end
   else
   begin
      if(VDS_cnt==0)
      begin
        outfile=$fopen(errFileName,"a");
        $strobe("nesvt         VDS     error limit ( %d ) reached at %7.4r  %M", maxEv, $abstime );
        $fwrite(outfile,"nesvt         VDS     error limit ( %d ) reached at %7.4r  %M\n", maxEv, $abstime );
        VDS_cnt=VDS_cnt-1;
        $fclose(outfile);
      end
   end

//      VDB
   VDB = V_D_B;
   if((VDB_cnt>0) || ( maxEv_flg==0 ))   begin
      if( (VDB < -0.1) && (VDB_retc!=-1))
      begin
        outfile=$fopen(errFileName,"a");
        $strobe("nesvt         VDB     leaving   OCA (  .. -0.100 V ) at %7.4r  %M", $abstime );
        $fwrite(outfile,"nesvt         VDB     leaving   OCA (  .. -0.100 V ) at %7.4r  %M\n", $abstime );
        VDB_retc=-1;
        VDB_cnt=VDB_cnt-1;
        $fclose(outfile);
      end
      if((VDB >= -0.1) &&  (VDB <= 1.98) && (VDB_retc!=0))
      begin
        outfile=$fopen(errFileName,"a");
        $strobe("nesvt         VDB     entering SOCA ( -0.100 V .. 1.980 V ) at %7.4r  %M", $abstime );
        $fwrite(outfile,"nesvt         VDB     entering SOCA ( -0.100 V .. 1.980 V ) at %7.4r  %M\n", $abstime );
        VDB_retc=0;
        VDB_cnt=VDB_cnt-1;
        $fclose(outfile);
      end
      if((VDB > 1.98) &&  (VDB_retc!=1))
      begin
        outfile=$fopen(errFileName,"a");
        $strobe("nesvt         VDB     leaving   OCA ( 1.980 V ..  ) at %7.4r  %M", $abstime );
        $fwrite(outfile,"nesvt         VDB     leaving   OCA ( 1.980 V ..  ) at %7.4r  %M\n", $abstime );
        VDB_retc=1;
        VDB_cnt=VDB_cnt-1;
        $fclose(outfile);
      end
   end
   else
   begin
      if(VDB_cnt==0)
      begin
        outfile=$fopen(errFileName,"a");
        $strobe("nesvt         VDB     error limit ( %d ) reached at %7.4r  %M", maxEv, $abstime );
        $fwrite(outfile,"nesvt         VDB     error limit ( %d ) reached at %7.4r  %M\n", maxEv, $abstime );
        VDB_cnt=VDB_cnt-1;
        $fclose(outfile);
      end
   end

//      VSB
   VSB = V_S_B;
   if((VSB_cnt>0) || ( maxEv_flg==0 ))   begin
      if( (VSB < -0.1) && (VSB_retc!=-1))
      begin
        outfile=$fopen(errFileName,"a");
        $strobe("nesvt         VSB     leaving   OCA (  .. -0.100 V ) at %7.4r  %M", $abstime );
        $fwrite(outfile,"nesvt         VSB     leaving   OCA (  .. -0.100 V ) at %7.4r  %M\n", $abstime );
        VSB_retc=-1;
        VSB_cnt=VSB_cnt-1;
        $fclose(outfile);
      end
      if((VSB >= -0.1) &&  (VSB <= 1.98) && (VSB_retc!=0))
      begin
        outfile=$fopen(errFileName,"a");
        $strobe("nesvt         VSB     entering SOCA ( -0.100 V .. 1.980 V ) at %7.4r  %M", $abstime );
        $fwrite(outfile,"nesvt         VSB     entering SOCA ( -0.100 V .. 1.980 V ) at %7.4r  %M\n", $abstime );
        VSB_retc=0;
        VSB_cnt=VSB_cnt-1;
        $fclose(outfile);
      end
      if((VSB > 1.98) &&  (VSB_retc!=1))
      begin
        outfile=$fopen(errFileName,"a");
        $strobe("nesvt         VSB     leaving   OCA ( 1.980 V ..  ) at %7.4r  %M", $abstime );
        $fwrite(outfile,"nesvt         VSB     leaving   OCA ( 1.980 V ..  ) at %7.4r  %M\n", $abstime );
        VSB_retc=1;
        VSB_cnt=VSB_cnt-1;
        $fclose(outfile);
      end
   end
   else
   begin
      if(VSB_cnt==0)
      begin
        outfile=$fopen(errFileName,"a");
        $strobe("nesvt         VSB     error limit ( %d ) reached at %7.4r  %M", maxEv, $abstime );
        $fwrite(outfile,"nesvt         VSB     error limit ( %d ) reached at %7.4r  %M\n", maxEv, $abstime );
        VSB_cnt=VSB_cnt-1;
        $fclose(outfile);
      end
   end

end // analog
endmodule // nesvt

// Verilog-A OC Watch for device pe Parameters  VGS VGD VDS VDB VSB
module pe_ahdl(D,G,S,B);
parameter tstep_occ=100n;
parameter errFileName="./occ.err";
parameter maxEv = 25;
parameter maxEv_flg = 0;
inout D,G,S,B;
electrical D,G,S,B;

integer outfile;
real V_S_B;
real V_D_B;
real V_D_S;
real V_G_D;
real V_G_S;
real VGS;
integer VGS_retc;
integer VGS_cnt;
real VGD;
integer VGD_retc;
integer VGD_cnt;
real VDS;
integer VDS_retc;
integer VDS_cnt;
real VDB;
integer VDB_retc;
integer VDB_cnt;
real VSB;
integer VSB_retc;
integer VSB_cnt;

analog begin
   $bound_step( tstep_occ );
   @(initial_step) begin
      VGS_retc=0;
      VGS_cnt = maxEv;
      VGD_retc=0;
      VGD_cnt = maxEv;
      VDS_retc=0;
      VDS_cnt = maxEv;
      VDB_retc=0;
      VDB_cnt = maxEv;
      VSB_retc=0;
      VSB_cnt = maxEv;
   end
   V_S_B = V(S,B);
   V_D_B = V(D,B);
   V_D_S = V(D,S);
   V_G_D = V(G,D);
   V_G_S = V(G,S);

//      VGS
   VGS = V_G_S;
   if((VGS_cnt>0) || ( maxEv_flg==0 ))   begin
      if( (VGS < -1.98) && (VGS_retc!=-1))
      begin
        outfile=$fopen(errFileName,"a");
        $strobe("pe            VGS     leaving   OCA (  .. -1.980 V ) at %7.4r  %M", $abstime );
        $fwrite(outfile,"pe            VGS     leaving   OCA (  .. -1.980 V ) at %7.4r  %M\n", $abstime );
        VGS_retc=-1;
        VGS_cnt=VGS_cnt-1;
        $fclose(outfile);
      end
      if((VGS >= -1.98) &&  (VGS <= 1.98) && (VGS_retc!=0))
      begin
        outfile=$fopen(errFileName,"a");
        $strobe("pe            VGS     entering SOCA ( -1.980 V .. 1.980 V ) at %7.4r  %M", $abstime );
        $fwrite(outfile,"pe            VGS     entering SOCA ( -1.980 V .. 1.980 V ) at %7.4r  %M\n", $abstime );
        VGS_retc=0;
        VGS_cnt=VGS_cnt-1;
        $fclose(outfile);
      end
      if((VGS > 1.98) &&  (VGS_retc!=1))
      begin
        outfile=$fopen(errFileName,"a");
        $strobe("pe            VGS     leaving   OCA ( 1.980 V ..  ) at %7.4r  %M", $abstime );
        $fwrite(outfile,"pe            VGS     leaving   OCA ( 1.980 V ..  ) at %7.4r  %M\n", $abstime );
        VGS_retc=1;
        VGS_cnt=VGS_cnt-1;
        $fclose(outfile);
      end
   end
   else
   begin
      if(VGS_cnt==0)
      begin
        outfile=$fopen(errFileName,"a");
        $strobe("pe            VGS     error limit ( %d ) reached at %7.4r  %M", maxEv, $abstime );
        $fwrite(outfile,"pe            VGS     error limit ( %d ) reached at %7.4r  %M\n", maxEv, $abstime );
        VGS_cnt=VGS_cnt-1;
        $fclose(outfile);
      end
   end

//      VGD
   VGD = V_G_D;
   if((VGD_cnt>0) || ( maxEv_flg==0 ))   begin
      if( (VGD < -1.98) && (VGD_retc!=-1))
      begin
        outfile=$fopen(errFileName,"a");
        $strobe("pe            VGD     leaving   OCA (  .. -1.980 V ) at %7.4r  %M", $abstime );
        $fwrite(outfile,"pe            VGD     leaving   OCA (  .. -1.980 V ) at %7.4r  %M\n", $abstime );
        VGD_retc=-1;
        VGD_cnt=VGD_cnt-1;
        $fclose(outfile);
      end
      if((VGD >= -1.98) &&  (VGD <= 1.98) && (VGD_retc!=0))
      begin
        outfile=$fopen(errFileName,"a");
        $strobe("pe            VGD     entering SOCA ( -1.980 V .. 1.980 V ) at %7.4r  %M", $abstime );
        $fwrite(outfile,"pe            VGD     entering SOCA ( -1.980 V .. 1.980 V ) at %7.4r  %M\n", $abstime );
        VGD_retc=0;
        VGD_cnt=VGD_cnt-1;
        $fclose(outfile);
      end
      if((VGD > 1.98) &&  (VGD_retc!=1))
      begin
        outfile=$fopen(errFileName,"a");
        $strobe("pe            VGD     leaving   OCA ( 1.980 V ..  ) at %7.4r  %M", $abstime );
        $fwrite(outfile,"pe            VGD     leaving   OCA ( 1.980 V ..  ) at %7.4r  %M\n", $abstime );
        VGD_retc=1;
        VGD_cnt=VGD_cnt-1;
        $fclose(outfile);
      end
   end
   else
   begin
      if(VGD_cnt==0)
      begin
        outfile=$fopen(errFileName,"a");
        $strobe("pe            VGD     error limit ( %d ) reached at %7.4r  %M", maxEv, $abstime );
        $fwrite(outfile,"pe            VGD     error limit ( %d ) reached at %7.4r  %M\n", maxEv, $abstime );
        VGD_cnt=VGD_cnt-1;
        $fclose(outfile);
      end
   end

//      VDS
   VDS = V_D_S;
   if((VDS_cnt>0) || ( maxEv_flg==0 ))   begin
      if( (VDS < -1.98) && (VDS_retc!=-1))
      begin
        outfile=$fopen(errFileName,"a");
        $strobe("pe            VDS     leaving   OCA (  .. -1.980 V ) at %7.4r  %M", $abstime );
        $fwrite(outfile,"pe            VDS     leaving   OCA (  .. -1.980 V ) at %7.4r  %M\n", $abstime );
        VDS_retc=-1;
        VDS_cnt=VDS_cnt-1;
        $fclose(outfile);
      end
      if((VDS >= -1.98) &&  (VDS <= 1.98) && (VDS_retc!=0))
      begin
        outfile=$fopen(errFileName,"a");
        $strobe("pe            VDS     entering SOCA ( -1.980 V .. 1.980 V ) at %7.4r  %M", $abstime );
        $fwrite(outfile,"pe            VDS     entering SOCA ( -1.980 V .. 1.980 V ) at %7.4r  %M\n", $abstime );
        VDS_retc=0;
        VDS_cnt=VDS_cnt-1;
        $fclose(outfile);
      end
      if((VDS > 1.98) &&  (VDS_retc!=1))
      begin
        outfile=$fopen(errFileName,"a");
        $strobe("pe            VDS     leaving   OCA ( 1.980 V ..  ) at %7.4r  %M", $abstime );
        $fwrite(outfile,"pe            VDS     leaving   OCA ( 1.980 V ..  ) at %7.4r  %M\n", $abstime );
        VDS_retc=1;
        VDS_cnt=VDS_cnt-1;
        $fclose(outfile);
      end
   end
   else
   begin
      if(VDS_cnt==0)
      begin
        outfile=$fopen(errFileName,"a");
        $strobe("pe            VDS     error limit ( %d ) reached at %7.4r  %M", maxEv, $abstime );
        $fwrite(outfile,"pe            VDS     error limit ( %d ) reached at %7.4r  %M\n", maxEv, $abstime );
        VDS_cnt=VDS_cnt-1;
        $fclose(outfile);
      end
   end

//      VDB
   VDB = V_D_B;
   if((VDB_cnt>0) || ( maxEv_flg==0 ))   begin
      if( (VDB < -1.98) && (VDB_retc!=-1))
      begin
        outfile=$fopen(errFileName,"a");
        $strobe("pe            VDB     leaving   OCA (  .. -1.980 V ) at %7.4r  %M", $abstime );
        $fwrite(outfile,"pe            VDB     leaving   OCA (  .. -1.980 V ) at %7.4r  %M\n", $abstime );
        VDB_retc=-1;
        VDB_cnt=VDB_cnt-1;
        $fclose(outfile);
      end
      if((VDB >= -1.98) &&  (VDB <= 0.1) && (VDB_retc!=0))
      begin
        outfile=$fopen(errFileName,"a");
        $strobe("pe            VDB     entering SOCA ( -1.980 V .. 0.100 V ) at %7.4r  %M", $abstime );
        $fwrite(outfile,"pe            VDB     entering SOCA ( -1.980 V .. 0.100 V ) at %7.4r  %M\n", $abstime );
        VDB_retc=0;
        VDB_cnt=VDB_cnt-1;
        $fclose(outfile);
      end
      if((VDB > 0.1) &&  (VDB_retc!=1))
      begin
        outfile=$fopen(errFileName,"a");
        $strobe("pe            VDB     leaving   OCA ( 0.100 V ..  ) at %7.4r  %M", $abstime );
        $fwrite(outfile,"pe            VDB     leaving   OCA ( 0.100 V ..  ) at %7.4r  %M\n", $abstime );
        VDB_retc=1;
        VDB_cnt=VDB_cnt-1;
        $fclose(outfile);
      end
   end
   else
   begin
      if(VDB_cnt==0)
      begin
        outfile=$fopen(errFileName,"a");
        $strobe("pe            VDB     error limit ( %d ) reached at %7.4r  %M", maxEv, $abstime );
        $fwrite(outfile,"pe            VDB     error limit ( %d ) reached at %7.4r  %M\n", maxEv, $abstime );
        VDB_cnt=VDB_cnt-1;
        $fclose(outfile);
      end
   end

//      VSB
   VSB = V_S_B;
   if((VSB_cnt>0) || ( maxEv_flg==0 ))   begin
      if( (VSB < -1.98) && (VSB_retc!=-1))
      begin
        outfile=$fopen(errFileName,"a");
        $strobe("pe            VSB     leaving   OCA (  .. -1.980 V ) at %7.4r  %M", $abstime );
        $fwrite(outfile,"pe            VSB     leaving   OCA (  .. -1.980 V ) at %7.4r  %M\n", $abstime );
        VSB_retc=-1;
        VSB_cnt=VSB_cnt-1;
        $fclose(outfile);
      end
      if((VSB >= -1.98) &&  (VSB <= 0.1) && (VSB_retc!=0))
      begin
        outfile=$fopen(errFileName,"a");
        $strobe("pe            VSB     entering SOCA ( -1.980 V .. 0.100 V ) at %7.4r  %M", $abstime );
        $fwrite(outfile,"pe            VSB     entering SOCA ( -1.980 V .. 0.100 V ) at %7.4r  %M\n", $abstime );
        VSB_retc=0;
        VSB_cnt=VSB_cnt-1;
        $fclose(outfile);
      end
      if((VSB > 0.1) &&  (VSB_retc!=1))
      begin
        outfile=$fopen(errFileName,"a");
        $strobe("pe            VSB     leaving   OCA ( 0.100 V ..  ) at %7.4r  %M", $abstime );
        $fwrite(outfile,"pe            VSB     leaving   OCA ( 0.100 V ..  ) at %7.4r  %M\n", $abstime );
        VSB_retc=1;
        VSB_cnt=VSB_cnt-1;
        $fclose(outfile);
      end
   end
   else
   begin
      if(VSB_cnt==0)
      begin
        outfile=$fopen(errFileName,"a");
        $strobe("pe            VSB     error limit ( %d ) reached at %7.4r  %M", maxEv, $abstime );
        $fwrite(outfile,"pe            VSB     error limit ( %d ) reached at %7.4r  %M\n", maxEv, $abstime );
        VSB_cnt=VSB_cnt-1;
        $fclose(outfile);
      end
   end

end // analog
endmodule // pe

// Verilog-A OC Watch for device pel Parameters  VGS VGD VDS VDB VSB
module pel_ahdl(D,G,S,B);
parameter tstep_occ=100n;
parameter errFileName="./occ.err";
parameter maxEv = 25;
parameter maxEv_flg = 0;
inout D,G,S,B;
electrical D,G,S,B;

integer outfile;
real V_S_B;
real V_D_B;
real V_D_S;
real V_G_D;
real V_G_S;
real VGS;
integer VGS_retc;
integer VGS_cnt;
real VGD;
integer VGD_retc;
integer VGD_cnt;
real VDS;
integer VDS_retc;
integer VDS_cnt;
real VDB;
integer VDB_retc;
integer VDB_cnt;
real VSB;
integer VSB_retc;
integer VSB_cnt;

analog begin
   $bound_step( tstep_occ );
   @(initial_step) begin
      VGS_retc=0;
      VGS_cnt = maxEv;
      VGD_retc=0;
      VGD_cnt = maxEv;
      VDS_retc=0;
      VDS_cnt = maxEv;
      VDB_retc=0;
      VDB_cnt = maxEv;
      VSB_retc=0;
      VSB_cnt = maxEv;
   end
   V_S_B = V(S,B);
   V_D_B = V(D,B);
   V_D_S = V(D,S);
   V_G_D = V(G,D);
   V_G_S = V(G,S);

//      VGS
   VGS = V_G_S;
   if((VGS_cnt>0) || ( maxEv_flg==0 ))   begin
      if( (VGS < -1.98) && (VGS_retc!=-1))
      begin
        outfile=$fopen(errFileName,"a");
        $strobe("pel           VGS     leaving   OCA (  .. -1.980 V ) at %7.4r  %M", $abstime );
        $fwrite(outfile,"pel           VGS     leaving   OCA (  .. -1.980 V ) at %7.4r  %M\n", $abstime );
        VGS_retc=-1;
        VGS_cnt=VGS_cnt-1;
        $fclose(outfile);
      end
      if((VGS >= -1.98) &&  (VGS <= 1.98) && (VGS_retc!=0))
      begin
        outfile=$fopen(errFileName,"a");
        $strobe("pel           VGS     entering SOCA ( -1.980 V .. 1.980 V ) at %7.4r  %M", $abstime );
        $fwrite(outfile,"pel           VGS     entering SOCA ( -1.980 V .. 1.980 V ) at %7.4r  %M\n", $abstime );
        VGS_retc=0;
        VGS_cnt=VGS_cnt-1;
        $fclose(outfile);
      end
      if((VGS > 1.98) &&  (VGS_retc!=1))
      begin
        outfile=$fopen(errFileName,"a");
        $strobe("pel           VGS     leaving   OCA ( 1.980 V ..  ) at %7.4r  %M", $abstime );
        $fwrite(outfile,"pel           VGS     leaving   OCA ( 1.980 V ..  ) at %7.4r  %M\n", $abstime );
        VGS_retc=1;
        VGS_cnt=VGS_cnt-1;
        $fclose(outfile);
      end
   end
   else
   begin
      if(VGS_cnt==0)
      begin
        outfile=$fopen(errFileName,"a");
        $strobe("pel           VGS     error limit ( %d ) reached at %7.4r  %M", maxEv, $abstime );
        $fwrite(outfile,"pel           VGS     error limit ( %d ) reached at %7.4r  %M\n", maxEv, $abstime );
        VGS_cnt=VGS_cnt-1;
        $fclose(outfile);
      end
   end

//      VGD
   VGD = V_G_D;
   if((VGD_cnt>0) || ( maxEv_flg==0 ))   begin
      if( (VGD < -1.98) && (VGD_retc!=-1))
      begin
        outfile=$fopen(errFileName,"a");
        $strobe("pel           VGD     leaving   OCA (  .. -1.980 V ) at %7.4r  %M", $abstime );
        $fwrite(outfile,"pel           VGD     leaving   OCA (  .. -1.980 V ) at %7.4r  %M\n", $abstime );
        VGD_retc=-1;
        VGD_cnt=VGD_cnt-1;
        $fclose(outfile);
      end
      if((VGD >= -1.98) &&  (VGD <= 1.98) && (VGD_retc!=0))
      begin
        outfile=$fopen(errFileName,"a");
        $strobe("pel           VGD     entering SOCA ( -1.980 V .. 1.980 V ) at %7.4r  %M", $abstime );
        $fwrite(outfile,"pel           VGD     entering SOCA ( -1.980 V .. 1.980 V ) at %7.4r  %M\n", $abstime );
        VGD_retc=0;
        VGD_cnt=VGD_cnt-1;
        $fclose(outfile);
      end
      if((VGD > 1.98) &&  (VGD_retc!=1))
      begin
        outfile=$fopen(errFileName,"a");
        $strobe("pel           VGD     leaving   OCA ( 1.980 V ..  ) at %7.4r  %M", $abstime );
        $fwrite(outfile,"pel           VGD     leaving   OCA ( 1.980 V ..  ) at %7.4r  %M\n", $abstime );
        VGD_retc=1;
        VGD_cnt=VGD_cnt-1;
        $fclose(outfile);
      end
   end
   else
   begin
      if(VGD_cnt==0)
      begin
        outfile=$fopen(errFileName,"a");
        $strobe("pel           VGD     error limit ( %d ) reached at %7.4r  %M", maxEv, $abstime );
        $fwrite(outfile,"pel           VGD     error limit ( %d ) reached at %7.4r  %M\n", maxEv, $abstime );
        VGD_cnt=VGD_cnt-1;
        $fclose(outfile);
      end
   end

//      VDS
   VDS = V_D_S;
   if((VDS_cnt>0) || ( maxEv_flg==0 ))   begin
      if( (VDS < -1.98) && (VDS_retc!=-1))
      begin
        outfile=$fopen(errFileName,"a");
        $strobe("pel           VDS     leaving   OCA (  .. -1.980 V ) at %7.4r  %M", $abstime );
        $fwrite(outfile,"pel           VDS     leaving   OCA (  .. -1.980 V ) at %7.4r  %M\n", $abstime );
        VDS_retc=-1;
        VDS_cnt=VDS_cnt-1;
        $fclose(outfile);
      end
      if((VDS >= -1.98) &&  (VDS <= 1.98) && (VDS_retc!=0))
      begin
        outfile=$fopen(errFileName,"a");
        $strobe("pel           VDS     entering SOCA ( -1.980 V .. 1.980 V ) at %7.4r  %M", $abstime );
        $fwrite(outfile,"pel           VDS     entering SOCA ( -1.980 V .. 1.980 V ) at %7.4r  %M\n", $abstime );
        VDS_retc=0;
        VDS_cnt=VDS_cnt-1;
        $fclose(outfile);
      end
      if((VDS > 1.98) &&  (VDS_retc!=1))
      begin
        outfile=$fopen(errFileName,"a");
        $strobe("pel           VDS     leaving   OCA ( 1.980 V ..  ) at %7.4r  %M", $abstime );
        $fwrite(outfile,"pel           VDS     leaving   OCA ( 1.980 V ..  ) at %7.4r  %M\n", $abstime );
        VDS_retc=1;
        VDS_cnt=VDS_cnt-1;
        $fclose(outfile);
      end
   end
   else
   begin
      if(VDS_cnt==0)
      begin
        outfile=$fopen(errFileName,"a");
        $strobe("pel           VDS     error limit ( %d ) reached at %7.4r  %M", maxEv, $abstime );
        $fwrite(outfile,"pel           VDS     error limit ( %d ) reached at %7.4r  %M\n", maxEv, $abstime );
        VDS_cnt=VDS_cnt-1;
        $fclose(outfile);
      end
   end

//      VDB
   VDB = V_D_B;
   if((VDB_cnt>0) || ( maxEv_flg==0 ))   begin
      if( (VDB < -1.98) && (VDB_retc!=-1))
      begin
        outfile=$fopen(errFileName,"a");
        $strobe("pel           VDB     leaving   OCA (  .. -1.980 V ) at %7.4r  %M", $abstime );
        $fwrite(outfile,"pel           VDB     leaving   OCA (  .. -1.980 V ) at %7.4r  %M\n", $abstime );
        VDB_retc=-1;
        VDB_cnt=VDB_cnt-1;
        $fclose(outfile);
      end
      if((VDB >= -1.98) &&  (VDB <= 0.1) && (VDB_retc!=0))
      begin
        outfile=$fopen(errFileName,"a");
        $strobe("pel           VDB     entering SOCA ( -1.980 V .. 0.100 V ) at %7.4r  %M", $abstime );
        $fwrite(outfile,"pel           VDB     entering SOCA ( -1.980 V .. 0.100 V ) at %7.4r  %M\n", $abstime );
        VDB_retc=0;
        VDB_cnt=VDB_cnt-1;
        $fclose(outfile);
      end
      if((VDB > 0.1) &&  (VDB_retc!=1))
      begin
        outfile=$fopen(errFileName,"a");
        $strobe("pel           VDB     leaving   OCA ( 0.100 V ..  ) at %7.4r  %M", $abstime );
        $fwrite(outfile,"pel           VDB     leaving   OCA ( 0.100 V ..  ) at %7.4r  %M\n", $abstime );
        VDB_retc=1;
        VDB_cnt=VDB_cnt-1;
        $fclose(outfile);
      end
   end
   else
   begin
      if(VDB_cnt==0)
      begin
        outfile=$fopen(errFileName,"a");
        $strobe("pel           VDB     error limit ( %d ) reached at %7.4r  %M", maxEv, $abstime );
        $fwrite(outfile,"pel           VDB     error limit ( %d ) reached at %7.4r  %M\n", maxEv, $abstime );
        VDB_cnt=VDB_cnt-1;
        $fclose(outfile);
      end
   end

//      VSB
   VSB = V_S_B;
   if((VSB_cnt>0) || ( maxEv_flg==0 ))   begin
      if( (VSB < -1.98) && (VSB_retc!=-1))
      begin
        outfile=$fopen(errFileName,"a");
        $strobe("pel           VSB     leaving   OCA (  .. -1.980 V ) at %7.4r  %M", $abstime );
        $fwrite(outfile,"pel           VSB     leaving   OCA (  .. -1.980 V ) at %7.4r  %M\n", $abstime );
        VSB_retc=-1;
        VSB_cnt=VSB_cnt-1;
        $fclose(outfile);
      end
      if((VSB >= -1.98) &&  (VSB <= 0.1) && (VSB_retc!=0))
      begin
        outfile=$fopen(errFileName,"a");
        $strobe("pel           VSB     entering SOCA ( -1.980 V .. 0.100 V ) at %7.4r  %M", $abstime );
        $fwrite(outfile,"pel           VSB     entering SOCA ( -1.980 V .. 0.100 V ) at %7.4r  %M\n", $abstime );
        VSB_retc=0;
        VSB_cnt=VSB_cnt-1;
        $fclose(outfile);
      end
      if((VSB > 0.1) &&  (VSB_retc!=1))
      begin
        outfile=$fopen(errFileName,"a");
        $strobe("pel           VSB     leaving   OCA ( 0.100 V ..  ) at %7.4r  %M", $abstime );
        $fwrite(outfile,"pel           VSB     leaving   OCA ( 0.100 V ..  ) at %7.4r  %M\n", $abstime );
        VSB_retc=1;
        VSB_cnt=VSB_cnt-1;
        $fclose(outfile);
      end
   end
   else
   begin
      if(VSB_cnt==0)
      begin
        outfile=$fopen(errFileName,"a");
        $strobe("pel           VSB     error limit ( %d ) reached at %7.4r  %M", maxEv, $abstime );
        $fwrite(outfile,"pel           VSB     error limit ( %d ) reached at %7.4r  %M\n", maxEv, $abstime );
        VSB_cnt=VSB_cnt-1;
        $fclose(outfile);
      end
   end

end // analog
endmodule // pel

// Verilog-A OC Watch for device peti Parameters  VGS VGD VDS VDB VSB
module peti_ahdl(D,G,S,B);
parameter tstep_occ=100n;
parameter errFileName="./occ.err";
parameter maxEv = 25;
parameter maxEv_flg = 0;
inout D,G,S,B;
electrical D,G,S,B;

integer outfile;
real V_S_B;
real V_D_B;
real V_D_S;
real V_G_D;
real V_G_S;
real VGS;
integer VGS_retc;
integer VGS_cnt;
real VGD;
integer VGD_retc;
integer VGD_cnt;
real VDS;
integer VDS_retc;
integer VDS_cnt;
real VDB;
integer VDB_retc;
integer VDB_cnt;
real VSB;
integer VSB_retc;
integer VSB_cnt;

analog begin
   $bound_step( tstep_occ );
   @(initial_step) begin
      VGS_retc=0;
      VGS_cnt = maxEv;
      VGD_retc=0;
      VGD_cnt = maxEv;
      VDS_retc=0;
      VDS_cnt = maxEv;
      VDB_retc=0;
      VDB_cnt = maxEv;
      VSB_retc=0;
      VSB_cnt = maxEv;
   end
   V_S_B = V(S,B);
   V_D_B = V(D,B);
   V_D_S = V(D,S);
   V_G_D = V(G,D);
   V_G_S = V(G,S);

//      VGS
   VGS = V_G_S;
   if((VGS_cnt>0) || ( maxEv_flg==0 ))   begin
      if( (VGS < -1.98) && (VGS_retc!=-1))
      begin
        outfile=$fopen(errFileName,"a");
        $strobe("peti          VGS     leaving   OCA (  .. -1.980 V ) at %7.4r  %M", $abstime );
        $fwrite(outfile,"peti          VGS     leaving   OCA (  .. -1.980 V ) at %7.4r  %M\n", $abstime );
        VGS_retc=-1;
        VGS_cnt=VGS_cnt-1;
        $fclose(outfile);
      end
      if((VGS >= -1.98) &&  (VGS <= 1.98) && (VGS_retc!=0))
      begin
        outfile=$fopen(errFileName,"a");
        $strobe("peti          VGS     entering SOCA ( -1.980 V .. 1.980 V ) at %7.4r  %M", $abstime );
        $fwrite(outfile,"peti          VGS     entering SOCA ( -1.980 V .. 1.980 V ) at %7.4r  %M\n", $abstime );
        VGS_retc=0;
        VGS_cnt=VGS_cnt-1;
        $fclose(outfile);
      end
      if((VGS > 1.98) &&  (VGS_retc!=1))
      begin
        outfile=$fopen(errFileName,"a");
        $strobe("peti          VGS     leaving   OCA ( 1.980 V ..  ) at %7.4r  %M", $abstime );
        $fwrite(outfile,"peti          VGS     leaving   OCA ( 1.980 V ..  ) at %7.4r  %M\n", $abstime );
        VGS_retc=1;
        VGS_cnt=VGS_cnt-1;
        $fclose(outfile);
      end
   end
   else
   begin
      if(VGS_cnt==0)
      begin
        outfile=$fopen(errFileName,"a");
        $strobe("peti          VGS     error limit ( %d ) reached at %7.4r  %M", maxEv, $abstime );
        $fwrite(outfile,"peti          VGS     error limit ( %d ) reached at %7.4r  %M\n", maxEv, $abstime );
        VGS_cnt=VGS_cnt-1;
        $fclose(outfile);
      end
   end

//      VGD
   VGD = V_G_D;
   if((VGD_cnt>0) || ( maxEv_flg==0 ))   begin
      if( (VGD < -1.98) && (VGD_retc!=-1))
      begin
        outfile=$fopen(errFileName,"a");
        $strobe("peti          VGD     leaving   OCA (  .. -1.980 V ) at %7.4r  %M", $abstime );
        $fwrite(outfile,"peti          VGD     leaving   OCA (  .. -1.980 V ) at %7.4r  %M\n", $abstime );
        VGD_retc=-1;
        VGD_cnt=VGD_cnt-1;
        $fclose(outfile);
      end
      if((VGD >= -1.98) &&  (VGD <= 1.98) && (VGD_retc!=0))
      begin
        outfile=$fopen(errFileName,"a");
        $strobe("peti          VGD     entering SOCA ( -1.980 V .. 1.980 V ) at %7.4r  %M", $abstime );
        $fwrite(outfile,"peti          VGD     entering SOCA ( -1.980 V .. 1.980 V ) at %7.4r  %M\n", $abstime );
        VGD_retc=0;
        VGD_cnt=VGD_cnt-1;
        $fclose(outfile);
      end
      if((VGD > 1.98) &&  (VGD_retc!=1))
      begin
        outfile=$fopen(errFileName,"a");
        $strobe("peti          VGD     leaving   OCA ( 1.980 V ..  ) at %7.4r  %M", $abstime );
        $fwrite(outfile,"peti          VGD     leaving   OCA ( 1.980 V ..  ) at %7.4r  %M\n", $abstime );
        VGD_retc=1;
        VGD_cnt=VGD_cnt-1;
        $fclose(outfile);
      end
   end
   else
   begin
      if(VGD_cnt==0)
      begin
        outfile=$fopen(errFileName,"a");
        $strobe("peti          VGD     error limit ( %d ) reached at %7.4r  %M", maxEv, $abstime );
        $fwrite(outfile,"peti          VGD     error limit ( %d ) reached at %7.4r  %M\n", maxEv, $abstime );
        VGD_cnt=VGD_cnt-1;
        $fclose(outfile);
      end
   end

//      VDS
   VDS = V_D_S;
   if((VDS_cnt>0) || ( maxEv_flg==0 ))   begin
      if( (VDS < -1.98) && (VDS_retc!=-1))
      begin
        outfile=$fopen(errFileName,"a");
        $strobe("peti          VDS     leaving   OCA (  .. -1.980 V ) at %7.4r  %M", $abstime );
        $fwrite(outfile,"peti          VDS     leaving   OCA (  .. -1.980 V ) at %7.4r  %M\n", $abstime );
        VDS_retc=-1;
        VDS_cnt=VDS_cnt-1;
        $fclose(outfile);
      end
      if((VDS >= -1.98) &&  (VDS <= 1.98) && (VDS_retc!=0))
      begin
        outfile=$fopen(errFileName,"a");
        $strobe("peti          VDS     entering SOCA ( -1.980 V .. 1.980 V ) at %7.4r  %M", $abstime );
        $fwrite(outfile,"peti          VDS     entering SOCA ( -1.980 V .. 1.980 V ) at %7.4r  %M\n", $abstime );
        VDS_retc=0;
        VDS_cnt=VDS_cnt-1;
        $fclose(outfile);
      end
      if((VDS > 1.98) &&  (VDS_retc!=1))
      begin
        outfile=$fopen(errFileName,"a");
        $strobe("peti          VDS     leaving   OCA ( 1.980 V ..  ) at %7.4r  %M", $abstime );
        $fwrite(outfile,"peti          VDS     leaving   OCA ( 1.980 V ..  ) at %7.4r  %M\n", $abstime );
        VDS_retc=1;
        VDS_cnt=VDS_cnt-1;
        $fclose(outfile);
      end
   end
   else
   begin
      if(VDS_cnt==0)
      begin
        outfile=$fopen(errFileName,"a");
        $strobe("peti          VDS     error limit ( %d ) reached at %7.4r  %M", maxEv, $abstime );
        $fwrite(outfile,"peti          VDS     error limit ( %d ) reached at %7.4r  %M\n", maxEv, $abstime );
        VDS_cnt=VDS_cnt-1;
        $fclose(outfile);
      end
   end

//      VDB
   VDB = V_D_B;
   if((VDB_cnt>0) || ( maxEv_flg==0 ))   begin
      if( (VDB < -1.98) && (VDB_retc!=-1))
      begin
        outfile=$fopen(errFileName,"a");
        $strobe("peti          VDB     leaving   OCA (  .. -1.980 V ) at %7.4r  %M", $abstime );
        $fwrite(outfile,"peti          VDB     leaving   OCA (  .. -1.980 V ) at %7.4r  %M\n", $abstime );
        VDB_retc=-1;
        VDB_cnt=VDB_cnt-1;
        $fclose(outfile);
      end
      if((VDB >= -1.98) &&  (VDB <= 0.1) && (VDB_retc!=0))
      begin
        outfile=$fopen(errFileName,"a");
        $strobe("peti          VDB     entering SOCA ( -1.980 V .. 0.100 V ) at %7.4r  %M", $abstime );
        $fwrite(outfile,"peti          VDB     entering SOCA ( -1.980 V .. 0.100 V ) at %7.4r  %M\n", $abstime );
        VDB_retc=0;
        VDB_cnt=VDB_cnt-1;
        $fclose(outfile);
      end
      if((VDB > 0.1) &&  (VDB_retc!=1))
      begin
        outfile=$fopen(errFileName,"a");
        $strobe("peti          VDB     leaving   OCA ( 0.100 V ..  ) at %7.4r  %M", $abstime );
        $fwrite(outfile,"peti          VDB     leaving   OCA ( 0.100 V ..  ) at %7.4r  %M\n", $abstime );
        VDB_retc=1;
        VDB_cnt=VDB_cnt-1;
        $fclose(outfile);
      end
   end
   else
   begin
      if(VDB_cnt==0)
      begin
        outfile=$fopen(errFileName,"a");
        $strobe("peti          VDB     error limit ( %d ) reached at %7.4r  %M", maxEv, $abstime );
        $fwrite(outfile,"peti          VDB     error limit ( %d ) reached at %7.4r  %M\n", maxEv, $abstime );
        VDB_cnt=VDB_cnt-1;
        $fclose(outfile);
      end
   end

//      VSB
   VSB = V_S_B;
   if((VSB_cnt>0) || ( maxEv_flg==0 ))   begin
      if( (VSB < -1.98) && (VSB_retc!=-1))
      begin
        outfile=$fopen(errFileName,"a");
        $strobe("peti          VSB     leaving   OCA (  .. -1.980 V ) at %7.4r  %M", $abstime );
        $fwrite(outfile,"peti          VSB     leaving   OCA (  .. -1.980 V ) at %7.4r  %M\n", $abstime );
        VSB_retc=-1;
        VSB_cnt=VSB_cnt-1;
        $fclose(outfile);
      end
      if((VSB >= -1.98) &&  (VSB <= 0.1) && (VSB_retc!=0))
      begin
        outfile=$fopen(errFileName,"a");
        $strobe("peti          VSB     entering SOCA ( -1.980 V .. 0.100 V ) at %7.4r  %M", $abstime );
        $fwrite(outfile,"peti          VSB     entering SOCA ( -1.980 V .. 0.100 V ) at %7.4r  %M\n", $abstime );
        VSB_retc=0;
        VSB_cnt=VSB_cnt-1;
        $fclose(outfile);
      end
      if((VSB > 0.1) &&  (VSB_retc!=1))
      begin
        outfile=$fopen(errFileName,"a");
        $strobe("peti          VSB     leaving   OCA ( 0.100 V ..  ) at %7.4r  %M", $abstime );
        $fwrite(outfile,"peti          VSB     leaving   OCA ( 0.100 V ..  ) at %7.4r  %M\n", $abstime );
        VSB_retc=1;
        VSB_cnt=VSB_cnt-1;
        $fclose(outfile);
      end
   end
   else
   begin
      if(VSB_cnt==0)
      begin
        outfile=$fopen(errFileName,"a");
        $strobe("peti          VSB     error limit ( %d ) reached at %7.4r  %M", maxEv, $abstime );
        $fwrite(outfile,"peti          VSB     error limit ( %d ) reached at %7.4r  %M\n", maxEv, $abstime );
        VSB_cnt=VSB_cnt-1;
        $fclose(outfile);
      end
   end

end // analog
endmodule // peti

// Verilog-A OC Watch for device pesvt Parameters  VGS VGD VDS VDB VSB
module pesvt_ahdl(D,G,S,B);
parameter tstep_occ=100n;
parameter errFileName="./occ.err";
parameter maxEv = 25;
parameter maxEv_flg = 0;
inout D,G,S,B;
electrical D,G,S,B;

integer outfile;
real V_S_B;
real V_D_B;
real V_D_S;
real V_G_D;
real V_G_S;
real VGS;
integer VGS_retc;
integer VGS_cnt;
real VGD;
integer VGD_retc;
integer VGD_cnt;
real VDS;
integer VDS_retc;
integer VDS_cnt;
real VDB;
integer VDB_retc;
integer VDB_cnt;
real VSB;
integer VSB_retc;
integer VSB_cnt;

analog begin
   $bound_step( tstep_occ );
   @(initial_step) begin
      VGS_retc=0;
      VGS_cnt = maxEv;
      VGD_retc=0;
      VGD_cnt = maxEv;
      VDS_retc=0;
      VDS_cnt = maxEv;
      VDB_retc=0;
      VDB_cnt = maxEv;
      VSB_retc=0;
      VSB_cnt = maxEv;
   end
   V_S_B = V(S,B);
   V_D_B = V(D,B);
   V_D_S = V(D,S);
   V_G_D = V(G,D);
   V_G_S = V(G,S);

//      VGS
   VGS = V_G_S;
   if((VGS_cnt>0) || ( maxEv_flg==0 ))   begin
      if( (VGS < -1.98) && (VGS_retc!=-1))
      begin
        outfile=$fopen(errFileName,"a");
        $strobe("pesvt         VGS     leaving   OCA (  .. -1.980 V ) at %7.4r  %M", $abstime );
        $fwrite(outfile,"pesvt         VGS     leaving   OCA (  .. -1.980 V ) at %7.4r  %M\n", $abstime );
        VGS_retc=-1;
        VGS_cnt=VGS_cnt-1;
        $fclose(outfile);
      end
      if((VGS >= -1.98) &&  (VGS <= 1.98) && (VGS_retc!=0))
      begin
        outfile=$fopen(errFileName,"a");
        $strobe("pesvt         VGS     entering SOCA ( -1.980 V .. 1.980 V ) at %7.4r  %M", $abstime );
        $fwrite(outfile,"pesvt         VGS     entering SOCA ( -1.980 V .. 1.980 V ) at %7.4r  %M\n", $abstime );
        VGS_retc=0;
        VGS_cnt=VGS_cnt-1;
        $fclose(outfile);
      end
      if((VGS > 1.98) &&  (VGS_retc!=1))
      begin
        outfile=$fopen(errFileName,"a");
        $strobe("pesvt         VGS     leaving   OCA ( 1.980 V ..  ) at %7.4r  %M", $abstime );
        $fwrite(outfile,"pesvt         VGS     leaving   OCA ( 1.980 V ..  ) at %7.4r  %M\n", $abstime );
        VGS_retc=1;
        VGS_cnt=VGS_cnt-1;
        $fclose(outfile);
      end
   end
   else
   begin
      if(VGS_cnt==0)
      begin
        outfile=$fopen(errFileName,"a");
        $strobe("pesvt         VGS     error limit ( %d ) reached at %7.4r  %M", maxEv, $abstime );
        $fwrite(outfile,"pesvt         VGS     error limit ( %d ) reached at %7.4r  %M\n", maxEv, $abstime );
        VGS_cnt=VGS_cnt-1;
        $fclose(outfile);
      end
   end

//      VGD
   VGD = V_G_D;
   if((VGD_cnt>0) || ( maxEv_flg==0 ))   begin
      if( (VGD < -1.98) && (VGD_retc!=-1))
      begin
        outfile=$fopen(errFileName,"a");
        $strobe("pesvt         VGD     leaving   OCA (  .. -1.980 V ) at %7.4r  %M", $abstime );
        $fwrite(outfile,"pesvt         VGD     leaving   OCA (  .. -1.980 V ) at %7.4r  %M\n", $abstime );
        VGD_retc=-1;
        VGD_cnt=VGD_cnt-1;
        $fclose(outfile);
      end
      if((VGD >= -1.98) &&  (VGD <= 1.98) && (VGD_retc!=0))
      begin
        outfile=$fopen(errFileName,"a");
        $strobe("pesvt         VGD     entering SOCA ( -1.980 V .. 1.980 V ) at %7.4r  %M", $abstime );
        $fwrite(outfile,"pesvt         VGD     entering SOCA ( -1.980 V .. 1.980 V ) at %7.4r  %M\n", $abstime );
        VGD_retc=0;
        VGD_cnt=VGD_cnt-1;
        $fclose(outfile);
      end
      if((VGD > 1.98) &&  (VGD_retc!=1))
      begin
        outfile=$fopen(errFileName,"a");
        $strobe("pesvt         VGD     leaving   OCA ( 1.980 V ..  ) at %7.4r  %M", $abstime );
        $fwrite(outfile,"pesvt         VGD     leaving   OCA ( 1.980 V ..  ) at %7.4r  %M\n", $abstime );
        VGD_retc=1;
        VGD_cnt=VGD_cnt-1;
        $fclose(outfile);
      end
   end
   else
   begin
      if(VGD_cnt==0)
      begin
        outfile=$fopen(errFileName,"a");
        $strobe("pesvt         VGD     error limit ( %d ) reached at %7.4r  %M", maxEv, $abstime );
        $fwrite(outfile,"pesvt         VGD     error limit ( %d ) reached at %7.4r  %M\n", maxEv, $abstime );
        VGD_cnt=VGD_cnt-1;
        $fclose(outfile);
      end
   end

//      VDS
   VDS = V_D_S;
   if((VDS_cnt>0) || ( maxEv_flg==0 ))   begin
      if( (VDS < -1.98) && (VDS_retc!=-1))
      begin
        outfile=$fopen(errFileName,"a");
        $strobe("pesvt         VDS     leaving   OCA (  .. -1.980 V ) at %7.4r  %M", $abstime );
        $fwrite(outfile,"pesvt         VDS     leaving   OCA (  .. -1.980 V ) at %7.4r  %M\n", $abstime );
        VDS_retc=-1;
        VDS_cnt=VDS_cnt-1;
        $fclose(outfile);
      end
      if((VDS >= -1.98) &&  (VDS <= 1.98) && (VDS_retc!=0))
      begin
        outfile=$fopen(errFileName,"a");
        $strobe("pesvt         VDS     entering SOCA ( -1.980 V .. 1.980 V ) at %7.4r  %M", $abstime );
        $fwrite(outfile,"pesvt         VDS     entering SOCA ( -1.980 V .. 1.980 V ) at %7.4r  %M\n", $abstime );
        VDS_retc=0;
        VDS_cnt=VDS_cnt-1;
        $fclose(outfile);
      end
      if((VDS > 1.98) &&  (VDS_retc!=1))
      begin
        outfile=$fopen(errFileName,"a");
        $strobe("pesvt         VDS     leaving   OCA ( 1.980 V ..  ) at %7.4r  %M", $abstime );
        $fwrite(outfile,"pesvt         VDS     leaving   OCA ( 1.980 V ..  ) at %7.4r  %M\n", $abstime );
        VDS_retc=1;
        VDS_cnt=VDS_cnt-1;
        $fclose(outfile);
      end
   end
   else
   begin
      if(VDS_cnt==0)
      begin
        outfile=$fopen(errFileName,"a");
        $strobe("pesvt         VDS     error limit ( %d ) reached at %7.4r  %M", maxEv, $abstime );
        $fwrite(outfile,"pesvt         VDS     error limit ( %d ) reached at %7.4r  %M\n", maxEv, $abstime );
        VDS_cnt=VDS_cnt-1;
        $fclose(outfile);
      end
   end

//      VDB
   VDB = V_D_B;
   if((VDB_cnt>0) || ( maxEv_flg==0 ))   begin
      if( (VDB < -1.98) && (VDB_retc!=-1))
      begin
        outfile=$fopen(errFileName,"a");
        $strobe("pesvt         VDB     leaving   OCA (  .. -1.980 V ) at %7.4r  %M", $abstime );
        $fwrite(outfile,"pesvt         VDB     leaving   OCA (  .. -1.980 V ) at %7.4r  %M\n", $abstime );
        VDB_retc=-1;
        VDB_cnt=VDB_cnt-1;
        $fclose(outfile);
      end
      if((VDB >= -1.98) &&  (VDB <= 0.1) && (VDB_retc!=0))
      begin
        outfile=$fopen(errFileName,"a");
        $strobe("pesvt         VDB     entering SOCA ( -1.980 V .. 0.100 V ) at %7.4r  %M", $abstime );
        $fwrite(outfile,"pesvt         VDB     entering SOCA ( -1.980 V .. 0.100 V ) at %7.4r  %M\n", $abstime );
        VDB_retc=0;
        VDB_cnt=VDB_cnt-1;
        $fclose(outfile);
      end
      if((VDB > 0.1) &&  (VDB_retc!=1))
      begin
        outfile=$fopen(errFileName,"a");
        $strobe("pesvt         VDB     leaving   OCA ( 0.100 V ..  ) at %7.4r  %M", $abstime );
        $fwrite(outfile,"pesvt         VDB     leaving   OCA ( 0.100 V ..  ) at %7.4r  %M\n", $abstime );
        VDB_retc=1;
        VDB_cnt=VDB_cnt-1;
        $fclose(outfile);
      end
   end
   else
   begin
      if(VDB_cnt==0)
      begin
        outfile=$fopen(errFileName,"a");
        $strobe("pesvt         VDB     error limit ( %d ) reached at %7.4r  %M", maxEv, $abstime );
        $fwrite(outfile,"pesvt         VDB     error limit ( %d ) reached at %7.4r  %M\n", maxEv, $abstime );
        VDB_cnt=VDB_cnt-1;
        $fclose(outfile);
      end
   end

//      VSB
   VSB = V_S_B;
   if((VSB_cnt>0) || ( maxEv_flg==0 ))   begin
      if( (VSB < -1.98) && (VSB_retc!=-1))
      begin
        outfile=$fopen(errFileName,"a");
        $strobe("pesvt         VSB     leaving   OCA (  .. -1.980 V ) at %7.4r  %M", $abstime );
        $fwrite(outfile,"pesvt         VSB     leaving   OCA (  .. -1.980 V ) at %7.4r  %M\n", $abstime );
        VSB_retc=-1;
        VSB_cnt=VSB_cnt-1;
        $fclose(outfile);
      end
      if((VSB >= -1.98) &&  (VSB <= 0.1) && (VSB_retc!=0))
      begin
        outfile=$fopen(errFileName,"a");
        $strobe("pesvt         VSB     entering SOCA ( -1.980 V .. 0.100 V ) at %7.4r  %M", $abstime );
        $fwrite(outfile,"pesvt         VSB     entering SOCA ( -1.980 V .. 0.100 V ) at %7.4r  %M\n", $abstime );
        VSB_retc=0;
        VSB_cnt=VSB_cnt-1;
        $fclose(outfile);
      end
      if((VSB > 0.1) &&  (VSB_retc!=1))
      begin
        outfile=$fopen(errFileName,"a");
        $strobe("pesvt         VSB     leaving   OCA ( 0.100 V ..  ) at %7.4r  %M", $abstime );
        $fwrite(outfile,"pesvt         VSB     leaving   OCA ( 0.100 V ..  ) at %7.4r  %M\n", $abstime );
        VSB_retc=1;
        VSB_cnt=VSB_cnt-1;
        $fclose(outfile);
      end
   end
   else
   begin
      if(VSB_cnt==0)
      begin
        outfile=$fopen(errFileName,"a");
        $strobe("pesvt         VSB     error limit ( %d ) reached at %7.4r  %M", maxEv, $abstime );
        $fwrite(outfile,"pesvt         VSB     error limit ( %d ) reached at %7.4r  %M\n", maxEv, $abstime );
        VSB_cnt=VSB_cnt-1;
        $fclose(outfile);
      end
   end

end // analog
endmodule // pesvt

// Verilog-A OC Watch for device pe_5 Parameters  VGS VGD VDS VDB VSB VBsub
module pe_5_ahdl(D,G,S,B,sub);
parameter tstep_occ=100n;
parameter errFileName="./occ.err";
parameter maxEv = 25;
parameter maxEv_flg = 0;
inout D,G,S,B,sub;
electrical D,G,S,B,sub;

integer outfile;
real V_B_sub;
real V_S_B;
real V_D_B;
real V_D_S;
real V_G_D;
real V_G_S;
real VGS;
integer VGS_retc;
integer VGS_cnt;
real VGD;
integer VGD_retc;
integer VGD_cnt;
real VDS;
integer VDS_retc;
integer VDS_cnt;
real VDB;
integer VDB_retc;
integer VDB_cnt;
real VSB;
integer VSB_retc;
integer VSB_cnt;
real VBsub;
integer VBsub_retc;
integer VBsub_cnt;

analog begin
   $bound_step( tstep_occ );
   @(initial_step) begin
      VGS_retc=0;
      VGS_cnt = maxEv;
      VGD_retc=0;
      VGD_cnt = maxEv;
      VDS_retc=0;
      VDS_cnt = maxEv;
      VDB_retc=0;
      VDB_cnt = maxEv;
      VSB_retc=0;
      VSB_cnt = maxEv;
      VBsub_retc=0;
      VBsub_cnt = maxEv;
   end
   V_B_sub = V(B,sub);
   V_S_B = V(S,B);
   V_D_B = V(D,B);
   V_D_S = V(D,S);
   V_G_D = V(G,D);
   V_G_S = V(G,S);

//      VGS
   VGS = V_G_S;
   if((VGS_cnt>0) || ( maxEv_flg==0 ))   begin
      if( (VGS < -1.98) && (VGS_retc!=-1))
      begin
        outfile=$fopen(errFileName,"a");
        $strobe("pe_5          VGS     leaving   OCA (  .. -1.980 V ) at %7.4r  %M", $abstime );
        $fwrite(outfile,"pe_5          VGS     leaving   OCA (  .. -1.980 V ) at %7.4r  %M\n", $abstime );
        VGS_retc=-1;
        VGS_cnt=VGS_cnt-1;
        $fclose(outfile);
      end
      if((VGS >= -1.98) &&  (VGS <= 1.98) && (VGS_retc!=0))
      begin
        outfile=$fopen(errFileName,"a");
        $strobe("pe_5          VGS     entering SOCA ( -1.980 V .. 1.980 V ) at %7.4r  %M", $abstime );
        $fwrite(outfile,"pe_5          VGS     entering SOCA ( -1.980 V .. 1.980 V ) at %7.4r  %M\n", $abstime );
        VGS_retc=0;
        VGS_cnt=VGS_cnt-1;
        $fclose(outfile);
      end
      if((VGS > 1.98) &&  (VGS_retc!=1))
      begin
        outfile=$fopen(errFileName,"a");
        $strobe("pe_5          VGS     leaving   OCA ( 1.980 V ..  ) at %7.4r  %M", $abstime );
        $fwrite(outfile,"pe_5          VGS     leaving   OCA ( 1.980 V ..  ) at %7.4r  %M\n", $abstime );
        VGS_retc=1;
        VGS_cnt=VGS_cnt-1;
        $fclose(outfile);
      end
   end
   else
   begin
      if(VGS_cnt==0)
      begin
        outfile=$fopen(errFileName,"a");
        $strobe("pe_5          VGS     error limit ( %d ) reached at %7.4r  %M", maxEv, $abstime );
        $fwrite(outfile,"pe_5          VGS     error limit ( %d ) reached at %7.4r  %M\n", maxEv, $abstime );
        VGS_cnt=VGS_cnt-1;
        $fclose(outfile);
      end
   end

//      VGD
   VGD = V_G_D;
   if((VGD_cnt>0) || ( maxEv_flg==0 ))   begin
      if( (VGD < -1.98) && (VGD_retc!=-1))
      begin
        outfile=$fopen(errFileName,"a");
        $strobe("pe_5          VGD     leaving   OCA (  .. -1.980 V ) at %7.4r  %M", $abstime );
        $fwrite(outfile,"pe_5          VGD     leaving   OCA (  .. -1.980 V ) at %7.4r  %M\n", $abstime );
        VGD_retc=-1;
        VGD_cnt=VGD_cnt-1;
        $fclose(outfile);
      end
      if((VGD >= -1.98) &&  (VGD <= 1.98) && (VGD_retc!=0))
      begin
        outfile=$fopen(errFileName,"a");
        $strobe("pe_5          VGD     entering SOCA ( -1.980 V .. 1.980 V ) at %7.4r  %M", $abstime );
        $fwrite(outfile,"pe_5          VGD     entering SOCA ( -1.980 V .. 1.980 V ) at %7.4r  %M\n", $abstime );
        VGD_retc=0;
        VGD_cnt=VGD_cnt-1;
        $fclose(outfile);
      end
      if((VGD > 1.98) &&  (VGD_retc!=1))
      begin
        outfile=$fopen(errFileName,"a");
        $strobe("pe_5          VGD     leaving   OCA ( 1.980 V ..  ) at %7.4r  %M", $abstime );
        $fwrite(outfile,"pe_5          VGD     leaving   OCA ( 1.980 V ..  ) at %7.4r  %M\n", $abstime );
        VGD_retc=1;
        VGD_cnt=VGD_cnt-1;
        $fclose(outfile);
      end
   end
   else
   begin
      if(VGD_cnt==0)
      begin
        outfile=$fopen(errFileName,"a");
        $strobe("pe_5          VGD     error limit ( %d ) reached at %7.4r  %M", maxEv, $abstime );
        $fwrite(outfile,"pe_5          VGD     error limit ( %d ) reached at %7.4r  %M\n", maxEv, $abstime );
        VGD_cnt=VGD_cnt-1;
        $fclose(outfile);
      end
   end

//      VDS
   VDS = V_D_S;
   if((VDS_cnt>0) || ( maxEv_flg==0 ))   begin
      if( (VDS < -1.98) && (VDS_retc!=-1))
      begin
        outfile=$fopen(errFileName,"a");
        $strobe("pe_5          VDS     leaving   OCA (  .. -1.980 V ) at %7.4r  %M", $abstime );
        $fwrite(outfile,"pe_5          VDS     leaving   OCA (  .. -1.980 V ) at %7.4r  %M\n", $abstime );
        VDS_retc=-1;
        VDS_cnt=VDS_cnt-1;
        $fclose(outfile);
      end
      if((VDS >= -1.98) &&  (VDS <= 1.98) && (VDS_retc!=0))
      begin
        outfile=$fopen(errFileName,"a");
        $strobe("pe_5          VDS     entering SOCA ( -1.980 V .. 1.980 V ) at %7.4r  %M", $abstime );
        $fwrite(outfile,"pe_5          VDS     entering SOCA ( -1.980 V .. 1.980 V ) at %7.4r  %M\n", $abstime );
        VDS_retc=0;
        VDS_cnt=VDS_cnt-1;
        $fclose(outfile);
      end
      if((VDS > 1.98) &&  (VDS_retc!=1))
      begin
        outfile=$fopen(errFileName,"a");
        $strobe("pe_5          VDS     leaving   OCA ( 1.980 V ..  ) at %7.4r  %M", $abstime );
        $fwrite(outfile,"pe_5          VDS     leaving   OCA ( 1.980 V ..  ) at %7.4r  %M\n", $abstime );
        VDS_retc=1;
        VDS_cnt=VDS_cnt-1;
        $fclose(outfile);
      end
   end
   else
   begin
      if(VDS_cnt==0)
      begin
        outfile=$fopen(errFileName,"a");
        $strobe("pe_5          VDS     error limit ( %d ) reached at %7.4r  %M", maxEv, $abstime );
        $fwrite(outfile,"pe_5          VDS     error limit ( %d ) reached at %7.4r  %M\n", maxEv, $abstime );
        VDS_cnt=VDS_cnt-1;
        $fclose(outfile);
      end
   end

//      VDB
   VDB = V_D_B;
   if((VDB_cnt>0) || ( maxEv_flg==0 ))   begin
      if( (VDB < -1.98) && (VDB_retc!=-1))
      begin
        outfile=$fopen(errFileName,"a");
        $strobe("pe_5          VDB     leaving   OCA (  .. -1.980 V ) at %7.4r  %M", $abstime );
        $fwrite(outfile,"pe_5          VDB     leaving   OCA (  .. -1.980 V ) at %7.4r  %M\n", $abstime );
        VDB_retc=-1;
        VDB_cnt=VDB_cnt-1;
        $fclose(outfile);
      end
      if((VDB >= -1.98) &&  (VDB <= 0.1) && (VDB_retc!=0))
      begin
        outfile=$fopen(errFileName,"a");
        $strobe("pe_5          VDB     entering SOCA ( -1.980 V .. 0.100 V ) at %7.4r  %M", $abstime );
        $fwrite(outfile,"pe_5          VDB     entering SOCA ( -1.980 V .. 0.100 V ) at %7.4r  %M\n", $abstime );
        VDB_retc=0;
        VDB_cnt=VDB_cnt-1;
        $fclose(outfile);
      end
      if((VDB > 0.1) &&  (VDB_retc!=1))
      begin
        outfile=$fopen(errFileName,"a");
        $strobe("pe_5          VDB     leaving   OCA ( 0.100 V ..  ) at %7.4r  %M", $abstime );
        $fwrite(outfile,"pe_5          VDB     leaving   OCA ( 0.100 V ..  ) at %7.4r  %M\n", $abstime );
        VDB_retc=1;
        VDB_cnt=VDB_cnt-1;
        $fclose(outfile);
      end
   end
   else
   begin
      if(VDB_cnt==0)
      begin
        outfile=$fopen(errFileName,"a");
        $strobe("pe_5          VDB     error limit ( %d ) reached at %7.4r  %M", maxEv, $abstime );
        $fwrite(outfile,"pe_5          VDB     error limit ( %d ) reached at %7.4r  %M\n", maxEv, $abstime );
        VDB_cnt=VDB_cnt-1;
        $fclose(outfile);
      end
   end

//      VSB
   VSB = V_S_B;
   if((VSB_cnt>0) || ( maxEv_flg==0 ))   begin
      if( (VSB < -1.98) && (VSB_retc!=-1))
      begin
        outfile=$fopen(errFileName,"a");
        $strobe("pe_5          VSB     leaving   OCA (  .. -1.980 V ) at %7.4r  %M", $abstime );
        $fwrite(outfile,"pe_5          VSB     leaving   OCA (  .. -1.980 V ) at %7.4r  %M\n", $abstime );
        VSB_retc=-1;
        VSB_cnt=VSB_cnt-1;
        $fclose(outfile);
      end
      if((VSB >= -1.98) &&  (VSB <= 0.1) && (VSB_retc!=0))
      begin
        outfile=$fopen(errFileName,"a");
        $strobe("pe_5          VSB     entering SOCA ( -1.980 V .. 0.100 V ) at %7.4r  %M", $abstime );
        $fwrite(outfile,"pe_5          VSB     entering SOCA ( -1.980 V .. 0.100 V ) at %7.4r  %M\n", $abstime );
        VSB_retc=0;
        VSB_cnt=VSB_cnt-1;
        $fclose(outfile);
      end
      if((VSB > 0.1) &&  (VSB_retc!=1))
      begin
        outfile=$fopen(errFileName,"a");
        $strobe("pe_5          VSB     leaving   OCA ( 0.100 V ..  ) at %7.4r  %M", $abstime );
        $fwrite(outfile,"pe_5          VSB     leaving   OCA ( 0.100 V ..  ) at %7.4r  %M\n", $abstime );
        VSB_retc=1;
        VSB_cnt=VSB_cnt-1;
        $fclose(outfile);
      end
   end
   else
   begin
      if(VSB_cnt==0)
      begin
        outfile=$fopen(errFileName,"a");
        $strobe("pe_5          VSB     error limit ( %d ) reached at %7.4r  %M", maxEv, $abstime );
        $fwrite(outfile,"pe_5          VSB     error limit ( %d ) reached at %7.4r  %M\n", maxEv, $abstime );
        VSB_cnt=VSB_cnt-1;
        $fclose(outfile);
      end
   end

//      VBsub
   VBsub = V_B_sub;
   if((VBsub_cnt>0) || ( maxEv_flg==0 ))   begin
      if( (VBsub < -0.1) && (VBsub_retc!=-1))
      begin
        outfile=$fopen(errFileName,"a");
        $strobe("pe_5          VBsub   leaving   OCA (  .. -0.100 V ) at %7.4r  %M", $abstime );
        $fwrite(outfile,"pe_5          VBsub   leaving   OCA (  .. -0.100 V ) at %7.4r  %M\n", $abstime );
        VBsub_retc=-1;
        VBsub_cnt=VBsub_cnt-1;
        $fclose(outfile);
      end
      if((VBsub >= -0.1) &&  (VBsub <= 1.98) && (VBsub_retc!=0))
      begin
        outfile=$fopen(errFileName,"a");
        $strobe("pe_5          VBsub   entering SOCA ( -0.100 V .. 1.980 V ) at %7.4r  %M", $abstime );
        $fwrite(outfile,"pe_5          VBsub   entering SOCA ( -0.100 V .. 1.980 V ) at %7.4r  %M\n", $abstime );
        VBsub_retc=0;
        VBsub_cnt=VBsub_cnt-1;
        $fclose(outfile);
      end
      if((VBsub > 1.98) &&  (VBsub_retc!=1))
      begin
        outfile=$fopen(errFileName,"a");
        $strobe("pe_5          VBsub   leaving   OCA ( 1.980 V ..  ) at %7.4r  %M", $abstime );
        $fwrite(outfile,"pe_5          VBsub   leaving   OCA ( 1.980 V ..  ) at %7.4r  %M\n", $abstime );
        VBsub_retc=1;
        VBsub_cnt=VBsub_cnt-1;
        $fclose(outfile);
      end
   end
   else
   begin
      if(VBsub_cnt==0)
      begin
        outfile=$fopen(errFileName,"a");
        $strobe("pe_5          VBsub   error limit ( %d ) reached at %7.4r  %M", maxEv, $abstime );
        $fwrite(outfile,"pe_5          VBsub   error limit ( %d ) reached at %7.4r  %M\n", maxEv, $abstime );
        VBsub_cnt=VBsub_cnt-1;
        $fclose(outfile);
      end
   end

end // analog
endmodule // pe_5

// Verilog-A OC Watch for device pel_5 Parameters  VGS VGD VDS VDB VSB VBsub
module pel_5_ahdl(D,G,S,B,sub);
parameter tstep_occ=100n;
parameter errFileName="./occ.err";
parameter maxEv = 25;
parameter maxEv_flg = 0;
inout D,G,S,B,sub;
electrical D,G,S,B,sub;

integer outfile;
real V_B_sub;
real V_S_B;
real V_D_B;
real V_D_S;
real V_G_D;
real V_G_S;
real VGS;
integer VGS_retc;
integer VGS_cnt;
real VGD;
integer VGD_retc;
integer VGD_cnt;
real VDS;
integer VDS_retc;
integer VDS_cnt;
real VDB;
integer VDB_retc;
integer VDB_cnt;
real VSB;
integer VSB_retc;
integer VSB_cnt;
real VBsub;
integer VBsub_retc;
integer VBsub_cnt;

analog begin
   $bound_step( tstep_occ );
   @(initial_step) begin
      VGS_retc=0;
      VGS_cnt = maxEv;
      VGD_retc=0;
      VGD_cnt = maxEv;
      VDS_retc=0;
      VDS_cnt = maxEv;
      VDB_retc=0;
      VDB_cnt = maxEv;
      VSB_retc=0;
      VSB_cnt = maxEv;
      VBsub_retc=0;
      VBsub_cnt = maxEv;
   end
   V_B_sub = V(B,sub);
   V_S_B = V(S,B);
   V_D_B = V(D,B);
   V_D_S = V(D,S);
   V_G_D = V(G,D);
   V_G_S = V(G,S);

//      VGS
   VGS = V_G_S;
   if((VGS_cnt>0) || ( maxEv_flg==0 ))   begin
      if( (VGS < -1.98) && (VGS_retc!=-1))
      begin
        outfile=$fopen(errFileName,"a");
        $strobe("pel_5         VGS     leaving   OCA (  .. -1.980 V ) at %7.4r  %M", $abstime );
        $fwrite(outfile,"pel_5         VGS     leaving   OCA (  .. -1.980 V ) at %7.4r  %M\n", $abstime );
        VGS_retc=-1;
        VGS_cnt=VGS_cnt-1;
        $fclose(outfile);
      end
      if((VGS >= -1.98) &&  (VGS <= 1.98) && (VGS_retc!=0))
      begin
        outfile=$fopen(errFileName,"a");
        $strobe("pel_5         VGS     entering SOCA ( -1.980 V .. 1.980 V ) at %7.4r  %M", $abstime );
        $fwrite(outfile,"pel_5         VGS     entering SOCA ( -1.980 V .. 1.980 V ) at %7.4r  %M\n", $abstime );
        VGS_retc=0;
        VGS_cnt=VGS_cnt-1;
        $fclose(outfile);
      end
      if((VGS > 1.98) &&  (VGS_retc!=1))
      begin
        outfile=$fopen(errFileName,"a");
        $strobe("pel_5         VGS     leaving   OCA ( 1.980 V ..  ) at %7.4r  %M", $abstime );
        $fwrite(outfile,"pel_5         VGS     leaving   OCA ( 1.980 V ..  ) at %7.4r  %M\n", $abstime );
        VGS_retc=1;
        VGS_cnt=VGS_cnt-1;
        $fclose(outfile);
      end
   end
   else
   begin
      if(VGS_cnt==0)
      begin
        outfile=$fopen(errFileName,"a");
        $strobe("pel_5         VGS     error limit ( %d ) reached at %7.4r  %M", maxEv, $abstime );
        $fwrite(outfile,"pel_5         VGS     error limit ( %d ) reached at %7.4r  %M\n", maxEv, $abstime );
        VGS_cnt=VGS_cnt-1;
        $fclose(outfile);
      end
   end

//      VGD
   VGD = V_G_D;
   if((VGD_cnt>0) || ( maxEv_flg==0 ))   begin
      if( (VGD < -1.98) && (VGD_retc!=-1))
      begin
        outfile=$fopen(errFileName,"a");
        $strobe("pel_5         VGD     leaving   OCA (  .. -1.980 V ) at %7.4r  %M", $abstime );
        $fwrite(outfile,"pel_5         VGD     leaving   OCA (  .. -1.980 V ) at %7.4r  %M\n", $abstime );
        VGD_retc=-1;
        VGD_cnt=VGD_cnt-1;
        $fclose(outfile);
      end
      if((VGD >= -1.98) &&  (VGD <= 1.98) && (VGD_retc!=0))
      begin
        outfile=$fopen(errFileName,"a");
        $strobe("pel_5         VGD     entering SOCA ( -1.980 V .. 1.980 V ) at %7.4r  %M", $abstime );
        $fwrite(outfile,"pel_5         VGD     entering SOCA ( -1.980 V .. 1.980 V ) at %7.4r  %M\n", $abstime );
        VGD_retc=0;
        VGD_cnt=VGD_cnt-1;
        $fclose(outfile);
      end
      if((VGD > 1.98) &&  (VGD_retc!=1))
      begin
        outfile=$fopen(errFileName,"a");
        $strobe("pel_5         VGD     leaving   OCA ( 1.980 V ..  ) at %7.4r  %M", $abstime );
        $fwrite(outfile,"pel_5         VGD     leaving   OCA ( 1.980 V ..  ) at %7.4r  %M\n", $abstime );
        VGD_retc=1;
        VGD_cnt=VGD_cnt-1;
        $fclose(outfile);
      end
   end
   else
   begin
      if(VGD_cnt==0)
      begin
        outfile=$fopen(errFileName,"a");
        $strobe("pel_5         VGD     error limit ( %d ) reached at %7.4r  %M", maxEv, $abstime );
        $fwrite(outfile,"pel_5         VGD     error limit ( %d ) reached at %7.4r  %M\n", maxEv, $abstime );
        VGD_cnt=VGD_cnt-1;
        $fclose(outfile);
      end
   end

//      VDS
   VDS = V_D_S;
   if((VDS_cnt>0) || ( maxEv_flg==0 ))   begin
      if( (VDS < -1.98) && (VDS_retc!=-1))
      begin
        outfile=$fopen(errFileName,"a");
        $strobe("pel_5         VDS     leaving   OCA (  .. -1.980 V ) at %7.4r  %M", $abstime );
        $fwrite(outfile,"pel_5         VDS     leaving   OCA (  .. -1.980 V ) at %7.4r  %M\n", $abstime );
        VDS_retc=-1;
        VDS_cnt=VDS_cnt-1;
        $fclose(outfile);
      end
      if((VDS >= -1.98) &&  (VDS <= 1.98) && (VDS_retc!=0))
      begin
        outfile=$fopen(errFileName,"a");
        $strobe("pel_5         VDS     entering SOCA ( -1.980 V .. 1.980 V ) at %7.4r  %M", $abstime );
        $fwrite(outfile,"pel_5         VDS     entering SOCA ( -1.980 V .. 1.980 V ) at %7.4r  %M\n", $abstime );
        VDS_retc=0;
        VDS_cnt=VDS_cnt-1;
        $fclose(outfile);
      end
      if((VDS > 1.98) &&  (VDS_retc!=1))
      begin
        outfile=$fopen(errFileName,"a");
        $strobe("pel_5         VDS     leaving   OCA ( 1.980 V ..  ) at %7.4r  %M", $abstime );
        $fwrite(outfile,"pel_5         VDS     leaving   OCA ( 1.980 V ..  ) at %7.4r  %M\n", $abstime );
        VDS_retc=1;
        VDS_cnt=VDS_cnt-1;
        $fclose(outfile);
      end
   end
   else
   begin
      if(VDS_cnt==0)
      begin
        outfile=$fopen(errFileName,"a");
        $strobe("pel_5         VDS     error limit ( %d ) reached at %7.4r  %M", maxEv, $abstime );
        $fwrite(outfile,"pel_5         VDS     error limit ( %d ) reached at %7.4r  %M\n", maxEv, $abstime );
        VDS_cnt=VDS_cnt-1;
        $fclose(outfile);
      end
   end

//      VDB
   VDB = V_D_B;
   if((VDB_cnt>0) || ( maxEv_flg==0 ))   begin
      if( (VDB < -1.98) && (VDB_retc!=-1))
      begin
        outfile=$fopen(errFileName,"a");
        $strobe("pel_5         VDB     leaving   OCA (  .. -1.980 V ) at %7.4r  %M", $abstime );
        $fwrite(outfile,"pel_5         VDB     leaving   OCA (  .. -1.980 V ) at %7.4r  %M\n", $abstime );
        VDB_retc=-1;
        VDB_cnt=VDB_cnt-1;
        $fclose(outfile);
      end
      if((VDB >= -1.98) &&  (VDB <= 0.1) && (VDB_retc!=0))
      begin
        outfile=$fopen(errFileName,"a");
        $strobe("pel_5         VDB     entering SOCA ( -1.980 V .. 0.100 V ) at %7.4r  %M", $abstime );
        $fwrite(outfile,"pel_5         VDB     entering SOCA ( -1.980 V .. 0.100 V ) at %7.4r  %M\n", $abstime );
        VDB_retc=0;
        VDB_cnt=VDB_cnt-1;
        $fclose(outfile);
      end
      if((VDB > 0.1) &&  (VDB_retc!=1))
      begin
        outfile=$fopen(errFileName,"a");
        $strobe("pel_5         VDB     leaving   OCA ( 0.100 V ..  ) at %7.4r  %M", $abstime );
        $fwrite(outfile,"pel_5         VDB     leaving   OCA ( 0.100 V ..  ) at %7.4r  %M\n", $abstime );
        VDB_retc=1;
        VDB_cnt=VDB_cnt-1;
        $fclose(outfile);
      end
   end
   else
   begin
      if(VDB_cnt==0)
      begin
        outfile=$fopen(errFileName,"a");
        $strobe("pel_5         VDB     error limit ( %d ) reached at %7.4r  %M", maxEv, $abstime );
        $fwrite(outfile,"pel_5         VDB     error limit ( %d ) reached at %7.4r  %M\n", maxEv, $abstime );
        VDB_cnt=VDB_cnt-1;
        $fclose(outfile);
      end
   end

//      VSB
   VSB = V_S_B;
   if((VSB_cnt>0) || ( maxEv_flg==0 ))   begin
      if( (VSB < -1.98) && (VSB_retc!=-1))
      begin
        outfile=$fopen(errFileName,"a");
        $strobe("pel_5         VSB     leaving   OCA (  .. -1.980 V ) at %7.4r  %M", $abstime );
        $fwrite(outfile,"pel_5         VSB     leaving   OCA (  .. -1.980 V ) at %7.4r  %M\n", $abstime );
        VSB_retc=-1;
        VSB_cnt=VSB_cnt-1;
        $fclose(outfile);
      end
      if((VSB >= -1.98) &&  (VSB <= 0.1) && (VSB_retc!=0))
      begin
        outfile=$fopen(errFileName,"a");
        $strobe("pel_5         VSB     entering SOCA ( -1.980 V .. 0.100 V ) at %7.4r  %M", $abstime );
        $fwrite(outfile,"pel_5         VSB     entering SOCA ( -1.980 V .. 0.100 V ) at %7.4r  %M\n", $abstime );
        VSB_retc=0;
        VSB_cnt=VSB_cnt-1;
        $fclose(outfile);
      end
      if((VSB > 0.1) &&  (VSB_retc!=1))
      begin
        outfile=$fopen(errFileName,"a");
        $strobe("pel_5         VSB     leaving   OCA ( 0.100 V ..  ) at %7.4r  %M", $abstime );
        $fwrite(outfile,"pel_5         VSB     leaving   OCA ( 0.100 V ..  ) at %7.4r  %M\n", $abstime );
        VSB_retc=1;
        VSB_cnt=VSB_cnt-1;
        $fclose(outfile);
      end
   end
   else
   begin
      if(VSB_cnt==0)
      begin
        outfile=$fopen(errFileName,"a");
        $strobe("pel_5         VSB     error limit ( %d ) reached at %7.4r  %M", maxEv, $abstime );
        $fwrite(outfile,"pel_5         VSB     error limit ( %d ) reached at %7.4r  %M\n", maxEv, $abstime );
        VSB_cnt=VSB_cnt-1;
        $fclose(outfile);
      end
   end

//      VBsub
   VBsub = V_B_sub;
   if((VBsub_cnt>0) || ( maxEv_flg==0 ))   begin
      if( (VBsub < -0.1) && (VBsub_retc!=-1))
      begin
        outfile=$fopen(errFileName,"a");
        $strobe("pel_5         VBsub   leaving   OCA (  .. -0.100 V ) at %7.4r  %M", $abstime );
        $fwrite(outfile,"pel_5         VBsub   leaving   OCA (  .. -0.100 V ) at %7.4r  %M\n", $abstime );
        VBsub_retc=-1;
        VBsub_cnt=VBsub_cnt-1;
        $fclose(outfile);
      end
      if((VBsub >= -0.1) &&  (VBsub <= 1.98) && (VBsub_retc!=0))
      begin
        outfile=$fopen(errFileName,"a");
        $strobe("pel_5         VBsub   entering SOCA ( -0.100 V .. 1.980 V ) at %7.4r  %M", $abstime );
        $fwrite(outfile,"pel_5         VBsub   entering SOCA ( -0.100 V .. 1.980 V ) at %7.4r  %M\n", $abstime );
        VBsub_retc=0;
        VBsub_cnt=VBsub_cnt-1;
        $fclose(outfile);
      end
      if((VBsub > 1.98) &&  (VBsub_retc!=1))
      begin
        outfile=$fopen(errFileName,"a");
        $strobe("pel_5         VBsub   leaving   OCA ( 1.980 V ..  ) at %7.4r  %M", $abstime );
        $fwrite(outfile,"pel_5         VBsub   leaving   OCA ( 1.980 V ..  ) at %7.4r  %M\n", $abstime );
        VBsub_retc=1;
        VBsub_cnt=VBsub_cnt-1;
        $fclose(outfile);
      end
   end
   else
   begin
      if(VBsub_cnt==0)
      begin
        outfile=$fopen(errFileName,"a");
        $strobe("pel_5         VBsub   error limit ( %d ) reached at %7.4r  %M", maxEv, $abstime );
        $fwrite(outfile,"pel_5         VBsub   error limit ( %d ) reached at %7.4r  %M\n", maxEv, $abstime );
        VBsub_cnt=VBsub_cnt-1;
        $fclose(outfile);
      end
   end

end // analog
endmodule // pel_5

// Verilog-A OC Watch for device pesvt_5 Parameters  VGS VGD VDS VDB VSB VBsub
module pesvt_5_ahdl(D,G,S,B,sub);
parameter tstep_occ=100n;
parameter errFileName="./occ.err";
parameter maxEv = 25;
parameter maxEv_flg = 0;
inout D,G,S,B,sub;
electrical D,G,S,B,sub;

integer outfile;
real V_B_sub;
real V_S_B;
real V_D_B;
real V_D_S;
real V_G_D;
real V_G_S;
real VGS;
integer VGS_retc;
integer VGS_cnt;
real VGD;
integer VGD_retc;
integer VGD_cnt;
real VDS;
integer VDS_retc;
integer VDS_cnt;
real VDB;
integer VDB_retc;
integer VDB_cnt;
real VSB;
integer VSB_retc;
integer VSB_cnt;
real VBsub;
integer VBsub_retc;
integer VBsub_cnt;

analog begin
   $bound_step( tstep_occ );
   @(initial_step) begin
      VGS_retc=0;
      VGS_cnt = maxEv;
      VGD_retc=0;
      VGD_cnt = maxEv;
      VDS_retc=0;
      VDS_cnt = maxEv;
      VDB_retc=0;
      VDB_cnt = maxEv;
      VSB_retc=0;
      VSB_cnt = maxEv;
      VBsub_retc=0;
      VBsub_cnt = maxEv;
   end
   V_B_sub = V(B,sub);
   V_S_B = V(S,B);
   V_D_B = V(D,B);
   V_D_S = V(D,S);
   V_G_D = V(G,D);
   V_G_S = V(G,S);

//      VGS
   VGS = V_G_S;
   if((VGS_cnt>0) || ( maxEv_flg==0 ))   begin
      if( (VGS < -1.98) && (VGS_retc!=-1))
      begin
        outfile=$fopen(errFileName,"a");
        $strobe("pesvt_5       VGS     leaving   OCA (  .. -1.980 V ) at %7.4r  %M", $abstime );
        $fwrite(outfile,"pesvt_5       VGS     leaving   OCA (  .. -1.980 V ) at %7.4r  %M\n", $abstime );
        VGS_retc=-1;
        VGS_cnt=VGS_cnt-1;
        $fclose(outfile);
      end
      if((VGS >= -1.98) &&  (VGS <= 1.98) && (VGS_retc!=0))
      begin
        outfile=$fopen(errFileName,"a");
        $strobe("pesvt_5       VGS     entering SOCA ( -1.980 V .. 1.980 V ) at %7.4r  %M", $abstime );
        $fwrite(outfile,"pesvt_5       VGS     entering SOCA ( -1.980 V .. 1.980 V ) at %7.4r  %M\n", $abstime );
        VGS_retc=0;
        VGS_cnt=VGS_cnt-1;
        $fclose(outfile);
      end
      if((VGS > 1.98) &&  (VGS_retc!=1))
      begin
        outfile=$fopen(errFileName,"a");
        $strobe("pesvt_5       VGS     leaving   OCA ( 1.980 V ..  ) at %7.4r  %M", $abstime );
        $fwrite(outfile,"pesvt_5       VGS     leaving   OCA ( 1.980 V ..  ) at %7.4r  %M\n", $abstime );
        VGS_retc=1;
        VGS_cnt=VGS_cnt-1;
        $fclose(outfile);
      end
   end
   else
   begin
      if(VGS_cnt==0)
      begin
        outfile=$fopen(errFileName,"a");
        $strobe("pesvt_5       VGS     error limit ( %d ) reached at %7.4r  %M", maxEv, $abstime );
        $fwrite(outfile,"pesvt_5       VGS     error limit ( %d ) reached at %7.4r  %M\n", maxEv, $abstime );
        VGS_cnt=VGS_cnt-1;
        $fclose(outfile);
      end
   end

//      VGD
   VGD = V_G_D;
   if((VGD_cnt>0) || ( maxEv_flg==0 ))   begin
      if( (VGD < -1.98) && (VGD_retc!=-1))
      begin
        outfile=$fopen(errFileName,"a");
        $strobe("pesvt_5       VGD     leaving   OCA (  .. -1.980 V ) at %7.4r  %M", $abstime );
        $fwrite(outfile,"pesvt_5       VGD     leaving   OCA (  .. -1.980 V ) at %7.4r  %M\n", $abstime );
        VGD_retc=-1;
        VGD_cnt=VGD_cnt-1;
        $fclose(outfile);
      end
      if((VGD >= -1.98) &&  (VGD <= 1.98) && (VGD_retc!=0))
      begin
        outfile=$fopen(errFileName,"a");
        $strobe("pesvt_5       VGD     entering SOCA ( -1.980 V .. 1.980 V ) at %7.4r  %M", $abstime );
        $fwrite(outfile,"pesvt_5       VGD     entering SOCA ( -1.980 V .. 1.980 V ) at %7.4r  %M\n", $abstime );
        VGD_retc=0;
        VGD_cnt=VGD_cnt-1;
        $fclose(outfile);
      end
      if((VGD > 1.98) &&  (VGD_retc!=1))
      begin
        outfile=$fopen(errFileName,"a");
        $strobe("pesvt_5       VGD     leaving   OCA ( 1.980 V ..  ) at %7.4r  %M", $abstime );
        $fwrite(outfile,"pesvt_5       VGD     leaving   OCA ( 1.980 V ..  ) at %7.4r  %M\n", $abstime );
        VGD_retc=1;
        VGD_cnt=VGD_cnt-1;
        $fclose(outfile);
      end
   end
   else
   begin
      if(VGD_cnt==0)
      begin
        outfile=$fopen(errFileName,"a");
        $strobe("pesvt_5       VGD     error limit ( %d ) reached at %7.4r  %M", maxEv, $abstime );
        $fwrite(outfile,"pesvt_5       VGD     error limit ( %d ) reached at %7.4r  %M\n", maxEv, $abstime );
        VGD_cnt=VGD_cnt-1;
        $fclose(outfile);
      end
   end

//      VDS
   VDS = V_D_S;
   if((VDS_cnt>0) || ( maxEv_flg==0 ))   begin
      if( (VDS < -1.98) && (VDS_retc!=-1))
      begin
        outfile=$fopen(errFileName,"a");
        $strobe("pesvt_5       VDS     leaving   OCA (  .. -1.980 V ) at %7.4r  %M", $abstime );
        $fwrite(outfile,"pesvt_5       VDS     leaving   OCA (  .. -1.980 V ) at %7.4r  %M\n", $abstime );
        VDS_retc=-1;
        VDS_cnt=VDS_cnt-1;
        $fclose(outfile);
      end
      if((VDS >= -1.98) &&  (VDS <= 1.98) && (VDS_retc!=0))
      begin
        outfile=$fopen(errFileName,"a");
        $strobe("pesvt_5       VDS     entering SOCA ( -1.980 V .. 1.980 V ) at %7.4r  %M", $abstime );
        $fwrite(outfile,"pesvt_5       VDS     entering SOCA ( -1.980 V .. 1.980 V ) at %7.4r  %M\n", $abstime );
        VDS_retc=0;
        VDS_cnt=VDS_cnt-1;
        $fclose(outfile);
      end
      if((VDS > 1.98) &&  (VDS_retc!=1))
      begin
        outfile=$fopen(errFileName,"a");
        $strobe("pesvt_5       VDS     leaving   OCA ( 1.980 V ..  ) at %7.4r  %M", $abstime );
        $fwrite(outfile,"pesvt_5       VDS     leaving   OCA ( 1.980 V ..  ) at %7.4r  %M\n", $abstime );
        VDS_retc=1;
        VDS_cnt=VDS_cnt-1;
        $fclose(outfile);
      end
   end
   else
   begin
      if(VDS_cnt==0)
      begin
        outfile=$fopen(errFileName,"a");
        $strobe("pesvt_5       VDS     error limit ( %d ) reached at %7.4r  %M", maxEv, $abstime );
        $fwrite(outfile,"pesvt_5       VDS     error limit ( %d ) reached at %7.4r  %M\n", maxEv, $abstime );
        VDS_cnt=VDS_cnt-1;
        $fclose(outfile);
      end
   end

//      VDB
   VDB = V_D_B;
   if((VDB_cnt>0) || ( maxEv_flg==0 ))   begin
      if( (VDB < -1.98) && (VDB_retc!=-1))
      begin
        outfile=$fopen(errFileName,"a");
        $strobe("pesvt_5       VDB     leaving   OCA (  .. -1.980 V ) at %7.4r  %M", $abstime );
        $fwrite(outfile,"pesvt_5       VDB     leaving   OCA (  .. -1.980 V ) at %7.4r  %M\n", $abstime );
        VDB_retc=-1;
        VDB_cnt=VDB_cnt-1;
        $fclose(outfile);
      end
      if((VDB >= -1.98) &&  (VDB <= 0.1) && (VDB_retc!=0))
      begin
        outfile=$fopen(errFileName,"a");
        $strobe("pesvt_5       VDB     entering SOCA ( -1.980 V .. 0.100 V ) at %7.4r  %M", $abstime );
        $fwrite(outfile,"pesvt_5       VDB     entering SOCA ( -1.980 V .. 0.100 V ) at %7.4r  %M\n", $abstime );
        VDB_retc=0;
        VDB_cnt=VDB_cnt-1;
        $fclose(outfile);
      end
      if((VDB > 0.1) &&  (VDB_retc!=1))
      begin
        outfile=$fopen(errFileName,"a");
        $strobe("pesvt_5       VDB     leaving   OCA ( 0.100 V ..  ) at %7.4r  %M", $abstime );
        $fwrite(outfile,"pesvt_5       VDB     leaving   OCA ( 0.100 V ..  ) at %7.4r  %M\n", $abstime );
        VDB_retc=1;
        VDB_cnt=VDB_cnt-1;
        $fclose(outfile);
      end
   end
   else
   begin
      if(VDB_cnt==0)
      begin
        outfile=$fopen(errFileName,"a");
        $strobe("pesvt_5       VDB     error limit ( %d ) reached at %7.4r  %M", maxEv, $abstime );
        $fwrite(outfile,"pesvt_5       VDB     error limit ( %d ) reached at %7.4r  %M\n", maxEv, $abstime );
        VDB_cnt=VDB_cnt-1;
        $fclose(outfile);
      end
   end

//      VSB
   VSB = V_S_B;
   if((VSB_cnt>0) || ( maxEv_flg==0 ))   begin
      if( (VSB < -1.98) && (VSB_retc!=-1))
      begin
        outfile=$fopen(errFileName,"a");
        $strobe("pesvt_5       VSB     leaving   OCA (  .. -1.980 V ) at %7.4r  %M", $abstime );
        $fwrite(outfile,"pesvt_5       VSB     leaving   OCA (  .. -1.980 V ) at %7.4r  %M\n", $abstime );
        VSB_retc=-1;
        VSB_cnt=VSB_cnt-1;
        $fclose(outfile);
      end
      if((VSB >= -1.98) &&  (VSB <= 0.1) && (VSB_retc!=0))
      begin
        outfile=$fopen(errFileName,"a");
        $strobe("pesvt_5       VSB     entering SOCA ( -1.980 V .. 0.100 V ) at %7.4r  %M", $abstime );
        $fwrite(outfile,"pesvt_5       VSB     entering SOCA ( -1.980 V .. 0.100 V ) at %7.4r  %M\n", $abstime );
        VSB_retc=0;
        VSB_cnt=VSB_cnt-1;
        $fclose(outfile);
      end
      if((VSB > 0.1) &&  (VSB_retc!=1))
      begin
        outfile=$fopen(errFileName,"a");
        $strobe("pesvt_5       VSB     leaving   OCA ( 0.100 V ..  ) at %7.4r  %M", $abstime );
        $fwrite(outfile,"pesvt_5       VSB     leaving   OCA ( 0.100 V ..  ) at %7.4r  %M\n", $abstime );
        VSB_retc=1;
        VSB_cnt=VSB_cnt-1;
        $fclose(outfile);
      end
   end
   else
   begin
      if(VSB_cnt==0)
      begin
        outfile=$fopen(errFileName,"a");
        $strobe("pesvt_5       VSB     error limit ( %d ) reached at %7.4r  %M", maxEv, $abstime );
        $fwrite(outfile,"pesvt_5       VSB     error limit ( %d ) reached at %7.4r  %M\n", maxEv, $abstime );
        VSB_cnt=VSB_cnt-1;
        $fclose(outfile);
      end
   end

//      VBsub
   VBsub = V_B_sub;
   if((VBsub_cnt>0) || ( maxEv_flg==0 ))   begin
      if( (VBsub < -0.1) && (VBsub_retc!=-1))
      begin
        outfile=$fopen(errFileName,"a");
        $strobe("pesvt_5       VBsub   leaving   OCA (  .. -0.100 V ) at %7.4r  %M", $abstime );
        $fwrite(outfile,"pesvt_5       VBsub   leaving   OCA (  .. -0.100 V ) at %7.4r  %M\n", $abstime );
        VBsub_retc=-1;
        VBsub_cnt=VBsub_cnt-1;
        $fclose(outfile);
      end
      if((VBsub >= -0.1) &&  (VBsub <= 1.98) && (VBsub_retc!=0))
      begin
        outfile=$fopen(errFileName,"a");
        $strobe("pesvt_5       VBsub   entering SOCA ( -0.100 V .. 1.980 V ) at %7.4r  %M", $abstime );
        $fwrite(outfile,"pesvt_5       VBsub   entering SOCA ( -0.100 V .. 1.980 V ) at %7.4r  %M\n", $abstime );
        VBsub_retc=0;
        VBsub_cnt=VBsub_cnt-1;
        $fclose(outfile);
      end
      if((VBsub > 1.98) &&  (VBsub_retc!=1))
      begin
        outfile=$fopen(errFileName,"a");
        $strobe("pesvt_5       VBsub   leaving   OCA ( 1.980 V ..  ) at %7.4r  %M", $abstime );
        $fwrite(outfile,"pesvt_5       VBsub   leaving   OCA ( 1.980 V ..  ) at %7.4r  %M\n", $abstime );
        VBsub_retc=1;
        VBsub_cnt=VBsub_cnt-1;
        $fclose(outfile);
      end
   end
   else
   begin
      if(VBsub_cnt==0)
      begin
        outfile=$fopen(errFileName,"a");
        $strobe("pesvt_5       VBsub   error limit ( %d ) reached at %7.4r  %M", maxEv, $abstime );
        $fwrite(outfile,"pesvt_5       VBsub   error limit ( %d ) reached at %7.4r  %M\n", maxEv, $abstime );
        VBsub_cnt=VBsub_cnt-1;
        $fclose(outfile);
      end
   end

end // analog
endmodule // pesvt_5

// Verilog-A OC Watch for device ne5 Parameters  VGS VGD VDS VDB VSB
module ne5_ahdl(D,G,S,B);
parameter tstep_occ=100n;
parameter errFileName="./occ.err";
parameter maxEv = 25;
parameter maxEv_flg = 0;
inout D,G,S,B;
electrical D,G,S,B;

integer outfile;
real V_S_B;
real V_D_B;
real V_D_S;
real V_G_D;
real V_G_S;
real VGS;
integer VGS_retc;
integer VGS_cnt;
real VGD;
integer VGD_retc;
integer VGD_cnt;
real VDS;
integer VDS_retc;
integer VDS_cnt;
real VDB;
integer VDB_retc;
integer VDB_cnt;
real VSB;
integer VSB_retc;
integer VSB_cnt;

analog begin
   $bound_step( tstep_occ );
   @(initial_step) begin
      VGS_retc=0;
      VGS_cnt = maxEv;
      VGD_retc=0;
      VGD_cnt = maxEv;
      VDS_retc=0;
      VDS_cnt = maxEv;
      VDB_retc=0;
      VDB_cnt = maxEv;
      VSB_retc=0;
      VSB_cnt = maxEv;
   end
   V_S_B = V(S,B);
   V_D_B = V(D,B);
   V_D_S = V(D,S);
   V_G_D = V(G,D);
   V_G_S = V(G,S);

//      VGS
   VGS = V_G_S;
   if((VGS_cnt>0) || ( maxEv_flg==0 ))   begin
      if( (VGS < -5.5) && (VGS_retc!=-1))
      begin
        outfile=$fopen(errFileName,"a");
        $strobe("ne5           VGS     leaving   OCA (  .. -5.500 V ) at %7.4r  %M", $abstime );
        $fwrite(outfile,"ne5           VGS     leaving   OCA (  .. -5.500 V ) at %7.4r  %M\n", $abstime );
        VGS_retc=-1;
        VGS_cnt=VGS_cnt-1;
        $fclose(outfile);
      end
      if((VGS >= -5.5) &&  (VGS <= 5.5) && (VGS_retc!=0))
      begin
        outfile=$fopen(errFileName,"a");
        $strobe("ne5           VGS     entering SOCA ( -5.500 V .. 5.500 V ) at %7.4r  %M", $abstime );
        $fwrite(outfile,"ne5           VGS     entering SOCA ( -5.500 V .. 5.500 V ) at %7.4r  %M\n", $abstime );
        VGS_retc=0;
        VGS_cnt=VGS_cnt-1;
        $fclose(outfile);
      end
      if((VGS > 5.5) &&  (VGS_retc!=1))
      begin
        outfile=$fopen(errFileName,"a");
        $strobe("ne5           VGS     leaving   OCA ( 5.500 V ..  ) at %7.4r  %M", $abstime );
        $fwrite(outfile,"ne5           VGS     leaving   OCA ( 5.500 V ..  ) at %7.4r  %M\n", $abstime );
        VGS_retc=1;
        VGS_cnt=VGS_cnt-1;
        $fclose(outfile);
      end
   end
   else
   begin
      if(VGS_cnt==0)
      begin
        outfile=$fopen(errFileName,"a");
        $strobe("ne5           VGS     error limit ( %d ) reached at %7.4r  %M", maxEv, $abstime );
        $fwrite(outfile,"ne5           VGS     error limit ( %d ) reached at %7.4r  %M\n", maxEv, $abstime );
        VGS_cnt=VGS_cnt-1;
        $fclose(outfile);
      end
   end

//      VGD
   VGD = V_G_D;
   if((VGD_cnt>0) || ( maxEv_flg==0 ))   begin
      if( (VGD < -5.5) && (VGD_retc!=-1))
      begin
        outfile=$fopen(errFileName,"a");
        $strobe("ne5           VGD     leaving   OCA (  .. -5.500 V ) at %7.4r  %M", $abstime );
        $fwrite(outfile,"ne5           VGD     leaving   OCA (  .. -5.500 V ) at %7.4r  %M\n", $abstime );
        VGD_retc=-1;
        VGD_cnt=VGD_cnt-1;
        $fclose(outfile);
      end
      if((VGD >= -5.5) &&  (VGD <= 5.5) && (VGD_retc!=0))
      begin
        outfile=$fopen(errFileName,"a");
        $strobe("ne5           VGD     entering SOCA ( -5.500 V .. 5.500 V ) at %7.4r  %M", $abstime );
        $fwrite(outfile,"ne5           VGD     entering SOCA ( -5.500 V .. 5.500 V ) at %7.4r  %M\n", $abstime );
        VGD_retc=0;
        VGD_cnt=VGD_cnt-1;
        $fclose(outfile);
      end
      if((VGD > 5.5) &&  (VGD_retc!=1))
      begin
        outfile=$fopen(errFileName,"a");
        $strobe("ne5           VGD     leaving   OCA ( 5.500 V ..  ) at %7.4r  %M", $abstime );
        $fwrite(outfile,"ne5           VGD     leaving   OCA ( 5.500 V ..  ) at %7.4r  %M\n", $abstime );
        VGD_retc=1;
        VGD_cnt=VGD_cnt-1;
        $fclose(outfile);
      end
   end
   else
   begin
      if(VGD_cnt==0)
      begin
        outfile=$fopen(errFileName,"a");
        $strobe("ne5           VGD     error limit ( %d ) reached at %7.4r  %M", maxEv, $abstime );
        $fwrite(outfile,"ne5           VGD     error limit ( %d ) reached at %7.4r  %M\n", maxEv, $abstime );
        VGD_cnt=VGD_cnt-1;
        $fclose(outfile);
      end
   end

//      VDS
   VDS = V_D_S;
   if((VDS_cnt>0) || ( maxEv_flg==0 ))   begin
      if( (VDS < -5.5) && (VDS_retc!=-1))
      begin
        outfile=$fopen(errFileName,"a");
        $strobe("ne5           VDS     leaving   OCA (  .. -5.500 V ) at %7.4r  %M", $abstime );
        $fwrite(outfile,"ne5           VDS     leaving   OCA (  .. -5.500 V ) at %7.4r  %M\n", $abstime );
        VDS_retc=-1;
        VDS_cnt=VDS_cnt-1;
        $fclose(outfile);
      end
      if((VDS >= -5.5) &&  (VDS <= 5.5) && (VDS_retc!=0))
      begin
        outfile=$fopen(errFileName,"a");
        $strobe("ne5           VDS     entering SOCA ( -5.500 V .. 5.500 V ) at %7.4r  %M", $abstime );
        $fwrite(outfile,"ne5           VDS     entering SOCA ( -5.500 V .. 5.500 V ) at %7.4r  %M\n", $abstime );
        VDS_retc=0;
        VDS_cnt=VDS_cnt-1;
        $fclose(outfile);
      end
      if((VDS > 5.5) &&  (VDS_retc!=1))
      begin
        outfile=$fopen(errFileName,"a");
        $strobe("ne5           VDS     leaving   OCA ( 5.500 V ..  ) at %7.4r  %M", $abstime );
        $fwrite(outfile,"ne5           VDS     leaving   OCA ( 5.500 V ..  ) at %7.4r  %M\n", $abstime );
        VDS_retc=1;
        VDS_cnt=VDS_cnt-1;
        $fclose(outfile);
      end
   end
   else
   begin
      if(VDS_cnt==0)
      begin
        outfile=$fopen(errFileName,"a");
        $strobe("ne5           VDS     error limit ( %d ) reached at %7.4r  %M", maxEv, $abstime );
        $fwrite(outfile,"ne5           VDS     error limit ( %d ) reached at %7.4r  %M\n", maxEv, $abstime );
        VDS_cnt=VDS_cnt-1;
        $fclose(outfile);
      end
   end

//      VDB
   VDB = V_D_B;
   if((VDB_cnt>0) || ( maxEv_flg==0 ))   begin
      if( (VDB < -0.1) && (VDB_retc!=-1))
      begin
        outfile=$fopen(errFileName,"a");
        $strobe("ne5           VDB     leaving   OCA (  .. -0.100 V ) at %7.4r  %M", $abstime );
        $fwrite(outfile,"ne5           VDB     leaving   OCA (  .. -0.100 V ) at %7.4r  %M\n", $abstime );
        VDB_retc=-1;
        VDB_cnt=VDB_cnt-1;
        $fclose(outfile);
      end
      if((VDB >= -0.1) &&  (VDB <= 5.5) && (VDB_retc!=0))
      begin
        outfile=$fopen(errFileName,"a");
        $strobe("ne5           VDB     entering SOCA ( -0.100 V .. 5.500 V ) at %7.4r  %M", $abstime );
        $fwrite(outfile,"ne5           VDB     entering SOCA ( -0.100 V .. 5.500 V ) at %7.4r  %M\n", $abstime );
        VDB_retc=0;
        VDB_cnt=VDB_cnt-1;
        $fclose(outfile);
      end
      if((VDB > 5.5) &&  (VDB_retc!=1))
      begin
        outfile=$fopen(errFileName,"a");
        $strobe("ne5           VDB     leaving   OCA ( 5.500 V ..  ) at %7.4r  %M", $abstime );
        $fwrite(outfile,"ne5           VDB     leaving   OCA ( 5.500 V ..  ) at %7.4r  %M\n", $abstime );
        VDB_retc=1;
        VDB_cnt=VDB_cnt-1;
        $fclose(outfile);
      end
   end
   else
   begin
      if(VDB_cnt==0)
      begin
        outfile=$fopen(errFileName,"a");
        $strobe("ne5           VDB     error limit ( %d ) reached at %7.4r  %M", maxEv, $abstime );
        $fwrite(outfile,"ne5           VDB     error limit ( %d ) reached at %7.4r  %M\n", maxEv, $abstime );
        VDB_cnt=VDB_cnt-1;
        $fclose(outfile);
      end
   end

//      VSB
   VSB = V_S_B;
   if((VSB_cnt>0) || ( maxEv_flg==0 ))   begin
      if( (VSB < -0.1) && (VSB_retc!=-1))
      begin
        outfile=$fopen(errFileName,"a");
        $strobe("ne5           VSB     leaving   OCA (  .. -0.100 V ) at %7.4r  %M", $abstime );
        $fwrite(outfile,"ne5           VSB     leaving   OCA (  .. -0.100 V ) at %7.4r  %M\n", $abstime );
        VSB_retc=-1;
        VSB_cnt=VSB_cnt-1;
        $fclose(outfile);
      end
      if((VSB >= -0.1) &&  (VSB <= 5.5) && (VSB_retc!=0))
      begin
        outfile=$fopen(errFileName,"a");
        $strobe("ne5           VSB     entering SOCA ( -0.100 V .. 5.500 V ) at %7.4r  %M", $abstime );
        $fwrite(outfile,"ne5           VSB     entering SOCA ( -0.100 V .. 5.500 V ) at %7.4r  %M\n", $abstime );
        VSB_retc=0;
        VSB_cnt=VSB_cnt-1;
        $fclose(outfile);
      end
      if((VSB > 5.5) &&  (VSB_retc!=1))
      begin
        outfile=$fopen(errFileName,"a");
        $strobe("ne5           VSB     leaving   OCA ( 5.500 V ..  ) at %7.4r  %M", $abstime );
        $fwrite(outfile,"ne5           VSB     leaving   OCA ( 5.500 V ..  ) at %7.4r  %M\n", $abstime );
        VSB_retc=1;
        VSB_cnt=VSB_cnt-1;
        $fclose(outfile);
      end
   end
   else
   begin
      if(VSB_cnt==0)
      begin
        outfile=$fopen(errFileName,"a");
        $strobe("ne5           VSB     error limit ( %d ) reached at %7.4r  %M", maxEv, $abstime );
        $fwrite(outfile,"ne5           VSB     error limit ( %d ) reached at %7.4r  %M\n", maxEv, $abstime );
        VSB_cnt=VSB_cnt-1;
        $fclose(outfile);
      end
   end

end // analog
endmodule // ne5

// Verilog-A OC Watch for device nn5 Parameters  VGS VGD VDS VDB VSB
module nn5_ahdl(D,G,S,B);
parameter tstep_occ=100n;
parameter errFileName="./occ.err";
parameter maxEv = 25;
parameter maxEv_flg = 0;
inout D,G,S,B;
electrical D,G,S,B;

integer outfile;
real V_S_B;
real V_D_B;
real V_D_S;
real V_G_D;
real V_G_S;
real VGS;
integer VGS_retc;
integer VGS_cnt;
real VGD;
integer VGD_retc;
integer VGD_cnt;
real VDS;
integer VDS_retc;
integer VDS_cnt;
real VDB;
integer VDB_retc;
integer VDB_cnt;
real VSB;
integer VSB_retc;
integer VSB_cnt;

analog begin
   $bound_step( tstep_occ );
   @(initial_step) begin
      VGS_retc=0;
      VGS_cnt = maxEv;
      VGD_retc=0;
      VGD_cnt = maxEv;
      VDS_retc=0;
      VDS_cnt = maxEv;
      VDB_retc=0;
      VDB_cnt = maxEv;
      VSB_retc=0;
      VSB_cnt = maxEv;
   end
   V_S_B = V(S,B);
   V_D_B = V(D,B);
   V_D_S = V(D,S);
   V_G_D = V(G,D);
   V_G_S = V(G,S);

//      VGS
   VGS = V_G_S;
   if((VGS_cnt>0) || ( maxEv_flg==0 ))   begin
      if( (VGS < -5.5) && (VGS_retc!=-1))
      begin
        outfile=$fopen(errFileName,"a");
        $strobe("nn5           VGS     leaving   OCA (  .. -5.500 V ) at %7.4r  %M", $abstime );
        $fwrite(outfile,"nn5           VGS     leaving   OCA (  .. -5.500 V ) at %7.4r  %M\n", $abstime );
        VGS_retc=-1;
        VGS_cnt=VGS_cnt-1;
        $fclose(outfile);
      end
      if((VGS >= -5.5) &&  (VGS <= 5.5) && (VGS_retc!=0))
      begin
        outfile=$fopen(errFileName,"a");
        $strobe("nn5           VGS     entering SOCA ( -5.500 V .. 5.500 V ) at %7.4r  %M", $abstime );
        $fwrite(outfile,"nn5           VGS     entering SOCA ( -5.500 V .. 5.500 V ) at %7.4r  %M\n", $abstime );
        VGS_retc=0;
        VGS_cnt=VGS_cnt-1;
        $fclose(outfile);
      end
      if((VGS > 5.5) &&  (VGS_retc!=1))
      begin
        outfile=$fopen(errFileName,"a");
        $strobe("nn5           VGS     leaving   OCA ( 5.500 V ..  ) at %7.4r  %M", $abstime );
        $fwrite(outfile,"nn5           VGS     leaving   OCA ( 5.500 V ..  ) at %7.4r  %M\n", $abstime );
        VGS_retc=1;
        VGS_cnt=VGS_cnt-1;
        $fclose(outfile);
      end
   end
   else
   begin
      if(VGS_cnt==0)
      begin
        outfile=$fopen(errFileName,"a");
        $strobe("nn5           VGS     error limit ( %d ) reached at %7.4r  %M", maxEv, $abstime );
        $fwrite(outfile,"nn5           VGS     error limit ( %d ) reached at %7.4r  %M\n", maxEv, $abstime );
        VGS_cnt=VGS_cnt-1;
        $fclose(outfile);
      end
   end

//      VGD
   VGD = V_G_D;
   if((VGD_cnt>0) || ( maxEv_flg==0 ))   begin
      if( (VGD < -5.5) && (VGD_retc!=-1))
      begin
        outfile=$fopen(errFileName,"a");
        $strobe("nn5           VGD     leaving   OCA (  .. -5.500 V ) at %7.4r  %M", $abstime );
        $fwrite(outfile,"nn5           VGD     leaving   OCA (  .. -5.500 V ) at %7.4r  %M\n", $abstime );
        VGD_retc=-1;
        VGD_cnt=VGD_cnt-1;
        $fclose(outfile);
      end
      if((VGD >= -5.5) &&  (VGD <= 5.5) && (VGD_retc!=0))
      begin
        outfile=$fopen(errFileName,"a");
        $strobe("nn5           VGD     entering SOCA ( -5.500 V .. 5.500 V ) at %7.4r  %M", $abstime );
        $fwrite(outfile,"nn5           VGD     entering SOCA ( -5.500 V .. 5.500 V ) at %7.4r  %M\n", $abstime );
        VGD_retc=0;
        VGD_cnt=VGD_cnt-1;
        $fclose(outfile);
      end
      if((VGD > 5.5) &&  (VGD_retc!=1))
      begin
        outfile=$fopen(errFileName,"a");
        $strobe("nn5           VGD     leaving   OCA ( 5.500 V ..  ) at %7.4r  %M", $abstime );
        $fwrite(outfile,"nn5           VGD     leaving   OCA ( 5.500 V ..  ) at %7.4r  %M\n", $abstime );
        VGD_retc=1;
        VGD_cnt=VGD_cnt-1;
        $fclose(outfile);
      end
   end
   else
   begin
      if(VGD_cnt==0)
      begin
        outfile=$fopen(errFileName,"a");
        $strobe("nn5           VGD     error limit ( %d ) reached at %7.4r  %M", maxEv, $abstime );
        $fwrite(outfile,"nn5           VGD     error limit ( %d ) reached at %7.4r  %M\n", maxEv, $abstime );
        VGD_cnt=VGD_cnt-1;
        $fclose(outfile);
      end
   end

//      VDS
   VDS = V_D_S;
   if((VDS_cnt>0) || ( maxEv_flg==0 ))   begin
      if( (VDS < -5.5) && (VDS_retc!=-1))
      begin
        outfile=$fopen(errFileName,"a");
        $strobe("nn5           VDS     leaving   OCA (  .. -5.500 V ) at %7.4r  %M", $abstime );
        $fwrite(outfile,"nn5           VDS     leaving   OCA (  .. -5.500 V ) at %7.4r  %M\n", $abstime );
        VDS_retc=-1;
        VDS_cnt=VDS_cnt-1;
        $fclose(outfile);
      end
      if((VDS >= -5.5) &&  (VDS <= 5.5) && (VDS_retc!=0))
      begin
        outfile=$fopen(errFileName,"a");
        $strobe("nn5           VDS     entering SOCA ( -5.500 V .. 5.500 V ) at %7.4r  %M", $abstime );
        $fwrite(outfile,"nn5           VDS     entering SOCA ( -5.500 V .. 5.500 V ) at %7.4r  %M\n", $abstime );
        VDS_retc=0;
        VDS_cnt=VDS_cnt-1;
        $fclose(outfile);
      end
      if((VDS > 5.5) &&  (VDS_retc!=1))
      begin
        outfile=$fopen(errFileName,"a");
        $strobe("nn5           VDS     leaving   OCA ( 5.500 V ..  ) at %7.4r  %M", $abstime );
        $fwrite(outfile,"nn5           VDS     leaving   OCA ( 5.500 V ..  ) at %7.4r  %M\n", $abstime );
        VDS_retc=1;
        VDS_cnt=VDS_cnt-1;
        $fclose(outfile);
      end
   end
   else
   begin
      if(VDS_cnt==0)
      begin
        outfile=$fopen(errFileName,"a");
        $strobe("nn5           VDS     error limit ( %d ) reached at %7.4r  %M", maxEv, $abstime );
        $fwrite(outfile,"nn5           VDS     error limit ( %d ) reached at %7.4r  %M\n", maxEv, $abstime );
        VDS_cnt=VDS_cnt-1;
        $fclose(outfile);
      end
   end

//      VDB
   VDB = V_D_B;
   if((VDB_cnt>0) || ( maxEv_flg==0 ))   begin
      if( (VDB < -0.1) && (VDB_retc!=-1))
      begin
        outfile=$fopen(errFileName,"a");
        $strobe("nn5           VDB     leaving   OCA (  .. -0.100 V ) at %7.4r  %M", $abstime );
        $fwrite(outfile,"nn5           VDB     leaving   OCA (  .. -0.100 V ) at %7.4r  %M\n", $abstime );
        VDB_retc=-1;
        VDB_cnt=VDB_cnt-1;
        $fclose(outfile);
      end
      if((VDB >= -0.1) &&  (VDB <= 5.5) && (VDB_retc!=0))
      begin
        outfile=$fopen(errFileName,"a");
        $strobe("nn5           VDB     entering SOCA ( -0.100 V .. 5.500 V ) at %7.4r  %M", $abstime );
        $fwrite(outfile,"nn5           VDB     entering SOCA ( -0.100 V .. 5.500 V ) at %7.4r  %M\n", $abstime );
        VDB_retc=0;
        VDB_cnt=VDB_cnt-1;
        $fclose(outfile);
      end
      if((VDB > 5.5) &&  (VDB_retc!=1))
      begin
        outfile=$fopen(errFileName,"a");
        $strobe("nn5           VDB     leaving   OCA ( 5.500 V ..  ) at %7.4r  %M", $abstime );
        $fwrite(outfile,"nn5           VDB     leaving   OCA ( 5.500 V ..  ) at %7.4r  %M\n", $abstime );
        VDB_retc=1;
        VDB_cnt=VDB_cnt-1;
        $fclose(outfile);
      end
   end
   else
   begin
      if(VDB_cnt==0)
      begin
        outfile=$fopen(errFileName,"a");
        $strobe("nn5           VDB     error limit ( %d ) reached at %7.4r  %M", maxEv, $abstime );
        $fwrite(outfile,"nn5           VDB     error limit ( %d ) reached at %7.4r  %M\n", maxEv, $abstime );
        VDB_cnt=VDB_cnt-1;
        $fclose(outfile);
      end
   end

//      VSB
   VSB = V_S_B;
   if((VSB_cnt>0) || ( maxEv_flg==0 ))   begin
      if( (VSB < -0.1) && (VSB_retc!=-1))
      begin
        outfile=$fopen(errFileName,"a");
        $strobe("nn5           VSB     leaving   OCA (  .. -0.100 V ) at %7.4r  %M", $abstime );
        $fwrite(outfile,"nn5           VSB     leaving   OCA (  .. -0.100 V ) at %7.4r  %M\n", $abstime );
        VSB_retc=-1;
        VSB_cnt=VSB_cnt-1;
        $fclose(outfile);
      end
      if((VSB >= -0.1) &&  (VSB <= 5.5) && (VSB_retc!=0))
      begin
        outfile=$fopen(errFileName,"a");
        $strobe("nn5           VSB     entering SOCA ( -0.100 V .. 5.500 V ) at %7.4r  %M", $abstime );
        $fwrite(outfile,"nn5           VSB     entering SOCA ( -0.100 V .. 5.500 V ) at %7.4r  %M\n", $abstime );
        VSB_retc=0;
        VSB_cnt=VSB_cnt-1;
        $fclose(outfile);
      end
      if((VSB > 5.5) &&  (VSB_retc!=1))
      begin
        outfile=$fopen(errFileName,"a");
        $strobe("nn5           VSB     leaving   OCA ( 5.500 V ..  ) at %7.4r  %M", $abstime );
        $fwrite(outfile,"nn5           VSB     leaving   OCA ( 5.500 V ..  ) at %7.4r  %M\n", $abstime );
        VSB_retc=1;
        VSB_cnt=VSB_cnt-1;
        $fclose(outfile);
      end
   end
   else
   begin
      if(VSB_cnt==0)
      begin
        outfile=$fopen(errFileName,"a");
        $strobe("nn5           VSB     error limit ( %d ) reached at %7.4r  %M", maxEv, $abstime );
        $fwrite(outfile,"nn5           VSB     error limit ( %d ) reached at %7.4r  %M\n", maxEv, $abstime );
        VSB_cnt=VSB_cnt-1;
        $fclose(outfile);
      end
   end

end // analog
endmodule // nn5

// Verilog-A OC Watch for device nd5 Parameters  VGS VGD VDS VDB VSB
module nd5_ahdl(D,G,S,B);
parameter tstep_occ=100n;
parameter errFileName="./occ.err";
parameter maxEv = 25;
parameter maxEv_flg = 0;
inout D,G,S,B;
electrical D,G,S,B;

integer outfile;
real V_S_B;
real V_D_B;
real V_D_S;
real V_G_D;
real V_G_S;
real VGS;
integer VGS_retc;
integer VGS_cnt;
real VGD;
integer VGD_retc;
integer VGD_cnt;
real VDS;
integer VDS_retc;
integer VDS_cnt;
real VDB;
integer VDB_retc;
integer VDB_cnt;
real VSB;
integer VSB_retc;
integer VSB_cnt;

analog begin
   $bound_step( tstep_occ );
   @(initial_step) begin
      VGS_retc=0;
      VGS_cnt = maxEv;
      VGD_retc=0;
      VGD_cnt = maxEv;
      VDS_retc=0;
      VDS_cnt = maxEv;
      VDB_retc=0;
      VDB_cnt = maxEv;
      VSB_retc=0;
      VSB_cnt = maxEv;
   end
   V_S_B = V(S,B);
   V_D_B = V(D,B);
   V_D_S = V(D,S);
   V_G_D = V(G,D);
   V_G_S = V(G,S);

//      VGS
   VGS = V_G_S;
   if((VGS_cnt>0) || ( maxEv_flg==0 ))   begin
      if( (VGS < -5.5) && (VGS_retc!=-1))
      begin
        outfile=$fopen(errFileName,"a");
        $strobe("nd5           VGS     leaving   OCA (  .. -5.500 V ) at %7.4r  %M", $abstime );
        $fwrite(outfile,"nd5           VGS     leaving   OCA (  .. -5.500 V ) at %7.4r  %M\n", $abstime );
        VGS_retc=-1;
        VGS_cnt=VGS_cnt-1;
        $fclose(outfile);
      end
      if((VGS >= -5.5) &&  (VGS <= 5.5) && (VGS_retc!=0))
      begin
        outfile=$fopen(errFileName,"a");
        $strobe("nd5           VGS     entering SOCA ( -5.500 V .. 5.500 V ) at %7.4r  %M", $abstime );
        $fwrite(outfile,"nd5           VGS     entering SOCA ( -5.500 V .. 5.500 V ) at %7.4r  %M\n", $abstime );
        VGS_retc=0;
        VGS_cnt=VGS_cnt-1;
        $fclose(outfile);
      end
      if((VGS > 5.5) &&  (VGS_retc!=1))
      begin
        outfile=$fopen(errFileName,"a");
        $strobe("nd5           VGS     leaving   OCA ( 5.500 V ..  ) at %7.4r  %M", $abstime );
        $fwrite(outfile,"nd5           VGS     leaving   OCA ( 5.500 V ..  ) at %7.4r  %M\n", $abstime );
        VGS_retc=1;
        VGS_cnt=VGS_cnt-1;
        $fclose(outfile);
      end
   end
   else
   begin
      if(VGS_cnt==0)
      begin
        outfile=$fopen(errFileName,"a");
        $strobe("nd5           VGS     error limit ( %d ) reached at %7.4r  %M", maxEv, $abstime );
        $fwrite(outfile,"nd5           VGS     error limit ( %d ) reached at %7.4r  %M\n", maxEv, $abstime );
        VGS_cnt=VGS_cnt-1;
        $fclose(outfile);
      end
   end

//      VGD
   VGD = V_G_D;
   if((VGD_cnt>0) || ( maxEv_flg==0 ))   begin
      if( (VGD < -5.5) && (VGD_retc!=-1))
      begin
        outfile=$fopen(errFileName,"a");
        $strobe("nd5           VGD     leaving   OCA (  .. -5.500 V ) at %7.4r  %M", $abstime );
        $fwrite(outfile,"nd5           VGD     leaving   OCA (  .. -5.500 V ) at %7.4r  %M\n", $abstime );
        VGD_retc=-1;
        VGD_cnt=VGD_cnt-1;
        $fclose(outfile);
      end
      if((VGD >= -5.5) &&  (VGD <= 5.5) && (VGD_retc!=0))
      begin
        outfile=$fopen(errFileName,"a");
        $strobe("nd5           VGD     entering SOCA ( -5.500 V .. 5.500 V ) at %7.4r  %M", $abstime );
        $fwrite(outfile,"nd5           VGD     entering SOCA ( -5.500 V .. 5.500 V ) at %7.4r  %M\n", $abstime );
        VGD_retc=0;
        VGD_cnt=VGD_cnt-1;
        $fclose(outfile);
      end
      if((VGD > 5.5) &&  (VGD_retc!=1))
      begin
        outfile=$fopen(errFileName,"a");
        $strobe("nd5           VGD     leaving   OCA ( 5.500 V ..  ) at %7.4r  %M", $abstime );
        $fwrite(outfile,"nd5           VGD     leaving   OCA ( 5.500 V ..  ) at %7.4r  %M\n", $abstime );
        VGD_retc=1;
        VGD_cnt=VGD_cnt-1;
        $fclose(outfile);
      end
   end
   else
   begin
      if(VGD_cnt==0)
      begin
        outfile=$fopen(errFileName,"a");
        $strobe("nd5           VGD     error limit ( %d ) reached at %7.4r  %M", maxEv, $abstime );
        $fwrite(outfile,"nd5           VGD     error limit ( %d ) reached at %7.4r  %M\n", maxEv, $abstime );
        VGD_cnt=VGD_cnt-1;
        $fclose(outfile);
      end
   end

//      VDS
   VDS = V_D_S;
   if((VDS_cnt>0) || ( maxEv_flg==0 ))   begin
      if( (VDS < -5.5) && (VDS_retc!=-1))
      begin
        outfile=$fopen(errFileName,"a");
        $strobe("nd5           VDS     leaving   OCA (  .. -5.500 V ) at %7.4r  %M", $abstime );
        $fwrite(outfile,"nd5           VDS     leaving   OCA (  .. -5.500 V ) at %7.4r  %M\n", $abstime );
        VDS_retc=-1;
        VDS_cnt=VDS_cnt-1;
        $fclose(outfile);
      end
      if((VDS >= -5.5) &&  (VDS <= 5.5) && (VDS_retc!=0))
      begin
        outfile=$fopen(errFileName,"a");
        $strobe("nd5           VDS     entering SOCA ( -5.500 V .. 5.500 V ) at %7.4r  %M", $abstime );
        $fwrite(outfile,"nd5           VDS     entering SOCA ( -5.500 V .. 5.500 V ) at %7.4r  %M\n", $abstime );
        VDS_retc=0;
        VDS_cnt=VDS_cnt-1;
        $fclose(outfile);
      end
      if((VDS > 5.5) &&  (VDS_retc!=1))
      begin
        outfile=$fopen(errFileName,"a");
        $strobe("nd5           VDS     leaving   OCA ( 5.500 V ..  ) at %7.4r  %M", $abstime );
        $fwrite(outfile,"nd5           VDS     leaving   OCA ( 5.500 V ..  ) at %7.4r  %M\n", $abstime );
        VDS_retc=1;
        VDS_cnt=VDS_cnt-1;
        $fclose(outfile);
      end
   end
   else
   begin
      if(VDS_cnt==0)
      begin
        outfile=$fopen(errFileName,"a");
        $strobe("nd5           VDS     error limit ( %d ) reached at %7.4r  %M", maxEv, $abstime );
        $fwrite(outfile,"nd5           VDS     error limit ( %d ) reached at %7.4r  %M\n", maxEv, $abstime );
        VDS_cnt=VDS_cnt-1;
        $fclose(outfile);
      end
   end

//      VDB
   VDB = V_D_B;
   if((VDB_cnt>0) || ( maxEv_flg==0 ))   begin
      if( (VDB < -0.1) && (VDB_retc!=-1))
      begin
        outfile=$fopen(errFileName,"a");
        $strobe("nd5           VDB     leaving   OCA (  .. -0.100 V ) at %7.4r  %M", $abstime );
        $fwrite(outfile,"nd5           VDB     leaving   OCA (  .. -0.100 V ) at %7.4r  %M\n", $abstime );
        VDB_retc=-1;
        VDB_cnt=VDB_cnt-1;
        $fclose(outfile);
      end
      if((VDB >= -0.1) &&  (VDB <= 5.5) && (VDB_retc!=0))
      begin
        outfile=$fopen(errFileName,"a");
        $strobe("nd5           VDB     entering SOCA ( -0.100 V .. 5.500 V ) at %7.4r  %M", $abstime );
        $fwrite(outfile,"nd5           VDB     entering SOCA ( -0.100 V .. 5.500 V ) at %7.4r  %M\n", $abstime );
        VDB_retc=0;
        VDB_cnt=VDB_cnt-1;
        $fclose(outfile);
      end
      if((VDB > 5.5) &&  (VDB_retc!=1))
      begin
        outfile=$fopen(errFileName,"a");
        $strobe("nd5           VDB     leaving   OCA ( 5.500 V ..  ) at %7.4r  %M", $abstime );
        $fwrite(outfile,"nd5           VDB     leaving   OCA ( 5.500 V ..  ) at %7.4r  %M\n", $abstime );
        VDB_retc=1;
        VDB_cnt=VDB_cnt-1;
        $fclose(outfile);
      end
   end
   else
   begin
      if(VDB_cnt==0)
      begin
        outfile=$fopen(errFileName,"a");
        $strobe("nd5           VDB     error limit ( %d ) reached at %7.4r  %M", maxEv, $abstime );
        $fwrite(outfile,"nd5           VDB     error limit ( %d ) reached at %7.4r  %M\n", maxEv, $abstime );
        VDB_cnt=VDB_cnt-1;
        $fclose(outfile);
      end
   end

//      VSB
   VSB = V_S_B;
   if((VSB_cnt>0) || ( maxEv_flg==0 ))   begin
      if( (VSB < -0.1) && (VSB_retc!=-1))
      begin
        outfile=$fopen(errFileName,"a");
        $strobe("nd5           VSB     leaving   OCA (  .. -0.100 V ) at %7.4r  %M", $abstime );
        $fwrite(outfile,"nd5           VSB     leaving   OCA (  .. -0.100 V ) at %7.4r  %M\n", $abstime );
        VSB_retc=-1;
        VSB_cnt=VSB_cnt-1;
        $fclose(outfile);
      end
      if((VSB >= -0.1) &&  (VSB <= 5.5) && (VSB_retc!=0))
      begin
        outfile=$fopen(errFileName,"a");
        $strobe("nd5           VSB     entering SOCA ( -0.100 V .. 5.500 V ) at %7.4r  %M", $abstime );
        $fwrite(outfile,"nd5           VSB     entering SOCA ( -0.100 V .. 5.500 V ) at %7.4r  %M\n", $abstime );
        VSB_retc=0;
        VSB_cnt=VSB_cnt-1;
        $fclose(outfile);
      end
      if((VSB > 5.5) &&  (VSB_retc!=1))
      begin
        outfile=$fopen(errFileName,"a");
        $strobe("nd5           VSB     leaving   OCA ( 5.500 V ..  ) at %7.4r  %M", $abstime );
        $fwrite(outfile,"nd5           VSB     leaving   OCA ( 5.500 V ..  ) at %7.4r  %M\n", $abstime );
        VSB_retc=1;
        VSB_cnt=VSB_cnt-1;
        $fclose(outfile);
      end
   end
   else
   begin
      if(VSB_cnt==0)
      begin
        outfile=$fopen(errFileName,"a");
        $strobe("nd5           VSB     error limit ( %d ) reached at %7.4r  %M", maxEv, $abstime );
        $fwrite(outfile,"nd5           VSB     error limit ( %d ) reached at %7.4r  %M\n", maxEv, $abstime );
        VSB_cnt=VSB_cnt-1;
        $fclose(outfile);
      end
   end

end // analog
endmodule // nd5

// Verilog-A OC Watch for device pe5 Parameters  VGS VGD VDS VDB VSB
module pe5_ahdl(D,G,S,B);
parameter tstep_occ=100n;
parameter errFileName="./occ.err";
parameter maxEv = 25;
parameter maxEv_flg = 0;
inout D,G,S,B;
electrical D,G,S,B;

integer outfile;
real V_S_B;
real V_D_B;
real V_D_S;
real V_G_D;
real V_G_S;
real VGS;
integer VGS_retc;
integer VGS_cnt;
real VGD;
integer VGD_retc;
integer VGD_cnt;
real VDS;
integer VDS_retc;
integer VDS_cnt;
real VDB;
integer VDB_retc;
integer VDB_cnt;
real VSB;
integer VSB_retc;
integer VSB_cnt;

analog begin
   $bound_step( tstep_occ );
   @(initial_step) begin
      VGS_retc=0;
      VGS_cnt = maxEv;
      VGD_retc=0;
      VGD_cnt = maxEv;
      VDS_retc=0;
      VDS_cnt = maxEv;
      VDB_retc=0;
      VDB_cnt = maxEv;
      VSB_retc=0;
      VSB_cnt = maxEv;
   end
   V_S_B = V(S,B);
   V_D_B = V(D,B);
   V_D_S = V(D,S);
   V_G_D = V(G,D);
   V_G_S = V(G,S);

//      VGS
   VGS = V_G_S;
   if((VGS_cnt>0) || ( maxEv_flg==0 ))   begin
      if( (VGS < -5.5) && (VGS_retc!=-1))
      begin
        outfile=$fopen(errFileName,"a");
        $strobe("pe5           VGS     leaving   OCA (  .. -5.500 V ) at %7.4r  %M", $abstime );
        $fwrite(outfile,"pe5           VGS     leaving   OCA (  .. -5.500 V ) at %7.4r  %M\n", $abstime );
        VGS_retc=-1;
        VGS_cnt=VGS_cnt-1;
        $fclose(outfile);
      end
      if((VGS >= -5.5) &&  (VGS <= 5.5) && (VGS_retc!=0))
      begin
        outfile=$fopen(errFileName,"a");
        $strobe("pe5           VGS     entering SOCA ( -5.500 V .. 5.500 V ) at %7.4r  %M", $abstime );
        $fwrite(outfile,"pe5           VGS     entering SOCA ( -5.500 V .. 5.500 V ) at %7.4r  %M\n", $abstime );
        VGS_retc=0;
        VGS_cnt=VGS_cnt-1;
        $fclose(outfile);
      end
      if((VGS > 5.5) &&  (VGS_retc!=1))
      begin
        outfile=$fopen(errFileName,"a");
        $strobe("pe5           VGS     leaving   OCA ( 5.500 V ..  ) at %7.4r  %M", $abstime );
        $fwrite(outfile,"pe5           VGS     leaving   OCA ( 5.500 V ..  ) at %7.4r  %M\n", $abstime );
        VGS_retc=1;
        VGS_cnt=VGS_cnt-1;
        $fclose(outfile);
      end
   end
   else
   begin
      if(VGS_cnt==0)
      begin
        outfile=$fopen(errFileName,"a");
        $strobe("pe5           VGS     error limit ( %d ) reached at %7.4r  %M", maxEv, $abstime );
        $fwrite(outfile,"pe5           VGS     error limit ( %d ) reached at %7.4r  %M\n", maxEv, $abstime );
        VGS_cnt=VGS_cnt-1;
        $fclose(outfile);
      end
   end

//      VGD
   VGD = V_G_D;
   if((VGD_cnt>0) || ( maxEv_flg==0 ))   begin
      if( (VGD < -5.5) && (VGD_retc!=-1))
      begin
        outfile=$fopen(errFileName,"a");
        $strobe("pe5           VGD     leaving   OCA (  .. -5.500 V ) at %7.4r  %M", $abstime );
        $fwrite(outfile,"pe5           VGD     leaving   OCA (  .. -5.500 V ) at %7.4r  %M\n", $abstime );
        VGD_retc=-1;
        VGD_cnt=VGD_cnt-1;
        $fclose(outfile);
      end
      if((VGD >= -5.5) &&  (VGD <= 5.5) && (VGD_retc!=0))
      begin
        outfile=$fopen(errFileName,"a");
        $strobe("pe5           VGD     entering SOCA ( -5.500 V .. 5.500 V ) at %7.4r  %M", $abstime );
        $fwrite(outfile,"pe5           VGD     entering SOCA ( -5.500 V .. 5.500 V ) at %7.4r  %M\n", $abstime );
        VGD_retc=0;
        VGD_cnt=VGD_cnt-1;
        $fclose(outfile);
      end
      if((VGD > 5.5) &&  (VGD_retc!=1))
      begin
        outfile=$fopen(errFileName,"a");
        $strobe("pe5           VGD     leaving   OCA ( 5.500 V ..  ) at %7.4r  %M", $abstime );
        $fwrite(outfile,"pe5           VGD     leaving   OCA ( 5.500 V ..  ) at %7.4r  %M\n", $abstime );
        VGD_retc=1;
        VGD_cnt=VGD_cnt-1;
        $fclose(outfile);
      end
   end
   else
   begin
      if(VGD_cnt==0)
      begin
        outfile=$fopen(errFileName,"a");
        $strobe("pe5           VGD     error limit ( %d ) reached at %7.4r  %M", maxEv, $abstime );
        $fwrite(outfile,"pe5           VGD     error limit ( %d ) reached at %7.4r  %M\n", maxEv, $abstime );
        VGD_cnt=VGD_cnt-1;
        $fclose(outfile);
      end
   end

//      VDS
   VDS = V_D_S;
   if((VDS_cnt>0) || ( maxEv_flg==0 ))   begin
      if( (VDS < -5.5) && (VDS_retc!=-1))
      begin
        outfile=$fopen(errFileName,"a");
        $strobe("pe5           VDS     leaving   OCA (  .. -5.500 V ) at %7.4r  %M", $abstime );
        $fwrite(outfile,"pe5           VDS     leaving   OCA (  .. -5.500 V ) at %7.4r  %M\n", $abstime );
        VDS_retc=-1;
        VDS_cnt=VDS_cnt-1;
        $fclose(outfile);
      end
      if((VDS >= -5.5) &&  (VDS <= 5.5) && (VDS_retc!=0))
      begin
        outfile=$fopen(errFileName,"a");
        $strobe("pe5           VDS     entering SOCA ( -5.500 V .. 5.500 V ) at %7.4r  %M", $abstime );
        $fwrite(outfile,"pe5           VDS     entering SOCA ( -5.500 V .. 5.500 V ) at %7.4r  %M\n", $abstime );
        VDS_retc=0;
        VDS_cnt=VDS_cnt-1;
        $fclose(outfile);
      end
      if((VDS > 5.5) &&  (VDS_retc!=1))
      begin
        outfile=$fopen(errFileName,"a");
        $strobe("pe5           VDS     leaving   OCA ( 5.500 V ..  ) at %7.4r  %M", $abstime );
        $fwrite(outfile,"pe5           VDS     leaving   OCA ( 5.500 V ..  ) at %7.4r  %M\n", $abstime );
        VDS_retc=1;
        VDS_cnt=VDS_cnt-1;
        $fclose(outfile);
      end
   end
   else
   begin
      if(VDS_cnt==0)
      begin
        outfile=$fopen(errFileName,"a");
        $strobe("pe5           VDS     error limit ( %d ) reached at %7.4r  %M", maxEv, $abstime );
        $fwrite(outfile,"pe5           VDS     error limit ( %d ) reached at %7.4r  %M\n", maxEv, $abstime );
        VDS_cnt=VDS_cnt-1;
        $fclose(outfile);
      end
   end

//      VDB
   VDB = V_D_B;
   if((VDB_cnt>0) || ( maxEv_flg==0 ))   begin
      if( (VDB < -5.5) && (VDB_retc!=-1))
      begin
        outfile=$fopen(errFileName,"a");
        $strobe("pe5           VDB     leaving   OCA (  .. -5.500 V ) at %7.4r  %M", $abstime );
        $fwrite(outfile,"pe5           VDB     leaving   OCA (  .. -5.500 V ) at %7.4r  %M\n", $abstime );
        VDB_retc=-1;
        VDB_cnt=VDB_cnt-1;
        $fclose(outfile);
      end
      if((VDB >= -5.5) &&  (VDB <= 0.1) && (VDB_retc!=0))
      begin
        outfile=$fopen(errFileName,"a");
        $strobe("pe5           VDB     entering SOCA ( -5.500 V .. 0.100 V ) at %7.4r  %M", $abstime );
        $fwrite(outfile,"pe5           VDB     entering SOCA ( -5.500 V .. 0.100 V ) at %7.4r  %M\n", $abstime );
        VDB_retc=0;
        VDB_cnt=VDB_cnt-1;
        $fclose(outfile);
      end
      if((VDB > 0.1) &&  (VDB_retc!=1))
      begin
        outfile=$fopen(errFileName,"a");
        $strobe("pe5           VDB     leaving   OCA ( 0.100 V ..  ) at %7.4r  %M", $abstime );
        $fwrite(outfile,"pe5           VDB     leaving   OCA ( 0.100 V ..  ) at %7.4r  %M\n", $abstime );
        VDB_retc=1;
        VDB_cnt=VDB_cnt-1;
        $fclose(outfile);
      end
   end
   else
   begin
      if(VDB_cnt==0)
      begin
        outfile=$fopen(errFileName,"a");
        $strobe("pe5           VDB     error limit ( %d ) reached at %7.4r  %M", maxEv, $abstime );
        $fwrite(outfile,"pe5           VDB     error limit ( %d ) reached at %7.4r  %M\n", maxEv, $abstime );
        VDB_cnt=VDB_cnt-1;
        $fclose(outfile);
      end
   end

//      VSB
   VSB = V_S_B;
   if((VSB_cnt>0) || ( maxEv_flg==0 ))   begin
      if( (VSB < -5.5) && (VSB_retc!=-1))
      begin
        outfile=$fopen(errFileName,"a");
        $strobe("pe5           VSB     leaving   OCA (  .. -5.500 V ) at %7.4r  %M", $abstime );
        $fwrite(outfile,"pe5           VSB     leaving   OCA (  .. -5.500 V ) at %7.4r  %M\n", $abstime );
        VSB_retc=-1;
        VSB_cnt=VSB_cnt-1;
        $fclose(outfile);
      end
      if((VSB >= -5.5) &&  (VSB <= 0.1) && (VSB_retc!=0))
      begin
        outfile=$fopen(errFileName,"a");
        $strobe("pe5           VSB     entering SOCA ( -5.500 V .. 0.100 V ) at %7.4r  %M", $abstime );
        $fwrite(outfile,"pe5           VSB     entering SOCA ( -5.500 V .. 0.100 V ) at %7.4r  %M\n", $abstime );
        VSB_retc=0;
        VSB_cnt=VSB_cnt-1;
        $fclose(outfile);
      end
      if((VSB > 0.1) &&  (VSB_retc!=1))
      begin
        outfile=$fopen(errFileName,"a");
        $strobe("pe5           VSB     leaving   OCA ( 0.100 V ..  ) at %7.4r  %M", $abstime );
        $fwrite(outfile,"pe5           VSB     leaving   OCA ( 0.100 V ..  ) at %7.4r  %M\n", $abstime );
        VSB_retc=1;
        VSB_cnt=VSB_cnt-1;
        $fclose(outfile);
      end
   end
   else
   begin
      if(VSB_cnt==0)
      begin
        outfile=$fopen(errFileName,"a");
        $strobe("pe5           VSB     error limit ( %d ) reached at %7.4r  %M", maxEv, $abstime );
        $fwrite(outfile,"pe5           VSB     error limit ( %d ) reached at %7.4r  %M\n", maxEv, $abstime );
        VSB_cnt=VSB_cnt-1;
        $fclose(outfile);
      end
   end

end // analog
endmodule // pe5

// Verilog-A OC Watch for device pe5ti Parameters  VGS VGD VDS VDB VSB
module pe5ti_ahdl(D,G,S,B);
parameter tstep_occ=100n;
parameter errFileName="./occ.err";
parameter maxEv = 25;
parameter maxEv_flg = 0;
inout D,G,S,B;
electrical D,G,S,B;

integer outfile;
real V_S_B;
real V_D_B;
real V_D_S;
real V_G_D;
real V_G_S;
real VGS;
integer VGS_retc;
integer VGS_cnt;
real VGD;
integer VGD_retc;
integer VGD_cnt;
real VDS;
integer VDS_retc;
integer VDS_cnt;
real VDB;
integer VDB_retc;
integer VDB_cnt;
real VSB;
integer VSB_retc;
integer VSB_cnt;

analog begin
   $bound_step( tstep_occ );
   @(initial_step) begin
      VGS_retc=0;
      VGS_cnt = maxEv;
      VGD_retc=0;
      VGD_cnt = maxEv;
      VDS_retc=0;
      VDS_cnt = maxEv;
      VDB_retc=0;
      VDB_cnt = maxEv;
      VSB_retc=0;
      VSB_cnt = maxEv;
   end
   V_S_B = V(S,B);
   V_D_B = V(D,B);
   V_D_S = V(D,S);
   V_G_D = V(G,D);
   V_G_S = V(G,S);

//      VGS
   VGS = V_G_S;
   if((VGS_cnt>0) || ( maxEv_flg==0 ))   begin
      if( (VGS < -5.5) && (VGS_retc!=-1))
      begin
        outfile=$fopen(errFileName,"a");
        $strobe("pe5ti         VGS     leaving   OCA (  .. -5.500 V ) at %7.4r  %M", $abstime );
        $fwrite(outfile,"pe5ti         VGS     leaving   OCA (  .. -5.500 V ) at %7.4r  %M\n", $abstime );
        VGS_retc=-1;
        VGS_cnt=VGS_cnt-1;
        $fclose(outfile);
      end
      if((VGS >= -5.5) &&  (VGS <= 5.5) && (VGS_retc!=0))
      begin
        outfile=$fopen(errFileName,"a");
        $strobe("pe5ti         VGS     entering SOCA ( -5.500 V .. 5.500 V ) at %7.4r  %M", $abstime );
        $fwrite(outfile,"pe5ti         VGS     entering SOCA ( -5.500 V .. 5.500 V ) at %7.4r  %M\n", $abstime );
        VGS_retc=0;
        VGS_cnt=VGS_cnt-1;
        $fclose(outfile);
      end
      if((VGS > 5.5) &&  (VGS_retc!=1))
      begin
        outfile=$fopen(errFileName,"a");
        $strobe("pe5ti         VGS     leaving   OCA ( 5.500 V ..  ) at %7.4r  %M", $abstime );
        $fwrite(outfile,"pe5ti         VGS     leaving   OCA ( 5.500 V ..  ) at %7.4r  %M\n", $abstime );
        VGS_retc=1;
        VGS_cnt=VGS_cnt-1;
        $fclose(outfile);
      end
   end
   else
   begin
      if(VGS_cnt==0)
      begin
        outfile=$fopen(errFileName,"a");
        $strobe("pe5ti         VGS     error limit ( %d ) reached at %7.4r  %M", maxEv, $abstime );
        $fwrite(outfile,"pe5ti         VGS     error limit ( %d ) reached at %7.4r  %M\n", maxEv, $abstime );
        VGS_cnt=VGS_cnt-1;
        $fclose(outfile);
      end
   end

//      VGD
   VGD = V_G_D;
   if((VGD_cnt>0) || ( maxEv_flg==0 ))   begin
      if( (VGD < -5.5) && (VGD_retc!=-1))
      begin
        outfile=$fopen(errFileName,"a");
        $strobe("pe5ti         VGD     leaving   OCA (  .. -5.500 V ) at %7.4r  %M", $abstime );
        $fwrite(outfile,"pe5ti         VGD     leaving   OCA (  .. -5.500 V ) at %7.4r  %M\n", $abstime );
        VGD_retc=-1;
        VGD_cnt=VGD_cnt-1;
        $fclose(outfile);
      end
      if((VGD >= -5.5) &&  (VGD <= 5.5) && (VGD_retc!=0))
      begin
        outfile=$fopen(errFileName,"a");
        $strobe("pe5ti         VGD     entering SOCA ( -5.500 V .. 5.500 V ) at %7.4r  %M", $abstime );
        $fwrite(outfile,"pe5ti         VGD     entering SOCA ( -5.500 V .. 5.500 V ) at %7.4r  %M\n", $abstime );
        VGD_retc=0;
        VGD_cnt=VGD_cnt-1;
        $fclose(outfile);
      end
      if((VGD > 5.5) &&  (VGD_retc!=1))
      begin
        outfile=$fopen(errFileName,"a");
        $strobe("pe5ti         VGD     leaving   OCA ( 5.500 V ..  ) at %7.4r  %M", $abstime );
        $fwrite(outfile,"pe5ti         VGD     leaving   OCA ( 5.500 V ..  ) at %7.4r  %M\n", $abstime );
        VGD_retc=1;
        VGD_cnt=VGD_cnt-1;
        $fclose(outfile);
      end
   end
   else
   begin
      if(VGD_cnt==0)
      begin
        outfile=$fopen(errFileName,"a");
        $strobe("pe5ti         VGD     error limit ( %d ) reached at %7.4r  %M", maxEv, $abstime );
        $fwrite(outfile,"pe5ti         VGD     error limit ( %d ) reached at %7.4r  %M\n", maxEv, $abstime );
        VGD_cnt=VGD_cnt-1;
        $fclose(outfile);
      end
   end

//      VDS
   VDS = V_D_S;
   if((VDS_cnt>0) || ( maxEv_flg==0 ))   begin
      if( (VDS < -5.5) && (VDS_retc!=-1))
      begin
        outfile=$fopen(errFileName,"a");
        $strobe("pe5ti         VDS     leaving   OCA (  .. -5.500 V ) at %7.4r  %M", $abstime );
        $fwrite(outfile,"pe5ti         VDS     leaving   OCA (  .. -5.500 V ) at %7.4r  %M\n", $abstime );
        VDS_retc=-1;
        VDS_cnt=VDS_cnt-1;
        $fclose(outfile);
      end
      if((VDS >= -5.5) &&  (VDS <= 5.5) && (VDS_retc!=0))
      begin
        outfile=$fopen(errFileName,"a");
        $strobe("pe5ti         VDS     entering SOCA ( -5.500 V .. 5.500 V ) at %7.4r  %M", $abstime );
        $fwrite(outfile,"pe5ti         VDS     entering SOCA ( -5.500 V .. 5.500 V ) at %7.4r  %M\n", $abstime );
        VDS_retc=0;
        VDS_cnt=VDS_cnt-1;
        $fclose(outfile);
      end
      if((VDS > 5.5) &&  (VDS_retc!=1))
      begin
        outfile=$fopen(errFileName,"a");
        $strobe("pe5ti         VDS     leaving   OCA ( 5.500 V ..  ) at %7.4r  %M", $abstime );
        $fwrite(outfile,"pe5ti         VDS     leaving   OCA ( 5.500 V ..  ) at %7.4r  %M\n", $abstime );
        VDS_retc=1;
        VDS_cnt=VDS_cnt-1;
        $fclose(outfile);
      end
   end
   else
   begin
      if(VDS_cnt==0)
      begin
        outfile=$fopen(errFileName,"a");
        $strobe("pe5ti         VDS     error limit ( %d ) reached at %7.4r  %M", maxEv, $abstime );
        $fwrite(outfile,"pe5ti         VDS     error limit ( %d ) reached at %7.4r  %M\n", maxEv, $abstime );
        VDS_cnt=VDS_cnt-1;
        $fclose(outfile);
      end
   end

//      VDB
   VDB = V_D_B;
   if((VDB_cnt>0) || ( maxEv_flg==0 ))   begin
      if( (VDB < -5.5) && (VDB_retc!=-1))
      begin
        outfile=$fopen(errFileName,"a");
        $strobe("pe5ti         VDB     leaving   OCA (  .. -5.500 V ) at %7.4r  %M", $abstime );
        $fwrite(outfile,"pe5ti         VDB     leaving   OCA (  .. -5.500 V ) at %7.4r  %M\n", $abstime );
        VDB_retc=-1;
        VDB_cnt=VDB_cnt-1;
        $fclose(outfile);
      end
      if((VDB >= -5.5) &&  (VDB <= 0.1) && (VDB_retc!=0))
      begin
        outfile=$fopen(errFileName,"a");
        $strobe("pe5ti         VDB     entering SOCA ( -5.500 V .. 0.100 V ) at %7.4r  %M", $abstime );
        $fwrite(outfile,"pe5ti         VDB     entering SOCA ( -5.500 V .. 0.100 V ) at %7.4r  %M\n", $abstime );
        VDB_retc=0;
        VDB_cnt=VDB_cnt-1;
        $fclose(outfile);
      end
      if((VDB > 0.1) &&  (VDB_retc!=1))
      begin
        outfile=$fopen(errFileName,"a");
        $strobe("pe5ti         VDB     leaving   OCA ( 0.100 V ..  ) at %7.4r  %M", $abstime );
        $fwrite(outfile,"pe5ti         VDB     leaving   OCA ( 0.100 V ..  ) at %7.4r  %M\n", $abstime );
        VDB_retc=1;
        VDB_cnt=VDB_cnt-1;
        $fclose(outfile);
      end
   end
   else
   begin
      if(VDB_cnt==0)
      begin
        outfile=$fopen(errFileName,"a");
        $strobe("pe5ti         VDB     error limit ( %d ) reached at %7.4r  %M", maxEv, $abstime );
        $fwrite(outfile,"pe5ti         VDB     error limit ( %d ) reached at %7.4r  %M\n", maxEv, $abstime );
        VDB_cnt=VDB_cnt-1;
        $fclose(outfile);
      end
   end

//      VSB
   VSB = V_S_B;
   if((VSB_cnt>0) || ( maxEv_flg==0 ))   begin
      if( (VSB < -5.5) && (VSB_retc!=-1))
      begin
        outfile=$fopen(errFileName,"a");
        $strobe("pe5ti         VSB     leaving   OCA (  .. -5.500 V ) at %7.4r  %M", $abstime );
        $fwrite(outfile,"pe5ti         VSB     leaving   OCA (  .. -5.500 V ) at %7.4r  %M\n", $abstime );
        VSB_retc=-1;
        VSB_cnt=VSB_cnt-1;
        $fclose(outfile);
      end
      if((VSB >= -5.5) &&  (VSB <= 0.1) && (VSB_retc!=0))
      begin
        outfile=$fopen(errFileName,"a");
        $strobe("pe5ti         VSB     entering SOCA ( -5.500 V .. 0.100 V ) at %7.4r  %M", $abstime );
        $fwrite(outfile,"pe5ti         VSB     entering SOCA ( -5.500 V .. 0.100 V ) at %7.4r  %M\n", $abstime );
        VSB_retc=0;
        VSB_cnt=VSB_cnt-1;
        $fclose(outfile);
      end
      if((VSB > 0.1) &&  (VSB_retc!=1))
      begin
        outfile=$fopen(errFileName,"a");
        $strobe("pe5ti         VSB     leaving   OCA ( 0.100 V ..  ) at %7.4r  %M", $abstime );
        $fwrite(outfile,"pe5ti         VSB     leaving   OCA ( 0.100 V ..  ) at %7.4r  %M\n", $abstime );
        VSB_retc=1;
        VSB_cnt=VSB_cnt-1;
        $fclose(outfile);
      end
   end
   else
   begin
      if(VSB_cnt==0)
      begin
        outfile=$fopen(errFileName,"a");
        $strobe("pe5ti         VSB     error limit ( %d ) reached at %7.4r  %M", maxEv, $abstime );
        $fwrite(outfile,"pe5ti         VSB     error limit ( %d ) reached at %7.4r  %M\n", maxEv, $abstime );
        VSB_cnt=VSB_cnt-1;
        $fclose(outfile);
      end
   end

end // analog
endmodule // pe5ti

// Verilog-A OC Watch for device pe5_5 Parameters  VGS VGD VDS VDB VSB VBsub
module pe5_5_ahdl(D,G,S,B,sub);
parameter tstep_occ=100n;
parameter errFileName="./occ.err";
parameter maxEv = 25;
parameter maxEv_flg = 0;
inout D,G,S,B,sub;
electrical D,G,S,B,sub;

integer outfile;
real V_B_sub;
real V_S_B;
real V_D_B;
real V_D_S;
real V_G_D;
real V_G_S;
real VGS;
integer VGS_retc;
integer VGS_cnt;
real VGD;
integer VGD_retc;
integer VGD_cnt;
real VDS;
integer VDS_retc;
integer VDS_cnt;
real VDB;
integer VDB_retc;
integer VDB_cnt;
real VSB;
integer VSB_retc;
integer VSB_cnt;
real VBsub;
integer VBsub_retc;
integer VBsub_cnt;

analog begin
   $bound_step( tstep_occ );
   @(initial_step) begin
      VGS_retc=0;
      VGS_cnt = maxEv;
      VGD_retc=0;
      VGD_cnt = maxEv;
      VDS_retc=0;
      VDS_cnt = maxEv;
      VDB_retc=0;
      VDB_cnt = maxEv;
      VSB_retc=0;
      VSB_cnt = maxEv;
      VBsub_retc=0;
      VBsub_cnt = maxEv;
   end
   V_B_sub = V(B,sub);
   V_S_B = V(S,B);
   V_D_B = V(D,B);
   V_D_S = V(D,S);
   V_G_D = V(G,D);
   V_G_S = V(G,S);

//      VGS
   VGS = V_G_S;
   if((VGS_cnt>0) || ( maxEv_flg==0 ))   begin
      if( (VGS < -5.5) && (VGS_retc!=-1))
      begin
        outfile=$fopen(errFileName,"a");
        $strobe("pe5_5         VGS     leaving   OCA (  .. -5.500 V ) at %7.4r  %M", $abstime );
        $fwrite(outfile,"pe5_5         VGS     leaving   OCA (  .. -5.500 V ) at %7.4r  %M\n", $abstime );
        VGS_retc=-1;
        VGS_cnt=VGS_cnt-1;
        $fclose(outfile);
      end
      if((VGS >= -5.5) &&  (VGS <= 5.5) && (VGS_retc!=0))
      begin
        outfile=$fopen(errFileName,"a");
        $strobe("pe5_5         VGS     entering SOCA ( -5.500 V .. 5.500 V ) at %7.4r  %M", $abstime );
        $fwrite(outfile,"pe5_5         VGS     entering SOCA ( -5.500 V .. 5.500 V ) at %7.4r  %M\n", $abstime );
        VGS_retc=0;
        VGS_cnt=VGS_cnt-1;
        $fclose(outfile);
      end
      if((VGS > 5.5) &&  (VGS_retc!=1))
      begin
        outfile=$fopen(errFileName,"a");
        $strobe("pe5_5         VGS     leaving   OCA ( 5.500 V ..  ) at %7.4r  %M", $abstime );
        $fwrite(outfile,"pe5_5         VGS     leaving   OCA ( 5.500 V ..  ) at %7.4r  %M\n", $abstime );
        VGS_retc=1;
        VGS_cnt=VGS_cnt-1;
        $fclose(outfile);
      end
   end
   else
   begin
      if(VGS_cnt==0)
      begin
        outfile=$fopen(errFileName,"a");
        $strobe("pe5_5         VGS     error limit ( %d ) reached at %7.4r  %M", maxEv, $abstime );
        $fwrite(outfile,"pe5_5         VGS     error limit ( %d ) reached at %7.4r  %M\n", maxEv, $abstime );
        VGS_cnt=VGS_cnt-1;
        $fclose(outfile);
      end
   end

//      VGD
   VGD = V_G_D;
   if((VGD_cnt>0) || ( maxEv_flg==0 ))   begin
      if( (VGD < -5.5) && (VGD_retc!=-1))
      begin
        outfile=$fopen(errFileName,"a");
        $strobe("pe5_5         VGD     leaving   OCA (  .. -5.500 V ) at %7.4r  %M", $abstime );
        $fwrite(outfile,"pe5_5         VGD     leaving   OCA (  .. -5.500 V ) at %7.4r  %M\n", $abstime );
        VGD_retc=-1;
        VGD_cnt=VGD_cnt-1;
        $fclose(outfile);
      end
      if((VGD >= -5.5) &&  (VGD <= 5.5) && (VGD_retc!=0))
      begin
        outfile=$fopen(errFileName,"a");
        $strobe("pe5_5         VGD     entering SOCA ( -5.500 V .. 5.500 V ) at %7.4r  %M", $abstime );
        $fwrite(outfile,"pe5_5         VGD     entering SOCA ( -5.500 V .. 5.500 V ) at %7.4r  %M\n", $abstime );
        VGD_retc=0;
        VGD_cnt=VGD_cnt-1;
        $fclose(outfile);
      end
      if((VGD > 5.5) &&  (VGD_retc!=1))
      begin
        outfile=$fopen(errFileName,"a");
        $strobe("pe5_5         VGD     leaving   OCA ( 5.500 V ..  ) at %7.4r  %M", $abstime );
        $fwrite(outfile,"pe5_5         VGD     leaving   OCA ( 5.500 V ..  ) at %7.4r  %M\n", $abstime );
        VGD_retc=1;
        VGD_cnt=VGD_cnt-1;
        $fclose(outfile);
      end
   end
   else
   begin
      if(VGD_cnt==0)
      begin
        outfile=$fopen(errFileName,"a");
        $strobe("pe5_5         VGD     error limit ( %d ) reached at %7.4r  %M", maxEv, $abstime );
        $fwrite(outfile,"pe5_5         VGD     error limit ( %d ) reached at %7.4r  %M\n", maxEv, $abstime );
        VGD_cnt=VGD_cnt-1;
        $fclose(outfile);
      end
   end

//      VDS
   VDS = V_D_S;
   if((VDS_cnt>0) || ( maxEv_flg==0 ))   begin
      if( (VDS < -5.5) && (VDS_retc!=-1))
      begin
        outfile=$fopen(errFileName,"a");
        $strobe("pe5_5         VDS     leaving   OCA (  .. -5.500 V ) at %7.4r  %M", $abstime );
        $fwrite(outfile,"pe5_5         VDS     leaving   OCA (  .. -5.500 V ) at %7.4r  %M\n", $abstime );
        VDS_retc=-1;
        VDS_cnt=VDS_cnt-1;
        $fclose(outfile);
      end
      if((VDS >= -5.5) &&  (VDS <= 5.5) && (VDS_retc!=0))
      begin
        outfile=$fopen(errFileName,"a");
        $strobe("pe5_5         VDS     entering SOCA ( -5.500 V .. 5.500 V ) at %7.4r  %M", $abstime );
        $fwrite(outfile,"pe5_5         VDS     entering SOCA ( -5.500 V .. 5.500 V ) at %7.4r  %M\n", $abstime );
        VDS_retc=0;
        VDS_cnt=VDS_cnt-1;
        $fclose(outfile);
      end
      if((VDS > 5.5) &&  (VDS_retc!=1))
      begin
        outfile=$fopen(errFileName,"a");
        $strobe("pe5_5         VDS     leaving   OCA ( 5.500 V ..  ) at %7.4r  %M", $abstime );
        $fwrite(outfile,"pe5_5         VDS     leaving   OCA ( 5.500 V ..  ) at %7.4r  %M\n", $abstime );
        VDS_retc=1;
        VDS_cnt=VDS_cnt-1;
        $fclose(outfile);
      end
   end
   else
   begin
      if(VDS_cnt==0)
      begin
        outfile=$fopen(errFileName,"a");
        $strobe("pe5_5         VDS     error limit ( %d ) reached at %7.4r  %M", maxEv, $abstime );
        $fwrite(outfile,"pe5_5         VDS     error limit ( %d ) reached at %7.4r  %M\n", maxEv, $abstime );
        VDS_cnt=VDS_cnt-1;
        $fclose(outfile);
      end
   end

//      VDB
   VDB = V_D_B;
   if((VDB_cnt>0) || ( maxEv_flg==0 ))   begin
      if( (VDB < -5.5) && (VDB_retc!=-1))
      begin
        outfile=$fopen(errFileName,"a");
        $strobe("pe5_5         VDB     leaving   OCA (  .. -5.500 V ) at %7.4r  %M", $abstime );
        $fwrite(outfile,"pe5_5         VDB     leaving   OCA (  .. -5.500 V ) at %7.4r  %M\n", $abstime );
        VDB_retc=-1;
        VDB_cnt=VDB_cnt-1;
        $fclose(outfile);
      end
      if((VDB >= -5.5) &&  (VDB <= 0.1) && (VDB_retc!=0))
      begin
        outfile=$fopen(errFileName,"a");
        $strobe("pe5_5         VDB     entering SOCA ( -5.500 V .. 0.100 V ) at %7.4r  %M", $abstime );
        $fwrite(outfile,"pe5_5         VDB     entering SOCA ( -5.500 V .. 0.100 V ) at %7.4r  %M\n", $abstime );
        VDB_retc=0;
        VDB_cnt=VDB_cnt-1;
        $fclose(outfile);
      end
      if((VDB > 0.1) &&  (VDB_retc!=1))
      begin
        outfile=$fopen(errFileName,"a");
        $strobe("pe5_5         VDB     leaving   OCA ( 0.100 V ..  ) at %7.4r  %M", $abstime );
        $fwrite(outfile,"pe5_5         VDB     leaving   OCA ( 0.100 V ..  ) at %7.4r  %M\n", $abstime );
        VDB_retc=1;
        VDB_cnt=VDB_cnt-1;
        $fclose(outfile);
      end
   end
   else
   begin
      if(VDB_cnt==0)
      begin
        outfile=$fopen(errFileName,"a");
        $strobe("pe5_5         VDB     error limit ( %d ) reached at %7.4r  %M", maxEv, $abstime );
        $fwrite(outfile,"pe5_5         VDB     error limit ( %d ) reached at %7.4r  %M\n", maxEv, $abstime );
        VDB_cnt=VDB_cnt-1;
        $fclose(outfile);
      end
   end

//      VSB
   VSB = V_S_B;
   if((VSB_cnt>0) || ( maxEv_flg==0 ))   begin
      if( (VSB < -5.5) && (VSB_retc!=-1))
      begin
        outfile=$fopen(errFileName,"a");
        $strobe("pe5_5         VSB     leaving   OCA (  .. -5.500 V ) at %7.4r  %M", $abstime );
        $fwrite(outfile,"pe5_5         VSB     leaving   OCA (  .. -5.500 V ) at %7.4r  %M\n", $abstime );
        VSB_retc=-1;
        VSB_cnt=VSB_cnt-1;
        $fclose(outfile);
      end
      if((VSB >= -5.5) &&  (VSB <= 0.1) && (VSB_retc!=0))
      begin
        outfile=$fopen(errFileName,"a");
        $strobe("pe5_5         VSB     entering SOCA ( -5.500 V .. 0.100 V ) at %7.4r  %M", $abstime );
        $fwrite(outfile,"pe5_5         VSB     entering SOCA ( -5.500 V .. 0.100 V ) at %7.4r  %M\n", $abstime );
        VSB_retc=0;
        VSB_cnt=VSB_cnt-1;
        $fclose(outfile);
      end
      if((VSB > 0.1) &&  (VSB_retc!=1))
      begin
        outfile=$fopen(errFileName,"a");
        $strobe("pe5_5         VSB     leaving   OCA ( 0.100 V ..  ) at %7.4r  %M", $abstime );
        $fwrite(outfile,"pe5_5         VSB     leaving   OCA ( 0.100 V ..  ) at %7.4r  %M\n", $abstime );
        VSB_retc=1;
        VSB_cnt=VSB_cnt-1;
        $fclose(outfile);
      end
   end
   else
   begin
      if(VSB_cnt==0)
      begin
        outfile=$fopen(errFileName,"a");
        $strobe("pe5_5         VSB     error limit ( %d ) reached at %7.4r  %M", maxEv, $abstime );
        $fwrite(outfile,"pe5_5         VSB     error limit ( %d ) reached at %7.4r  %M\n", maxEv, $abstime );
        VSB_cnt=VSB_cnt-1;
        $fclose(outfile);
      end
   end

//      VBsub
   VBsub = V_B_sub;
   if((VBsub_cnt>0) || ( maxEv_flg==0 ))   begin
      if( (VBsub < -0.1) && (VBsub_retc!=-1))
      begin
        outfile=$fopen(errFileName,"a");
        $strobe("pe5_5         VBsub   leaving   OCA (  .. -0.100 V ) at %7.4r  %M", $abstime );
        $fwrite(outfile,"pe5_5         VBsub   leaving   OCA (  .. -0.100 V ) at %7.4r  %M\n", $abstime );
        VBsub_retc=-1;
        VBsub_cnt=VBsub_cnt-1;
        $fclose(outfile);
      end
      if((VBsub >= -0.1) &&  (VBsub <= 5.5) && (VBsub_retc!=0))
      begin
        outfile=$fopen(errFileName,"a");
        $strobe("pe5_5         VBsub   entering SOCA ( -0.100 V .. 5.500 V ) at %7.4r  %M", $abstime );
        $fwrite(outfile,"pe5_5         VBsub   entering SOCA ( -0.100 V .. 5.500 V ) at %7.4r  %M\n", $abstime );
        VBsub_retc=0;
        VBsub_cnt=VBsub_cnt-1;
        $fclose(outfile);
      end
      if((VBsub > 5.5) &&  (VBsub_retc!=1))
      begin
        outfile=$fopen(errFileName,"a");
        $strobe("pe5_5         VBsub   leaving   OCA ( 5.500 V ..  ) at %7.4r  %M", $abstime );
        $fwrite(outfile,"pe5_5         VBsub   leaving   OCA ( 5.500 V ..  ) at %7.4r  %M\n", $abstime );
        VBsub_retc=1;
        VBsub_cnt=VBsub_cnt-1;
        $fclose(outfile);
      end
   end
   else
   begin
      if(VBsub_cnt==0)
      begin
        outfile=$fopen(errFileName,"a");
        $strobe("pe5_5         VBsub   error limit ( %d ) reached at %7.4r  %M", maxEv, $abstime );
        $fwrite(outfile,"pe5_5         VBsub   error limit ( %d ) reached at %7.4r  %M\n", maxEv, $abstime );
        VBsub_cnt=VBsub_cnt-1;
        $fclose(outfile);
      end
   end

end // analog
endmodule // pe5_5

// Verilog-A OC Watch for device nmvaa Parameters  VGS VGD VDS VDB
module nmvaa_ahdl(D,G,S,B);
parameter tstep_occ=100n;
parameter errFileName="./occ.err";
parameter maxEv = 25;
parameter maxEv_flg = 0;
inout D,G,S,B;
electrical D,G,S,B;

integer outfile;
real V_D_B;
real V_D_S;
real V_G_D;
real V_G_S;
real VGS;
integer VGS_retc;
integer VGS_cnt;
real VGD;
integer VGD_retc;
integer VGD_cnt;
real VDS;
integer VDS_retc;
integer VDS_cnt;
real VDB;
integer VDB_retc;
integer VDB_cnt;

analog begin
   $bound_step( tstep_occ );
   @(initial_step) begin
      VGS_retc=0;
      VGS_cnt = maxEv;
      VGD_retc=0;
      VGD_cnt = maxEv;
      VDS_retc=0;
      VDS_cnt = maxEv;
      VDB_retc=0;
      VDB_cnt = maxEv;
   end
   V_D_B = V(D,B);
   V_D_S = V(D,S);
   V_G_D = V(G,D);
   V_G_S = V(G,S);

//      VGS
   VGS = V_G_S;
   if((VGS_cnt>0) || ( maxEv_flg==0 ))   begin
      if( (VGS < -5.5) && (VGS_retc!=-1))
      begin
        outfile=$fopen(errFileName,"a");
        $strobe("nmvaa         VGS     leaving   OCA (  .. -5.500 V ) at %7.4r  %M", $abstime );
        $fwrite(outfile,"nmvaa         VGS     leaving   OCA (  .. -5.500 V ) at %7.4r  %M\n", $abstime );
        VGS_retc=-1;
        VGS_cnt=VGS_cnt-1;
        $fclose(outfile);
      end
      if((VGS >= -5.5) &&  (VGS <= 5.5) && (VGS_retc!=0))
      begin
        outfile=$fopen(errFileName,"a");
        $strobe("nmvaa         VGS     entering SOCA ( -5.500 V .. 5.500 V ) at %7.4r  %M", $abstime );
        $fwrite(outfile,"nmvaa         VGS     entering SOCA ( -5.500 V .. 5.500 V ) at %7.4r  %M\n", $abstime );
        VGS_retc=0;
        VGS_cnt=VGS_cnt-1;
        $fclose(outfile);
      end
      if((VGS > 5.5) &&  (VGS_retc!=1))
      begin
        outfile=$fopen(errFileName,"a");
        $strobe("nmvaa         VGS     leaving   OCA ( 5.500 V ..  ) at %7.4r  %M", $abstime );
        $fwrite(outfile,"nmvaa         VGS     leaving   OCA ( 5.500 V ..  ) at %7.4r  %M\n", $abstime );
        VGS_retc=1;
        VGS_cnt=VGS_cnt-1;
        $fclose(outfile);
      end
   end
   else
   begin
      if(VGS_cnt==0)
      begin
        outfile=$fopen(errFileName,"a");
        $strobe("nmvaa         VGS     error limit ( %d ) reached at %7.4r  %M", maxEv, $abstime );
        $fwrite(outfile,"nmvaa         VGS     error limit ( %d ) reached at %7.4r  %M\n", maxEv, $abstime );
        VGS_cnt=VGS_cnt-1;
        $fclose(outfile);
      end
   end

//      VGD
   VGD = V_G_D;
   if((VGD_cnt>0) || ( maxEv_flg==0 ))   begin
      if( (VGD < -10) && (VGD_retc!=-1))
      begin
        outfile=$fopen(errFileName,"a");
        $strobe("nmvaa         VGD     leaving   OCA (  .. -10.000 V ) at %7.4r  %M", $abstime );
        $fwrite(outfile,"nmvaa         VGD     leaving   OCA (  .. -10.000 V ) at %7.4r  %M\n", $abstime );
        VGD_retc=-1;
        VGD_cnt=VGD_cnt-1;
        $fclose(outfile);
      end
      if((VGD >= -10) &&  (VGD <= 5.5) && (VGD_retc!=0))
      begin
        outfile=$fopen(errFileName,"a");
        $strobe("nmvaa         VGD     entering SOCA ( -10.000 V .. 5.500 V ) at %7.4r  %M", $abstime );
        $fwrite(outfile,"nmvaa         VGD     entering SOCA ( -10.000 V .. 5.500 V ) at %7.4r  %M\n", $abstime );
        VGD_retc=0;
        VGD_cnt=VGD_cnt-1;
        $fclose(outfile);
      end
      if((VGD > 5.5) &&  (VGD_retc!=1))
      begin
        outfile=$fopen(errFileName,"a");
        $strobe("nmvaa         VGD     leaving   OCA ( 5.500 V ..  ) at %7.4r  %M", $abstime );
        $fwrite(outfile,"nmvaa         VGD     leaving   OCA ( 5.500 V ..  ) at %7.4r  %M\n", $abstime );
        VGD_retc=1;
        VGD_cnt=VGD_cnt-1;
        $fclose(outfile);
      end
   end
   else
   begin
      if(VGD_cnt==0)
      begin
        outfile=$fopen(errFileName,"a");
        $strobe("nmvaa         VGD     error limit ( %d ) reached at %7.4r  %M", maxEv, $abstime );
        $fwrite(outfile,"nmvaa         VGD     error limit ( %d ) reached at %7.4r  %M\n", maxEv, $abstime );
        VGD_cnt=VGD_cnt-1;
        $fclose(outfile);
      end
   end

//      VDS
   VDS = V_D_S;
   if((VDS_cnt>0) || ( maxEv_flg==0 ))   begin
      if( (VDS < -0.1) && (VDS_retc!=-1))
      begin
        outfile=$fopen(errFileName,"a");
        $strobe("nmvaa         VDS     leaving   OCA (  .. -0.100 V ) at %7.4r  %M", $abstime );
        $fwrite(outfile,"nmvaa         VDS     leaving   OCA (  .. -0.100 V ) at %7.4r  %M\n", $abstime );
        VDS_retc=-1;
        VDS_cnt=VDS_cnt-1;
        $fclose(outfile);
      end
      if((VDS >= -0.1) &&  (VDS <= 10) && (VDS_retc!=0))
      begin
        outfile=$fopen(errFileName,"a");
        $strobe("nmvaa         VDS     entering SOCA ( -0.100 V .. 10.000 V ) at %7.4r  %M", $abstime );
        $fwrite(outfile,"nmvaa         VDS     entering SOCA ( -0.100 V .. 10.000 V ) at %7.4r  %M\n", $abstime );
        VDS_retc=0;
        VDS_cnt=VDS_cnt-1;
        $fclose(outfile);
      end
      if((VDS > 10) &&  (VDS_retc!=1))
      begin
        outfile=$fopen(errFileName,"a");
        $strobe("nmvaa         VDS     leaving   OCA ( 10.000 V ..  ) at %7.4r  %M", $abstime );
        $fwrite(outfile,"nmvaa         VDS     leaving   OCA ( 10.000 V ..  ) at %7.4r  %M\n", $abstime );
        VDS_retc=1;
        VDS_cnt=VDS_cnt-1;
        $fclose(outfile);
      end
   end
   else
   begin
      if(VDS_cnt==0)
      begin
        outfile=$fopen(errFileName,"a");
        $strobe("nmvaa         VDS     error limit ( %d ) reached at %7.4r  %M", maxEv, $abstime );
        $fwrite(outfile,"nmvaa         VDS     error limit ( %d ) reached at %7.4r  %M\n", maxEv, $abstime );
        VDS_cnt=VDS_cnt-1;
        $fclose(outfile);
      end
   end

//      VDB
   VDB = V_D_B;
   if((VDB_cnt>0) || ( maxEv_flg==0 ))   begin
      if( (VDB < -0.1) && (VDB_retc!=-1))
      begin
        outfile=$fopen(errFileName,"a");
        $strobe("nmvaa         VDB     leaving   OCA (  .. -0.100 V ) at %7.4r  %M", $abstime );
        $fwrite(outfile,"nmvaa         VDB     leaving   OCA (  .. -0.100 V ) at %7.4r  %M\n", $abstime );
        VDB_retc=-1;
        VDB_cnt=VDB_cnt-1;
        $fclose(outfile);
      end
      if((VDB >= -0.1) &&  (VDB <= 10) && (VDB_retc!=0))
      begin
        outfile=$fopen(errFileName,"a");
        $strobe("nmvaa         VDB     entering SOCA ( -0.100 V .. 10.000 V ) at %7.4r  %M", $abstime );
        $fwrite(outfile,"nmvaa         VDB     entering SOCA ( -0.100 V .. 10.000 V ) at %7.4r  %M\n", $abstime );
        VDB_retc=0;
        VDB_cnt=VDB_cnt-1;
        $fclose(outfile);
      end
      if((VDB > 10) &&  (VDB_retc!=1))
      begin
        outfile=$fopen(errFileName,"a");
        $strobe("nmvaa         VDB     leaving   OCA ( 10.000 V ..  ) at %7.4r  %M", $abstime );
        $fwrite(outfile,"nmvaa         VDB     leaving   OCA ( 10.000 V ..  ) at %7.4r  %M\n", $abstime );
        VDB_retc=1;
        VDB_cnt=VDB_cnt-1;
        $fclose(outfile);
      end
   end
   else
   begin
      if(VDB_cnt==0)
      begin
        outfile=$fopen(errFileName,"a");
        $strobe("nmvaa         VDB     error limit ( %d ) reached at %7.4r  %M", maxEv, $abstime );
        $fwrite(outfile,"nmvaa         VDB     error limit ( %d ) reached at %7.4r  %M\n", maxEv, $abstime );
        VDB_cnt=VDB_cnt-1;
        $fclose(outfile);
      end
   end

end // analog
endmodule // nmvaa

// Verilog-A OC Watch for device nmvab Parameters  VGS VGD VDS VDB
module nmvab_ahdl(D,G,S,B);
parameter tstep_occ=100n;
parameter errFileName="./occ.err";
parameter maxEv = 25;
parameter maxEv_flg = 0;
inout D,G,S,B;
electrical D,G,S,B;

integer outfile;
real V_D_B;
real V_D_S;
real V_G_D;
real V_G_S;
real VGS;
integer VGS_retc;
integer VGS_cnt;
real VGD;
integer VGD_retc;
integer VGD_cnt;
real VDS;
integer VDS_retc;
integer VDS_cnt;
real VDB;
integer VDB_retc;
integer VDB_cnt;

analog begin
   $bound_step( tstep_occ );
   @(initial_step) begin
      VGS_retc=0;
      VGS_cnt = maxEv;
      VGD_retc=0;
      VGD_cnt = maxEv;
      VDS_retc=0;
      VDS_cnt = maxEv;
      VDB_retc=0;
      VDB_cnt = maxEv;
   end
   V_D_B = V(D,B);
   V_D_S = V(D,S);
   V_G_D = V(G,D);
   V_G_S = V(G,S);

//      VGS
   VGS = V_G_S;
   if((VGS_cnt>0) || ( maxEv_flg==0 ))   begin
      if( (VGS < -5.5) && (VGS_retc!=-1))
      begin
        outfile=$fopen(errFileName,"a");
        $strobe("nmvab         VGS     leaving   OCA (  .. -5.500 V ) at %7.4r  %M", $abstime );
        $fwrite(outfile,"nmvab         VGS     leaving   OCA (  .. -5.500 V ) at %7.4r  %M\n", $abstime );
        VGS_retc=-1;
        VGS_cnt=VGS_cnt-1;
        $fclose(outfile);
      end
      if((VGS >= -5.5) &&  (VGS <= 5.5) && (VGS_retc!=0))
      begin
        outfile=$fopen(errFileName,"a");
        $strobe("nmvab         VGS     entering SOCA ( -5.500 V .. 5.500 V ) at %7.4r  %M", $abstime );
        $fwrite(outfile,"nmvab         VGS     entering SOCA ( -5.500 V .. 5.500 V ) at %7.4r  %M\n", $abstime );
        VGS_retc=0;
        VGS_cnt=VGS_cnt-1;
        $fclose(outfile);
      end
      if((VGS > 5.5) &&  (VGS_retc!=1))
      begin
        outfile=$fopen(errFileName,"a");
        $strobe("nmvab         VGS     leaving   OCA ( 5.500 V ..  ) at %7.4r  %M", $abstime );
        $fwrite(outfile,"nmvab         VGS     leaving   OCA ( 5.500 V ..  ) at %7.4r  %M\n", $abstime );
        VGS_retc=1;
        VGS_cnt=VGS_cnt-1;
        $fclose(outfile);
      end
   end
   else
   begin
      if(VGS_cnt==0)
      begin
        outfile=$fopen(errFileName,"a");
        $strobe("nmvab         VGS     error limit ( %d ) reached at %7.4r  %M", maxEv, $abstime );
        $fwrite(outfile,"nmvab         VGS     error limit ( %d ) reached at %7.4r  %M\n", maxEv, $abstime );
        VGS_cnt=VGS_cnt-1;
        $fclose(outfile);
      end
   end

//      VGD
   VGD = V_G_D;
   if((VGD_cnt>0) || ( maxEv_flg==0 ))   begin
      if( (VGD < -10) && (VGD_retc!=-1))
      begin
        outfile=$fopen(errFileName,"a");
        $strobe("nmvab         VGD     leaving   OCA (  .. -10.000 V ) at %7.4r  %M", $abstime );
        $fwrite(outfile,"nmvab         VGD     leaving   OCA (  .. -10.000 V ) at %7.4r  %M\n", $abstime );
        VGD_retc=-1;
        VGD_cnt=VGD_cnt-1;
        $fclose(outfile);
      end
      if((VGD >= -10) &&  (VGD <= 5.5) && (VGD_retc!=0))
      begin
        outfile=$fopen(errFileName,"a");
        $strobe("nmvab         VGD     entering SOCA ( -10.000 V .. 5.500 V ) at %7.4r  %M", $abstime );
        $fwrite(outfile,"nmvab         VGD     entering SOCA ( -10.000 V .. 5.500 V ) at %7.4r  %M\n", $abstime );
        VGD_retc=0;
        VGD_cnt=VGD_cnt-1;
        $fclose(outfile);
      end
      if((VGD > 5.5) &&  (VGD_retc!=1))
      begin
        outfile=$fopen(errFileName,"a");
        $strobe("nmvab         VGD     leaving   OCA ( 5.500 V ..  ) at %7.4r  %M", $abstime );
        $fwrite(outfile,"nmvab         VGD     leaving   OCA ( 5.500 V ..  ) at %7.4r  %M\n", $abstime );
        VGD_retc=1;
        VGD_cnt=VGD_cnt-1;
        $fclose(outfile);
      end
   end
   else
   begin
      if(VGD_cnt==0)
      begin
        outfile=$fopen(errFileName,"a");
        $strobe("nmvab         VGD     error limit ( %d ) reached at %7.4r  %M", maxEv, $abstime );
        $fwrite(outfile,"nmvab         VGD     error limit ( %d ) reached at %7.4r  %M\n", maxEv, $abstime );
        VGD_cnt=VGD_cnt-1;
        $fclose(outfile);
      end
   end

//      VDS
   VDS = V_D_S;
   if((VDS_cnt>0) || ( maxEv_flg==0 ))   begin
      if( (VDS < -0.1) && (VDS_retc!=-1))
      begin
        outfile=$fopen(errFileName,"a");
        $strobe("nmvab         VDS     leaving   OCA (  .. -0.100 V ) at %7.4r  %M", $abstime );
        $fwrite(outfile,"nmvab         VDS     leaving   OCA (  .. -0.100 V ) at %7.4r  %M\n", $abstime );
        VDS_retc=-1;
        VDS_cnt=VDS_cnt-1;
        $fclose(outfile);
      end
      if((VDS >= -0.1) &&  (VDS <= 10) && (VDS_retc!=0))
      begin
        outfile=$fopen(errFileName,"a");
        $strobe("nmvab         VDS     entering SOCA ( -0.100 V .. 10.000 V ) at %7.4r  %M", $abstime );
        $fwrite(outfile,"nmvab         VDS     entering SOCA ( -0.100 V .. 10.000 V ) at %7.4r  %M\n", $abstime );
        VDS_retc=0;
        VDS_cnt=VDS_cnt-1;
        $fclose(outfile);
      end
      if((VDS > 10) &&  (VDS_retc!=1))
      begin
        outfile=$fopen(errFileName,"a");
        $strobe("nmvab         VDS     leaving   OCA ( 10.000 V ..  ) at %7.4r  %M", $abstime );
        $fwrite(outfile,"nmvab         VDS     leaving   OCA ( 10.000 V ..  ) at %7.4r  %M\n", $abstime );
        VDS_retc=1;
        VDS_cnt=VDS_cnt-1;
        $fclose(outfile);
      end
   end
   else
   begin
      if(VDS_cnt==0)
      begin
        outfile=$fopen(errFileName,"a");
        $strobe("nmvab         VDS     error limit ( %d ) reached at %7.4r  %M", maxEv, $abstime );
        $fwrite(outfile,"nmvab         VDS     error limit ( %d ) reached at %7.4r  %M\n", maxEv, $abstime );
        VDS_cnt=VDS_cnt-1;
        $fclose(outfile);
      end
   end

//      VDB
   VDB = V_D_B;
   if((VDB_cnt>0) || ( maxEv_flg==0 ))   begin
      if( (VDB < -0.1) && (VDB_retc!=-1))
      begin
        outfile=$fopen(errFileName,"a");
        $strobe("nmvab         VDB     leaving   OCA (  .. -0.100 V ) at %7.4r  %M", $abstime );
        $fwrite(outfile,"nmvab         VDB     leaving   OCA (  .. -0.100 V ) at %7.4r  %M\n", $abstime );
        VDB_retc=-1;
        VDB_cnt=VDB_cnt-1;
        $fclose(outfile);
      end
      if((VDB >= -0.1) &&  (VDB <= 10) && (VDB_retc!=0))
      begin
        outfile=$fopen(errFileName,"a");
        $strobe("nmvab         VDB     entering SOCA ( -0.100 V .. 10.000 V ) at %7.4r  %M", $abstime );
        $fwrite(outfile,"nmvab         VDB     entering SOCA ( -0.100 V .. 10.000 V ) at %7.4r  %M\n", $abstime );
        VDB_retc=0;
        VDB_cnt=VDB_cnt-1;
        $fclose(outfile);
      end
      if((VDB > 10) &&  (VDB_retc!=1))
      begin
        outfile=$fopen(errFileName,"a");
        $strobe("nmvab         VDB     leaving   OCA ( 10.000 V ..  ) at %7.4r  %M", $abstime );
        $fwrite(outfile,"nmvab         VDB     leaving   OCA ( 10.000 V ..  ) at %7.4r  %M\n", $abstime );
        VDB_retc=1;
        VDB_cnt=VDB_cnt-1;
        $fclose(outfile);
      end
   end
   else
   begin
      if(VDB_cnt==0)
      begin
        outfile=$fopen(errFileName,"a");
        $strobe("nmvab         VDB     error limit ( %d ) reached at %7.4r  %M", maxEv, $abstime );
        $fwrite(outfile,"nmvab         VDB     error limit ( %d ) reached at %7.4r  %M\n", maxEv, $abstime );
        VDB_cnt=VDB_cnt-1;
        $fclose(outfile);
      end
   end

end // analog
endmodule // nmvab

// Verilog-A OC Watch for device nmvb Parameters  VGS VGD VDS VDB VDHW
module nmvb_ahdl(D,G,S,B,HW);
parameter tstep_occ=100n;
parameter errFileName="./occ.err";
parameter maxEv = 25;
parameter maxEv_flg = 0;
inout D,G,S,B,HW;
electrical D,G,S,B,HW;

integer outfile;
real V_D_HW;
real V_D_B;
real V_D_S;
real V_G_D;
real V_G_S;
real VGS;
integer VGS_retc;
integer VGS_cnt;
real VGD;
integer VGD_retc;
integer VGD_cnt;
real VDS;
integer VDS_retc;
integer VDS_cnt;
real VDB;
integer VDB_retc;
integer VDB_cnt;
real VDHW;
integer VDHW_retc;
integer VDHW_cnt;

analog begin
   $bound_step( tstep_occ );
   @(initial_step) begin
      VGS_retc=0;
      VGS_cnt = maxEv;
      VGD_retc=0;
      VGD_cnt = maxEv;
      VDS_retc=0;
      VDS_cnt = maxEv;
      VDB_retc=0;
      VDB_cnt = maxEv;
      VDHW_retc=0;
      VDHW_cnt = maxEv;
   end
   V_D_HW = V(D,HW);
   V_D_B = V(D,B);
   V_D_S = V(D,S);
   V_G_D = V(G,D);
   V_G_S = V(G,S);

//      VGS
   VGS = V_G_S;
   if((VGS_cnt>0) || ( maxEv_flg==0 ))   begin
      if( (VGS < -5.5) && (VGS_retc!=-1))
      begin
        outfile=$fopen(errFileName,"a");
        $strobe("nmvb          VGS     leaving   OCA (  .. -5.500 V ) at %7.4r  %M", $abstime );
        $fwrite(outfile,"nmvb          VGS     leaving   OCA (  .. -5.500 V ) at %7.4r  %M\n", $abstime );
        VGS_retc=-1;
        VGS_cnt=VGS_cnt-1;
        $fclose(outfile);
      end
      if((VGS >= -5.5) &&  (VGS <= 5.5) && (VGS_retc!=0))
      begin
        outfile=$fopen(errFileName,"a");
        $strobe("nmvb          VGS     entering SOCA ( -5.500 V .. 5.500 V ) at %7.4r  %M", $abstime );
        $fwrite(outfile,"nmvb          VGS     entering SOCA ( -5.500 V .. 5.500 V ) at %7.4r  %M\n", $abstime );
        VGS_retc=0;
        VGS_cnt=VGS_cnt-1;
        $fclose(outfile);
      end
      if((VGS > 5.5) &&  (VGS_retc!=1))
      begin
        outfile=$fopen(errFileName,"a");
        $strobe("nmvb          VGS     leaving   OCA ( 5.500 V ..  ) at %7.4r  %M", $abstime );
        $fwrite(outfile,"nmvb          VGS     leaving   OCA ( 5.500 V ..  ) at %7.4r  %M\n", $abstime );
        VGS_retc=1;
        VGS_cnt=VGS_cnt-1;
        $fclose(outfile);
      end
   end
   else
   begin
      if(VGS_cnt==0)
      begin
        outfile=$fopen(errFileName,"a");
        $strobe("nmvb          VGS     error limit ( %d ) reached at %7.4r  %M", maxEv, $abstime );
        $fwrite(outfile,"nmvb          VGS     error limit ( %d ) reached at %7.4r  %M\n", maxEv, $abstime );
        VGS_cnt=VGS_cnt-1;
        $fclose(outfile);
      end
   end

//      VGD
   VGD = V_G_D;
   if((VGD_cnt>0) || ( maxEv_flg==0 ))   begin
      if( (VGD < -12) && (VGD_retc!=-1))
      begin
        outfile=$fopen(errFileName,"a");
        $strobe("nmvb          VGD     leaving   OCA (  .. -12.000 V ) at %7.4r  %M", $abstime );
        $fwrite(outfile,"nmvb          VGD     leaving   OCA (  .. -12.000 V ) at %7.4r  %M\n", $abstime );
        VGD_retc=-1;
        VGD_cnt=VGD_cnt-1;
        $fclose(outfile);
      end
      if((VGD >= -12) &&  (VGD <= 5.5) && (VGD_retc!=0))
      begin
        outfile=$fopen(errFileName,"a");
        $strobe("nmvb          VGD     entering SOCA ( -12.000 V .. 5.500 V ) at %7.4r  %M", $abstime );
        $fwrite(outfile,"nmvb          VGD     entering SOCA ( -12.000 V .. 5.500 V ) at %7.4r  %M\n", $abstime );
        VGD_retc=0;
        VGD_cnt=VGD_cnt-1;
        $fclose(outfile);
      end
      if((VGD > 5.5) &&  (VGD_retc!=1))
      begin
        outfile=$fopen(errFileName,"a");
        $strobe("nmvb          VGD     leaving   OCA ( 5.500 V ..  ) at %7.4r  %M", $abstime );
        $fwrite(outfile,"nmvb          VGD     leaving   OCA ( 5.500 V ..  ) at %7.4r  %M\n", $abstime );
        VGD_retc=1;
        VGD_cnt=VGD_cnt-1;
        $fclose(outfile);
      end
   end
   else
   begin
      if(VGD_cnt==0)
      begin
        outfile=$fopen(errFileName,"a");
        $strobe("nmvb          VGD     error limit ( %d ) reached at %7.4r  %M", maxEv, $abstime );
        $fwrite(outfile,"nmvb          VGD     error limit ( %d ) reached at %7.4r  %M\n", maxEv, $abstime );
        VGD_cnt=VGD_cnt-1;
        $fclose(outfile);
      end
   end

//      VDS
   VDS = V_D_S;
   if((VDS_cnt>0) || ( maxEv_flg==0 ))   begin
      if( (VDS < -1.5) && (VDS_retc!=-1))
      begin
        outfile=$fopen(errFileName,"a");
        $strobe("nmvb          VDS     leaving   OCA (  .. -1.500 V ) at %7.4r  %M", $abstime );
        $fwrite(outfile,"nmvb          VDS     leaving   OCA (  .. -1.500 V ) at %7.4r  %M\n", $abstime );
        VDS_retc=-1;
        VDS_cnt=VDS_cnt-1;
        $fclose(outfile);
      end
      if((VDS >= -1.5) &&  (VDS <= 12) && (VDS_retc!=0))
      begin
        outfile=$fopen(errFileName,"a");
        $strobe("nmvb          VDS     entering SOCA ( -1.500 V .. 12.000 V ) at %7.4r  %M", $abstime );
        $fwrite(outfile,"nmvb          VDS     entering SOCA ( -1.500 V .. 12.000 V ) at %7.4r  %M\n", $abstime );
        VDS_retc=0;
        VDS_cnt=VDS_cnt-1;
        $fclose(outfile);
      end
      if((VDS > 12) &&  (VDS_retc!=1))
      begin
        outfile=$fopen(errFileName,"a");
        $strobe("nmvb          VDS     leaving   OCA ( 12.000 V ..  ) at %7.4r  %M", $abstime );
        $fwrite(outfile,"nmvb          VDS     leaving   OCA ( 12.000 V ..  ) at %7.4r  %M\n", $abstime );
        VDS_retc=1;
        VDS_cnt=VDS_cnt-1;
        $fclose(outfile);
      end
   end
   else
   begin
      if(VDS_cnt==0)
      begin
        outfile=$fopen(errFileName,"a");
        $strobe("nmvb          VDS     error limit ( %d ) reached at %7.4r  %M", maxEv, $abstime );
        $fwrite(outfile,"nmvb          VDS     error limit ( %d ) reached at %7.4r  %M\n", maxEv, $abstime );
        VDS_cnt=VDS_cnt-1;
        $fclose(outfile);
      end
   end

//      VDB
   VDB = V_D_B;
   if((VDB_cnt>0) || ( maxEv_flg==0 ))   begin
      if( (VDB < -1.5) && (VDB_retc!=-1))
      begin
        outfile=$fopen(errFileName,"a");
        $strobe("nmvb          VDB     leaving   OCA (  .. -1.500 V ) at %7.4r  %M", $abstime );
        $fwrite(outfile,"nmvb          VDB     leaving   OCA (  .. -1.500 V ) at %7.4r  %M\n", $abstime );
        VDB_retc=-1;
        VDB_cnt=VDB_cnt-1;
        $fclose(outfile);
      end
      if((VDB >= -1.5) &&  (VDB <= 12) && (VDB_retc!=0))
      begin
        outfile=$fopen(errFileName,"a");
        $strobe("nmvb          VDB     entering SOCA ( -1.500 V .. 12.000 V ) at %7.4r  %M", $abstime );
        $fwrite(outfile,"nmvb          VDB     entering SOCA ( -1.500 V .. 12.000 V ) at %7.4r  %M\n", $abstime );
        VDB_retc=0;
        VDB_cnt=VDB_cnt-1;
        $fclose(outfile);
      end
      if((VDB > 12) &&  (VDB_retc!=1))
      begin
        outfile=$fopen(errFileName,"a");
        $strobe("nmvb          VDB     leaving   OCA ( 12.000 V ..  ) at %7.4r  %M", $abstime );
        $fwrite(outfile,"nmvb          VDB     leaving   OCA ( 12.000 V ..  ) at %7.4r  %M\n", $abstime );
        VDB_retc=1;
        VDB_cnt=VDB_cnt-1;
        $fclose(outfile);
      end
   end
   else
   begin
      if(VDB_cnt==0)
      begin
        outfile=$fopen(errFileName,"a");
        $strobe("nmvb          VDB     error limit ( %d ) reached at %7.4r  %M", maxEv, $abstime );
        $fwrite(outfile,"nmvb          VDB     error limit ( %d ) reached at %7.4r  %M\n", maxEv, $abstime );
        VDB_cnt=VDB_cnt-1;
        $fclose(outfile);
      end
   end

//      VDHW
   VDHW = V_D_HW;
   if((VDHW_cnt>0) || ( maxEv_flg==0 ))   begin
      if( (VDHW < -25) && (VDHW_retc!=-1))
      begin
        outfile=$fopen(errFileName,"a");
        $strobe("nmvb          VDHW    leaving   OCA (  .. -25.000 V ) at %7.4r  %M", $abstime );
        $fwrite(outfile,"nmvb          VDHW    leaving   OCA (  .. -25.000 V ) at %7.4r  %M\n", $abstime );
        VDHW_retc=-1;
        VDHW_cnt=VDHW_cnt-1;
        $fclose(outfile);
      end
      if((VDHW >= -25) &&  (VDHW <= 400) && (VDHW_retc!=0))
      begin
        outfile=$fopen(errFileName,"a");
        $strobe("nmvb          VDHW    entering SOCA ( -25.000 V .. 400.000 V ) at %7.4r  %M", $abstime );
        $fwrite(outfile,"nmvb          VDHW    entering SOCA ( -25.000 V .. 400.000 V ) at %7.4r  %M\n", $abstime );
        VDHW_retc=0;
        VDHW_cnt=VDHW_cnt-1;
        $fclose(outfile);
      end
      if((VDHW > 400) &&  (VDHW_retc!=1))
      begin
        outfile=$fopen(errFileName,"a");
        $strobe("nmvb          VDHW    leaving   OCA ( 400.000 V ..  ) at %7.4r  %M", $abstime );
        $fwrite(outfile,"nmvb          VDHW    leaving   OCA ( 400.000 V ..  ) at %7.4r  %M\n", $abstime );
        VDHW_retc=1;
        VDHW_cnt=VDHW_cnt-1;
        $fclose(outfile);
      end
   end
   else
   begin
      if(VDHW_cnt==0)
      begin
        outfile=$fopen(errFileName,"a");
        $strobe("nmvb          VDHW    error limit ( %d ) reached at %7.4r  %M", maxEv, $abstime );
        $fwrite(outfile,"nmvb          VDHW    error limit ( %d ) reached at %7.4r  %M\n", maxEv, $abstime );
        VDHW_cnt=VDHW_cnt-1;
        $fclose(outfile);
      end
   end

end // analog
endmodule // nmvb

// Verilog-A OC Watch for device nmvc Parameters  VGS VGD VDS VDB VDHW
module nmvc_ahdl(D,G,S,B,HW);
parameter tstep_occ=100n;
parameter errFileName="./occ.err";
parameter maxEv = 25;
parameter maxEv_flg = 0;
inout D,G,S,B,HW;
electrical D,G,S,B,HW;

integer outfile;
real V_D_HW;
real V_D_B;
real V_D_S;
real V_G_D;
real V_G_S;
real VGS;
integer VGS_retc;
integer VGS_cnt;
real VGD;
integer VGD_retc;
integer VGD_cnt;
real VDS;
integer VDS_retc;
integer VDS_cnt;
real VDB;
integer VDB_retc;
integer VDB_cnt;
real VDHW;
integer VDHW_retc;
integer VDHW_cnt;

analog begin
   $bound_step( tstep_occ );
   @(initial_step) begin
      VGS_retc=0;
      VGS_cnt = maxEv;
      VGD_retc=0;
      VGD_cnt = maxEv;
      VDS_retc=0;
      VDS_cnt = maxEv;
      VDB_retc=0;
      VDB_cnt = maxEv;
      VDHW_retc=0;
      VDHW_cnt = maxEv;
   end
   V_D_HW = V(D,HW);
   V_D_B = V(D,B);
   V_D_S = V(D,S);
   V_G_D = V(G,D);
   V_G_S = V(G,S);

//      VGS
   VGS = V_G_S;
   if((VGS_cnt>0) || ( maxEv_flg==0 ))   begin
      if( (VGS < -5.5) && (VGS_retc!=-1))
      begin
        outfile=$fopen(errFileName,"a");
        $strobe("nmvc          VGS     leaving   OCA (  .. -5.500 V ) at %7.4r  %M", $abstime );
        $fwrite(outfile,"nmvc          VGS     leaving   OCA (  .. -5.500 V ) at %7.4r  %M\n", $abstime );
        VGS_retc=-1;
        VGS_cnt=VGS_cnt-1;
        $fclose(outfile);
      end
      if((VGS >= -5.5) &&  (VGS <= 5.5) && (VGS_retc!=0))
      begin
        outfile=$fopen(errFileName,"a");
        $strobe("nmvc          VGS     entering SOCA ( -5.500 V .. 5.500 V ) at %7.4r  %M", $abstime );
        $fwrite(outfile,"nmvc          VGS     entering SOCA ( -5.500 V .. 5.500 V ) at %7.4r  %M\n", $abstime );
        VGS_retc=0;
        VGS_cnt=VGS_cnt-1;
        $fclose(outfile);
      end
      if((VGS > 5.5) &&  (VGS_retc!=1))
      begin
        outfile=$fopen(errFileName,"a");
        $strobe("nmvc          VGS     leaving   OCA ( 5.500 V ..  ) at %7.4r  %M", $abstime );
        $fwrite(outfile,"nmvc          VGS     leaving   OCA ( 5.500 V ..  ) at %7.4r  %M\n", $abstime );
        VGS_retc=1;
        VGS_cnt=VGS_cnt-1;
        $fclose(outfile);
      end
   end
   else
   begin
      if(VGS_cnt==0)
      begin
        outfile=$fopen(errFileName,"a");
        $strobe("nmvc          VGS     error limit ( %d ) reached at %7.4r  %M", maxEv, $abstime );
        $fwrite(outfile,"nmvc          VGS     error limit ( %d ) reached at %7.4r  %M\n", maxEv, $abstime );
        VGS_cnt=VGS_cnt-1;
        $fclose(outfile);
      end
   end

//      VGD
   VGD = V_G_D;
   if((VGD_cnt>0) || ( maxEv_flg==0 ))   begin
      if( (VGD < -15) && (VGD_retc!=-1))
      begin
        outfile=$fopen(errFileName,"a");
        $strobe("nmvc          VGD     leaving   OCA (  .. -15.000 V ) at %7.4r  %M", $abstime );
        $fwrite(outfile,"nmvc          VGD     leaving   OCA (  .. -15.000 V ) at %7.4r  %M\n", $abstime );
        VGD_retc=-1;
        VGD_cnt=VGD_cnt-1;
        $fclose(outfile);
      end
      if((VGD >= -15) &&  (VGD <= 5.5) && (VGD_retc!=0))
      begin
        outfile=$fopen(errFileName,"a");
        $strobe("nmvc          VGD     entering SOCA ( -15.000 V .. 5.500 V ) at %7.4r  %M", $abstime );
        $fwrite(outfile,"nmvc          VGD     entering SOCA ( -15.000 V .. 5.500 V ) at %7.4r  %M\n", $abstime );
        VGD_retc=0;
        VGD_cnt=VGD_cnt-1;
        $fclose(outfile);
      end
      if((VGD > 5.5) &&  (VGD_retc!=1))
      begin
        outfile=$fopen(errFileName,"a");
        $strobe("nmvc          VGD     leaving   OCA ( 5.500 V ..  ) at %7.4r  %M", $abstime );
        $fwrite(outfile,"nmvc          VGD     leaving   OCA ( 5.500 V ..  ) at %7.4r  %M\n", $abstime );
        VGD_retc=1;
        VGD_cnt=VGD_cnt-1;
        $fclose(outfile);
      end
   end
   else
   begin
      if(VGD_cnt==0)
      begin
        outfile=$fopen(errFileName,"a");
        $strobe("nmvc          VGD     error limit ( %d ) reached at %7.4r  %M", maxEv, $abstime );
        $fwrite(outfile,"nmvc          VGD     error limit ( %d ) reached at %7.4r  %M\n", maxEv, $abstime );
        VGD_cnt=VGD_cnt-1;
        $fclose(outfile);
      end
   end

//      VDS
   VDS = V_D_S;
   if((VDS_cnt>0) || ( maxEv_flg==0 ))   begin
      if( (VDS < -1.5) && (VDS_retc!=-1))
      begin
        outfile=$fopen(errFileName,"a");
        $strobe("nmvc          VDS     leaving   OCA (  .. -1.500 V ) at %7.4r  %M", $abstime );
        $fwrite(outfile,"nmvc          VDS     leaving   OCA (  .. -1.500 V ) at %7.4r  %M\n", $abstime );
        VDS_retc=-1;
        VDS_cnt=VDS_cnt-1;
        $fclose(outfile);
      end
      if((VDS >= -1.5) &&  (VDS <= 15) && (VDS_retc!=0))
      begin
        outfile=$fopen(errFileName,"a");
        $strobe("nmvc          VDS     entering SOCA ( -1.500 V .. 15.000 V ) at %7.4r  %M", $abstime );
        $fwrite(outfile,"nmvc          VDS     entering SOCA ( -1.500 V .. 15.000 V ) at %7.4r  %M\n", $abstime );
        VDS_retc=0;
        VDS_cnt=VDS_cnt-1;
        $fclose(outfile);
      end
      if((VDS > 15) &&  (VDS_retc!=1))
      begin
        outfile=$fopen(errFileName,"a");
        $strobe("nmvc          VDS     leaving   OCA ( 15.000 V ..  ) at %7.4r  %M", $abstime );
        $fwrite(outfile,"nmvc          VDS     leaving   OCA ( 15.000 V ..  ) at %7.4r  %M\n", $abstime );
        VDS_retc=1;
        VDS_cnt=VDS_cnt-1;
        $fclose(outfile);
      end
   end
   else
   begin
      if(VDS_cnt==0)
      begin
        outfile=$fopen(errFileName,"a");
        $strobe("nmvc          VDS     error limit ( %d ) reached at %7.4r  %M", maxEv, $abstime );
        $fwrite(outfile,"nmvc          VDS     error limit ( %d ) reached at %7.4r  %M\n", maxEv, $abstime );
        VDS_cnt=VDS_cnt-1;
        $fclose(outfile);
      end
   end

//      VDB
   VDB = V_D_B;
   if((VDB_cnt>0) || ( maxEv_flg==0 ))   begin
      if( (VDB < -1.5) && (VDB_retc!=-1))
      begin
        outfile=$fopen(errFileName,"a");
        $strobe("nmvc          VDB     leaving   OCA (  .. -1.500 V ) at %7.4r  %M", $abstime );
        $fwrite(outfile,"nmvc          VDB     leaving   OCA (  .. -1.500 V ) at %7.4r  %M\n", $abstime );
        VDB_retc=-1;
        VDB_cnt=VDB_cnt-1;
        $fclose(outfile);
      end
      if((VDB >= -1.5) &&  (VDB <= 15) && (VDB_retc!=0))
      begin
        outfile=$fopen(errFileName,"a");
        $strobe("nmvc          VDB     entering SOCA ( -1.500 V .. 15.000 V ) at %7.4r  %M", $abstime );
        $fwrite(outfile,"nmvc          VDB     entering SOCA ( -1.500 V .. 15.000 V ) at %7.4r  %M\n", $abstime );
        VDB_retc=0;
        VDB_cnt=VDB_cnt-1;
        $fclose(outfile);
      end
      if((VDB > 15) &&  (VDB_retc!=1))
      begin
        outfile=$fopen(errFileName,"a");
        $strobe("nmvc          VDB     leaving   OCA ( 15.000 V ..  ) at %7.4r  %M", $abstime );
        $fwrite(outfile,"nmvc          VDB     leaving   OCA ( 15.000 V ..  ) at %7.4r  %M\n", $abstime );
        VDB_retc=1;
        VDB_cnt=VDB_cnt-1;
        $fclose(outfile);
      end
   end
   else
   begin
      if(VDB_cnt==0)
      begin
        outfile=$fopen(errFileName,"a");
        $strobe("nmvc          VDB     error limit ( %d ) reached at %7.4r  %M", maxEv, $abstime );
        $fwrite(outfile,"nmvc          VDB     error limit ( %d ) reached at %7.4r  %M\n", maxEv, $abstime );
        VDB_cnt=VDB_cnt-1;
        $fclose(outfile);
      end
   end

//      VDHW
   VDHW = V_D_HW;
   if((VDHW_cnt>0) || ( maxEv_flg==0 ))   begin
      if( (VDHW < -25) && (VDHW_retc!=-1))
      begin
        outfile=$fopen(errFileName,"a");
        $strobe("nmvc          VDHW    leaving   OCA (  .. -25.000 V ) at %7.4r  %M", $abstime );
        $fwrite(outfile,"nmvc          VDHW    leaving   OCA (  .. -25.000 V ) at %7.4r  %M\n", $abstime );
        VDHW_retc=-1;
        VDHW_cnt=VDHW_cnt-1;
        $fclose(outfile);
      end
      if((VDHW >= -25) &&  (VDHW <= 400) && (VDHW_retc!=0))
      begin
        outfile=$fopen(errFileName,"a");
        $strobe("nmvc          VDHW    entering SOCA ( -25.000 V .. 400.000 V ) at %7.4r  %M", $abstime );
        $fwrite(outfile,"nmvc          VDHW    entering SOCA ( -25.000 V .. 400.000 V ) at %7.4r  %M\n", $abstime );
        VDHW_retc=0;
        VDHW_cnt=VDHW_cnt-1;
        $fclose(outfile);
      end
      if((VDHW > 400) &&  (VDHW_retc!=1))
      begin
        outfile=$fopen(errFileName,"a");
        $strobe("nmvc          VDHW    leaving   OCA ( 400.000 V ..  ) at %7.4r  %M", $abstime );
        $fwrite(outfile,"nmvc          VDHW    leaving   OCA ( 400.000 V ..  ) at %7.4r  %M\n", $abstime );
        VDHW_retc=1;
        VDHW_cnt=VDHW_cnt-1;
        $fclose(outfile);
      end
   end
   else
   begin
      if(VDHW_cnt==0)
      begin
        outfile=$fopen(errFileName,"a");
        $strobe("nmvc          VDHW    error limit ( %d ) reached at %7.4r  %M", maxEv, $abstime );
        $fwrite(outfile,"nmvc          VDHW    error limit ( %d ) reached at %7.4r  %M\n", maxEv, $abstime );
        VDHW_cnt=VDHW_cnt-1;
        $fclose(outfile);
      end
   end

end // analog
endmodule // nmvc

// Verilog-A OC Watch for device nmvd Parameters  VGS VGD VDS VDB VDHW
module nmvd_ahdl(D,G,S,B,HW);
parameter tstep_occ=100n;
parameter errFileName="./occ.err";
parameter maxEv = 25;
parameter maxEv_flg = 0;
inout D,G,S,B,HW;
electrical D,G,S,B,HW;

integer outfile;
real V_D_HW;
real V_D_B;
real V_D_S;
real V_G_D;
real V_G_S;
real VGS;
integer VGS_retc;
integer VGS_cnt;
real VGD;
integer VGD_retc;
integer VGD_cnt;
real VDS;
integer VDS_retc;
integer VDS_cnt;
real VDB;
integer VDB_retc;
integer VDB_cnt;
real VDHW;
integer VDHW_retc;
integer VDHW_cnt;

analog begin
   $bound_step( tstep_occ );
   @(initial_step) begin
      VGS_retc=0;
      VGS_cnt = maxEv;
      VGD_retc=0;
      VGD_cnt = maxEv;
      VDS_retc=0;
      VDS_cnt = maxEv;
      VDB_retc=0;
      VDB_cnt = maxEv;
      VDHW_retc=0;
      VDHW_cnt = maxEv;
   end
   V_D_HW = V(D,HW);
   V_D_B = V(D,B);
   V_D_S = V(D,S);
   V_G_D = V(G,D);
   V_G_S = V(G,S);

//      VGS
   VGS = V_G_S;
   if((VGS_cnt>0) || ( maxEv_flg==0 ))   begin
      if( (VGS < -5.5) && (VGS_retc!=-1))
      begin
        outfile=$fopen(errFileName,"a");
        $strobe("nmvd          VGS     leaving   OCA (  .. -5.500 V ) at %7.4r  %M", $abstime );
        $fwrite(outfile,"nmvd          VGS     leaving   OCA (  .. -5.500 V ) at %7.4r  %M\n", $abstime );
        VGS_retc=-1;
        VGS_cnt=VGS_cnt-1;
        $fclose(outfile);
      end
      if((VGS >= -5.5) &&  (VGS <= 5.5) && (VGS_retc!=0))
      begin
        outfile=$fopen(errFileName,"a");
        $strobe("nmvd          VGS     entering SOCA ( -5.500 V .. 5.500 V ) at %7.4r  %M", $abstime );
        $fwrite(outfile,"nmvd          VGS     entering SOCA ( -5.500 V .. 5.500 V ) at %7.4r  %M\n", $abstime );
        VGS_retc=0;
        VGS_cnt=VGS_cnt-1;
        $fclose(outfile);
      end
      if((VGS > 5.5) &&  (VGS_retc!=1))
      begin
        outfile=$fopen(errFileName,"a");
        $strobe("nmvd          VGS     leaving   OCA ( 5.500 V ..  ) at %7.4r  %M", $abstime );
        $fwrite(outfile,"nmvd          VGS     leaving   OCA ( 5.500 V ..  ) at %7.4r  %M\n", $abstime );
        VGS_retc=1;
        VGS_cnt=VGS_cnt-1;
        $fclose(outfile);
      end
   end
   else
   begin
      if(VGS_cnt==0)
      begin
        outfile=$fopen(errFileName,"a");
        $strobe("nmvd          VGS     error limit ( %d ) reached at %7.4r  %M", maxEv, $abstime );
        $fwrite(outfile,"nmvd          VGS     error limit ( %d ) reached at %7.4r  %M\n", maxEv, $abstime );
        VGS_cnt=VGS_cnt-1;
        $fclose(outfile);
      end
   end

//      VGD
   VGD = V_G_D;
   if((VGD_cnt>0) || ( maxEv_flg==0 ))   begin
      if( (VGD < -20) && (VGD_retc!=-1))
      begin
        outfile=$fopen(errFileName,"a");
        $strobe("nmvd          VGD     leaving   OCA (  .. -20.000 V ) at %7.4r  %M", $abstime );
        $fwrite(outfile,"nmvd          VGD     leaving   OCA (  .. -20.000 V ) at %7.4r  %M\n", $abstime );
        VGD_retc=-1;
        VGD_cnt=VGD_cnt-1;
        $fclose(outfile);
      end
      if((VGD >= -20) &&  (VGD <= 5.5) && (VGD_retc!=0))
      begin
        outfile=$fopen(errFileName,"a");
        $strobe("nmvd          VGD     entering SOCA ( -20.000 V .. 5.500 V ) at %7.4r  %M", $abstime );
        $fwrite(outfile,"nmvd          VGD     entering SOCA ( -20.000 V .. 5.500 V ) at %7.4r  %M\n", $abstime );
        VGD_retc=0;
        VGD_cnt=VGD_cnt-1;
        $fclose(outfile);
      end
      if((VGD > 5.5) &&  (VGD_retc!=1))
      begin
        outfile=$fopen(errFileName,"a");
        $strobe("nmvd          VGD     leaving   OCA ( 5.500 V ..  ) at %7.4r  %M", $abstime );
        $fwrite(outfile,"nmvd          VGD     leaving   OCA ( 5.500 V ..  ) at %7.4r  %M\n", $abstime );
        VGD_retc=1;
        VGD_cnt=VGD_cnt-1;
        $fclose(outfile);
      end
   end
   else
   begin
      if(VGD_cnt==0)
      begin
        outfile=$fopen(errFileName,"a");
        $strobe("nmvd          VGD     error limit ( %d ) reached at %7.4r  %M", maxEv, $abstime );
        $fwrite(outfile,"nmvd          VGD     error limit ( %d ) reached at %7.4r  %M\n", maxEv, $abstime );
        VGD_cnt=VGD_cnt-1;
        $fclose(outfile);
      end
   end

//      VDS
   VDS = V_D_S;
   if((VDS_cnt>0) || ( maxEv_flg==0 ))   begin
      if( (VDS < -1.5) && (VDS_retc!=-1))
      begin
        outfile=$fopen(errFileName,"a");
        $strobe("nmvd          VDS     leaving   OCA (  .. -1.500 V ) at %7.4r  %M", $abstime );
        $fwrite(outfile,"nmvd          VDS     leaving   OCA (  .. -1.500 V ) at %7.4r  %M\n", $abstime );
        VDS_retc=-1;
        VDS_cnt=VDS_cnt-1;
        $fclose(outfile);
      end
      if((VDS >= -1.5) &&  (VDS <= 20) && (VDS_retc!=0))
      begin
        outfile=$fopen(errFileName,"a");
        $strobe("nmvd          VDS     entering SOCA ( -1.500 V .. 20.000 V ) at %7.4r  %M", $abstime );
        $fwrite(outfile,"nmvd          VDS     entering SOCA ( -1.500 V .. 20.000 V ) at %7.4r  %M\n", $abstime );
        VDS_retc=0;
        VDS_cnt=VDS_cnt-1;
        $fclose(outfile);
      end
      if((VDS > 20) &&  (VDS_retc!=1))
      begin
        outfile=$fopen(errFileName,"a");
        $strobe("nmvd          VDS     leaving   OCA ( 20.000 V ..  ) at %7.4r  %M", $abstime );
        $fwrite(outfile,"nmvd          VDS     leaving   OCA ( 20.000 V ..  ) at %7.4r  %M\n", $abstime );
        VDS_retc=1;
        VDS_cnt=VDS_cnt-1;
        $fclose(outfile);
      end
   end
   else
   begin
      if(VDS_cnt==0)
      begin
        outfile=$fopen(errFileName,"a");
        $strobe("nmvd          VDS     error limit ( %d ) reached at %7.4r  %M", maxEv, $abstime );
        $fwrite(outfile,"nmvd          VDS     error limit ( %d ) reached at %7.4r  %M\n", maxEv, $abstime );
        VDS_cnt=VDS_cnt-1;
        $fclose(outfile);
      end
   end

//      VDB
   VDB = V_D_B;
   if((VDB_cnt>0) || ( maxEv_flg==0 ))   begin
      if( (VDB < -1.5) && (VDB_retc!=-1))
      begin
        outfile=$fopen(errFileName,"a");
        $strobe("nmvd          VDB     leaving   OCA (  .. -1.500 V ) at %7.4r  %M", $abstime );
        $fwrite(outfile,"nmvd          VDB     leaving   OCA (  .. -1.500 V ) at %7.4r  %M\n", $abstime );
        VDB_retc=-1;
        VDB_cnt=VDB_cnt-1;
        $fclose(outfile);
      end
      if((VDB >= -1.5) &&  (VDB <= 20) && (VDB_retc!=0))
      begin
        outfile=$fopen(errFileName,"a");
        $strobe("nmvd          VDB     entering SOCA ( -1.500 V .. 20.000 V ) at %7.4r  %M", $abstime );
        $fwrite(outfile,"nmvd          VDB     entering SOCA ( -1.500 V .. 20.000 V ) at %7.4r  %M\n", $abstime );
        VDB_retc=0;
        VDB_cnt=VDB_cnt-1;
        $fclose(outfile);
      end
      if((VDB > 20) &&  (VDB_retc!=1))
      begin
        outfile=$fopen(errFileName,"a");
        $strobe("nmvd          VDB     leaving   OCA ( 20.000 V ..  ) at %7.4r  %M", $abstime );
        $fwrite(outfile,"nmvd          VDB     leaving   OCA ( 20.000 V ..  ) at %7.4r  %M\n", $abstime );
        VDB_retc=1;
        VDB_cnt=VDB_cnt-1;
        $fclose(outfile);
      end
   end
   else
   begin
      if(VDB_cnt==0)
      begin
        outfile=$fopen(errFileName,"a");
        $strobe("nmvd          VDB     error limit ( %d ) reached at %7.4r  %M", maxEv, $abstime );
        $fwrite(outfile,"nmvd          VDB     error limit ( %d ) reached at %7.4r  %M\n", maxEv, $abstime );
        VDB_cnt=VDB_cnt-1;
        $fclose(outfile);
      end
   end

//      VDHW
   VDHW = V_D_HW;
   if((VDHW_cnt>0) || ( maxEv_flg==0 ))   begin
      if( (VDHW < -25) && (VDHW_retc!=-1))
      begin
        outfile=$fopen(errFileName,"a");
        $strobe("nmvd          VDHW    leaving   OCA (  .. -25.000 V ) at %7.4r  %M", $abstime );
        $fwrite(outfile,"nmvd          VDHW    leaving   OCA (  .. -25.000 V ) at %7.4r  %M\n", $abstime );
        VDHW_retc=-1;
        VDHW_cnt=VDHW_cnt-1;
        $fclose(outfile);
      end
      if((VDHW >= -25) &&  (VDHW <= 400) && (VDHW_retc!=0))
      begin
        outfile=$fopen(errFileName,"a");
        $strobe("nmvd          VDHW    entering SOCA ( -25.000 V .. 400.000 V ) at %7.4r  %M", $abstime );
        $fwrite(outfile,"nmvd          VDHW    entering SOCA ( -25.000 V .. 400.000 V ) at %7.4r  %M\n", $abstime );
        VDHW_retc=0;
        VDHW_cnt=VDHW_cnt-1;
        $fclose(outfile);
      end
      if((VDHW > 400) &&  (VDHW_retc!=1))
      begin
        outfile=$fopen(errFileName,"a");
        $strobe("nmvd          VDHW    leaving   OCA ( 400.000 V ..  ) at %7.4r  %M", $abstime );
        $fwrite(outfile,"nmvd          VDHW    leaving   OCA ( 400.000 V ..  ) at %7.4r  %M\n", $abstime );
        VDHW_retc=1;
        VDHW_cnt=VDHW_cnt-1;
        $fclose(outfile);
      end
   end
   else
   begin
      if(VDHW_cnt==0)
      begin
        outfile=$fopen(errFileName,"a");
        $strobe("nmvd          VDHW    error limit ( %d ) reached at %7.4r  %M", maxEv, $abstime );
        $fwrite(outfile,"nmvd          VDHW    error limit ( %d ) reached at %7.4r  %M\n", maxEv, $abstime );
        VDHW_cnt=VDHW_cnt-1;
        $fclose(outfile);
      end
   end

end // analog
endmodule // nmvd

// Verilog-A OC Watch for device nmve Parameters  VGS VGD VDS VDB VDHW
module nmve_ahdl(D,G,S,B,HW);
parameter tstep_occ=100n;
parameter errFileName="./occ.err";
parameter maxEv = 25;
parameter maxEv_flg = 0;
inout D,G,S,B,HW;
electrical D,G,S,B,HW;

integer outfile;
real V_D_HW;
real V_D_B;
real V_D_S;
real V_G_D;
real V_G_S;
real VGS;
integer VGS_retc;
integer VGS_cnt;
real VGD;
integer VGD_retc;
integer VGD_cnt;
real VDS;
integer VDS_retc;
integer VDS_cnt;
real VDB;
integer VDB_retc;
integer VDB_cnt;
real VDHW;
integer VDHW_retc;
integer VDHW_cnt;

analog begin
   $bound_step( tstep_occ );
   @(initial_step) begin
      VGS_retc=0;
      VGS_cnt = maxEv;
      VGD_retc=0;
      VGD_cnt = maxEv;
      VDS_retc=0;
      VDS_cnt = maxEv;
      VDB_retc=0;
      VDB_cnt = maxEv;
      VDHW_retc=0;
      VDHW_cnt = maxEv;
   end
   V_D_HW = V(D,HW);
   V_D_B = V(D,B);
   V_D_S = V(D,S);
   V_G_D = V(G,D);
   V_G_S = V(G,S);

//      VGS
   VGS = V_G_S;
   if((VGS_cnt>0) || ( maxEv_flg==0 ))   begin
      if( (VGS < -5.5) && (VGS_retc!=-1))
      begin
        outfile=$fopen(errFileName,"a");
        $strobe("nmve          VGS     leaving   OCA (  .. -5.500 V ) at %7.4r  %M", $abstime );
        $fwrite(outfile,"nmve          VGS     leaving   OCA (  .. -5.500 V ) at %7.4r  %M\n", $abstime );
        VGS_retc=-1;
        VGS_cnt=VGS_cnt-1;
        $fclose(outfile);
      end
      if((VGS >= -5.5) &&  (VGS <= 5.5) && (VGS_retc!=0))
      begin
        outfile=$fopen(errFileName,"a");
        $strobe("nmve          VGS     entering SOCA ( -5.500 V .. 5.500 V ) at %7.4r  %M", $abstime );
        $fwrite(outfile,"nmve          VGS     entering SOCA ( -5.500 V .. 5.500 V ) at %7.4r  %M\n", $abstime );
        VGS_retc=0;
        VGS_cnt=VGS_cnt-1;
        $fclose(outfile);
      end
      if((VGS > 5.5) &&  (VGS_retc!=1))
      begin
        outfile=$fopen(errFileName,"a");
        $strobe("nmve          VGS     leaving   OCA ( 5.500 V ..  ) at %7.4r  %M", $abstime );
        $fwrite(outfile,"nmve          VGS     leaving   OCA ( 5.500 V ..  ) at %7.4r  %M\n", $abstime );
        VGS_retc=1;
        VGS_cnt=VGS_cnt-1;
        $fclose(outfile);
      end
   end
   else
   begin
      if(VGS_cnt==0)
      begin
        outfile=$fopen(errFileName,"a");
        $strobe("nmve          VGS     error limit ( %d ) reached at %7.4r  %M", maxEv, $abstime );
        $fwrite(outfile,"nmve          VGS     error limit ( %d ) reached at %7.4r  %M\n", maxEv, $abstime );
        VGS_cnt=VGS_cnt-1;
        $fclose(outfile);
      end
   end

//      VGD
   VGD = V_G_D;
   if((VGD_cnt>0) || ( maxEv_flg==0 ))   begin
      if( (VGD < -25) && (VGD_retc!=-1))
      begin
        outfile=$fopen(errFileName,"a");
        $strobe("nmve          VGD     leaving   OCA (  .. -25.000 V ) at %7.4r  %M", $abstime );
        $fwrite(outfile,"nmve          VGD     leaving   OCA (  .. -25.000 V ) at %7.4r  %M\n", $abstime );
        VGD_retc=-1;
        VGD_cnt=VGD_cnt-1;
        $fclose(outfile);
      end
      if((VGD >= -25) &&  (VGD <= 5.5) && (VGD_retc!=0))
      begin
        outfile=$fopen(errFileName,"a");
        $strobe("nmve          VGD     entering SOCA ( -25.000 V .. 5.500 V ) at %7.4r  %M", $abstime );
        $fwrite(outfile,"nmve          VGD     entering SOCA ( -25.000 V .. 5.500 V ) at %7.4r  %M\n", $abstime );
        VGD_retc=0;
        VGD_cnt=VGD_cnt-1;
        $fclose(outfile);
      end
      if((VGD > 5.5) &&  (VGD_retc!=1))
      begin
        outfile=$fopen(errFileName,"a");
        $strobe("nmve          VGD     leaving   OCA ( 5.500 V ..  ) at %7.4r  %M", $abstime );
        $fwrite(outfile,"nmve          VGD     leaving   OCA ( 5.500 V ..  ) at %7.4r  %M\n", $abstime );
        VGD_retc=1;
        VGD_cnt=VGD_cnt-1;
        $fclose(outfile);
      end
   end
   else
   begin
      if(VGD_cnt==0)
      begin
        outfile=$fopen(errFileName,"a");
        $strobe("nmve          VGD     error limit ( %d ) reached at %7.4r  %M", maxEv, $abstime );
        $fwrite(outfile,"nmve          VGD     error limit ( %d ) reached at %7.4r  %M\n", maxEv, $abstime );
        VGD_cnt=VGD_cnt-1;
        $fclose(outfile);
      end
   end

//      VDS
   VDS = V_D_S;
   if((VDS_cnt>0) || ( maxEv_flg==0 ))   begin
      if( (VDS < -1.5) && (VDS_retc!=-1))
      begin
        outfile=$fopen(errFileName,"a");
        $strobe("nmve          VDS     leaving   OCA (  .. -1.500 V ) at %7.4r  %M", $abstime );
        $fwrite(outfile,"nmve          VDS     leaving   OCA (  .. -1.500 V ) at %7.4r  %M\n", $abstime );
        VDS_retc=-1;
        VDS_cnt=VDS_cnt-1;
        $fclose(outfile);
      end
      if((VDS >= -1.5) &&  (VDS <= 25) && (VDS_retc!=0))
      begin
        outfile=$fopen(errFileName,"a");
        $strobe("nmve          VDS     entering SOCA ( -1.500 V .. 25.000 V ) at %7.4r  %M", $abstime );
        $fwrite(outfile,"nmve          VDS     entering SOCA ( -1.500 V .. 25.000 V ) at %7.4r  %M\n", $abstime );
        VDS_retc=0;
        VDS_cnt=VDS_cnt-1;
        $fclose(outfile);
      end
      if((VDS > 25) &&  (VDS_retc!=1))
      begin
        outfile=$fopen(errFileName,"a");
        $strobe("nmve          VDS     leaving   OCA ( 25.000 V ..  ) at %7.4r  %M", $abstime );
        $fwrite(outfile,"nmve          VDS     leaving   OCA ( 25.000 V ..  ) at %7.4r  %M\n", $abstime );
        VDS_retc=1;
        VDS_cnt=VDS_cnt-1;
        $fclose(outfile);
      end
   end
   else
   begin
      if(VDS_cnt==0)
      begin
        outfile=$fopen(errFileName,"a");
        $strobe("nmve          VDS     error limit ( %d ) reached at %7.4r  %M", maxEv, $abstime );
        $fwrite(outfile,"nmve          VDS     error limit ( %d ) reached at %7.4r  %M\n", maxEv, $abstime );
        VDS_cnt=VDS_cnt-1;
        $fclose(outfile);
      end
   end

//      VDB
   VDB = V_D_B;
   if((VDB_cnt>0) || ( maxEv_flg==0 ))   begin
      if( (VDB < -1.5) && (VDB_retc!=-1))
      begin
        outfile=$fopen(errFileName,"a");
        $strobe("nmve          VDB     leaving   OCA (  .. -1.500 V ) at %7.4r  %M", $abstime );
        $fwrite(outfile,"nmve          VDB     leaving   OCA (  .. -1.500 V ) at %7.4r  %M\n", $abstime );
        VDB_retc=-1;
        VDB_cnt=VDB_cnt-1;
        $fclose(outfile);
      end
      if((VDB >= -1.5) &&  (VDB <= 25) && (VDB_retc!=0))
      begin
        outfile=$fopen(errFileName,"a");
        $strobe("nmve          VDB     entering SOCA ( -1.500 V .. 25.000 V ) at %7.4r  %M", $abstime );
        $fwrite(outfile,"nmve          VDB     entering SOCA ( -1.500 V .. 25.000 V ) at %7.4r  %M\n", $abstime );
        VDB_retc=0;
        VDB_cnt=VDB_cnt-1;
        $fclose(outfile);
      end
      if((VDB > 25) &&  (VDB_retc!=1))
      begin
        outfile=$fopen(errFileName,"a");
        $strobe("nmve          VDB     leaving   OCA ( 25.000 V ..  ) at %7.4r  %M", $abstime );
        $fwrite(outfile,"nmve          VDB     leaving   OCA ( 25.000 V ..  ) at %7.4r  %M\n", $abstime );
        VDB_retc=1;
        VDB_cnt=VDB_cnt-1;
        $fclose(outfile);
      end
   end
   else
   begin
      if(VDB_cnt==0)
      begin
        outfile=$fopen(errFileName,"a");
        $strobe("nmve          VDB     error limit ( %d ) reached at %7.4r  %M", maxEv, $abstime );
        $fwrite(outfile,"nmve          VDB     error limit ( %d ) reached at %7.4r  %M\n", maxEv, $abstime );
        VDB_cnt=VDB_cnt-1;
        $fclose(outfile);
      end
   end

//      VDHW
   VDHW = V_D_HW;
   if((VDHW_cnt>0) || ( maxEv_flg==0 ))   begin
      if( (VDHW < -25) && (VDHW_retc!=-1))
      begin
        outfile=$fopen(errFileName,"a");
        $strobe("nmve          VDHW    leaving   OCA (  .. -25.000 V ) at %7.4r  %M", $abstime );
        $fwrite(outfile,"nmve          VDHW    leaving   OCA (  .. -25.000 V ) at %7.4r  %M\n", $abstime );
        VDHW_retc=-1;
        VDHW_cnt=VDHW_cnt-1;
        $fclose(outfile);
      end
      if((VDHW >= -25) &&  (VDHW <= 400) && (VDHW_retc!=0))
      begin
        outfile=$fopen(errFileName,"a");
        $strobe("nmve          VDHW    entering SOCA ( -25.000 V .. 400.000 V ) at %7.4r  %M", $abstime );
        $fwrite(outfile,"nmve          VDHW    entering SOCA ( -25.000 V .. 400.000 V ) at %7.4r  %M\n", $abstime );
        VDHW_retc=0;
        VDHW_cnt=VDHW_cnt-1;
        $fclose(outfile);
      end
      if((VDHW > 400) &&  (VDHW_retc!=1))
      begin
        outfile=$fopen(errFileName,"a");
        $strobe("nmve          VDHW    leaving   OCA ( 400.000 V ..  ) at %7.4r  %M", $abstime );
        $fwrite(outfile,"nmve          VDHW    leaving   OCA ( 400.000 V ..  ) at %7.4r  %M\n", $abstime );
        VDHW_retc=1;
        VDHW_cnt=VDHW_cnt-1;
        $fclose(outfile);
      end
   end
   else
   begin
      if(VDHW_cnt==0)
      begin
        outfile=$fopen(errFileName,"a");
        $strobe("nmve          VDHW    error limit ( %d ) reached at %7.4r  %M", maxEv, $abstime );
        $fwrite(outfile,"nmve          VDHW    error limit ( %d ) reached at %7.4r  %M\n", maxEv, $abstime );
        VDHW_cnt=VDHW_cnt-1;
        $fclose(outfile);
      end
   end

end // analog
endmodule // nmve

// Verilog-A OC Watch for device nmvf Parameters  VGS VGD VDS VDB VDHW
module nmvf_ahdl(D,G,S,B,HW);
parameter tstep_occ=100n;
parameter errFileName="./occ.err";
parameter maxEv = 25;
parameter maxEv_flg = 0;
inout D,G,S,B,HW;
electrical D,G,S,B,HW;

integer outfile;
real V_D_HW;
real V_D_B;
real V_D_S;
real V_G_D;
real V_G_S;
real VGS;
integer VGS_retc;
integer VGS_cnt;
real VGD;
integer VGD_retc;
integer VGD_cnt;
real VDS;
integer VDS_retc;
integer VDS_cnt;
real VDB;
integer VDB_retc;
integer VDB_cnt;
real VDHW;
integer VDHW_retc;
integer VDHW_cnt;

analog begin
   $bound_step( tstep_occ );
   @(initial_step) begin
      VGS_retc=0;
      VGS_cnt = maxEv;
      VGD_retc=0;
      VGD_cnt = maxEv;
      VDS_retc=0;
      VDS_cnt = maxEv;
      VDB_retc=0;
      VDB_cnt = maxEv;
      VDHW_retc=0;
      VDHW_cnt = maxEv;
   end
   V_D_HW = V(D,HW);
   V_D_B = V(D,B);
   V_D_S = V(D,S);
   V_G_D = V(G,D);
   V_G_S = V(G,S);

//      VGS
   VGS = V_G_S;
   if((VGS_cnt>0) || ( maxEv_flg==0 ))   begin
      if( (VGS < -5.5) && (VGS_retc!=-1))
      begin
        outfile=$fopen(errFileName,"a");
        $strobe("nmvf          VGS     leaving   OCA (  .. -5.500 V ) at %7.4r  %M", $abstime );
        $fwrite(outfile,"nmvf          VGS     leaving   OCA (  .. -5.500 V ) at %7.4r  %M\n", $abstime );
        VGS_retc=-1;
        VGS_cnt=VGS_cnt-1;
        $fclose(outfile);
      end
      if((VGS >= -5.5) &&  (VGS <= 5.5) && (VGS_retc!=0))
      begin
        outfile=$fopen(errFileName,"a");
        $strobe("nmvf          VGS     entering SOCA ( -5.500 V .. 5.500 V ) at %7.4r  %M", $abstime );
        $fwrite(outfile,"nmvf          VGS     entering SOCA ( -5.500 V .. 5.500 V ) at %7.4r  %M\n", $abstime );
        VGS_retc=0;
        VGS_cnt=VGS_cnt-1;
        $fclose(outfile);
      end
      if((VGS > 5.5) &&  (VGS_retc!=1))
      begin
        outfile=$fopen(errFileName,"a");
        $strobe("nmvf          VGS     leaving   OCA ( 5.500 V ..  ) at %7.4r  %M", $abstime );
        $fwrite(outfile,"nmvf          VGS     leaving   OCA ( 5.500 V ..  ) at %7.4r  %M\n", $abstime );
        VGS_retc=1;
        VGS_cnt=VGS_cnt-1;
        $fclose(outfile);
      end
   end
   else
   begin
      if(VGS_cnt==0)
      begin
        outfile=$fopen(errFileName,"a");
        $strobe("nmvf          VGS     error limit ( %d ) reached at %7.4r  %M", maxEv, $abstime );
        $fwrite(outfile,"nmvf          VGS     error limit ( %d ) reached at %7.4r  %M\n", maxEv, $abstime );
        VGS_cnt=VGS_cnt-1;
        $fclose(outfile);
      end
   end

//      VGD
   VGD = V_G_D;
   if((VGD_cnt>0) || ( maxEv_flg==0 ))   begin
      if( (VGD < -32) && (VGD_retc!=-1))
      begin
        outfile=$fopen(errFileName,"a");
        $strobe("nmvf          VGD     leaving   OCA (  .. -32.000 V ) at %7.4r  %M", $abstime );
        $fwrite(outfile,"nmvf          VGD     leaving   OCA (  .. -32.000 V ) at %7.4r  %M\n", $abstime );
        VGD_retc=-1;
        VGD_cnt=VGD_cnt-1;
        $fclose(outfile);
      end
      if((VGD >= -32) &&  (VGD <= 5.5) && (VGD_retc!=0))
      begin
        outfile=$fopen(errFileName,"a");
        $strobe("nmvf          VGD     entering SOCA ( -32.000 V .. 5.500 V ) at %7.4r  %M", $abstime );
        $fwrite(outfile,"nmvf          VGD     entering SOCA ( -32.000 V .. 5.500 V ) at %7.4r  %M\n", $abstime );
        VGD_retc=0;
        VGD_cnt=VGD_cnt-1;
        $fclose(outfile);
      end
      if((VGD > 5.5) &&  (VGD_retc!=1))
      begin
        outfile=$fopen(errFileName,"a");
        $strobe("nmvf          VGD     leaving   OCA ( 5.500 V ..  ) at %7.4r  %M", $abstime );
        $fwrite(outfile,"nmvf          VGD     leaving   OCA ( 5.500 V ..  ) at %7.4r  %M\n", $abstime );
        VGD_retc=1;
        VGD_cnt=VGD_cnt-1;
        $fclose(outfile);
      end
   end
   else
   begin
      if(VGD_cnt==0)
      begin
        outfile=$fopen(errFileName,"a");
        $strobe("nmvf          VGD     error limit ( %d ) reached at %7.4r  %M", maxEv, $abstime );
        $fwrite(outfile,"nmvf          VGD     error limit ( %d ) reached at %7.4r  %M\n", maxEv, $abstime );
        VGD_cnt=VGD_cnt-1;
        $fclose(outfile);
      end
   end

//      VDS
   VDS = V_D_S;
   if((VDS_cnt>0) || ( maxEv_flg==0 ))   begin
      if( (VDS < -1.5) && (VDS_retc!=-1))
      begin
        outfile=$fopen(errFileName,"a");
        $strobe("nmvf          VDS     leaving   OCA (  .. -1.500 V ) at %7.4r  %M", $abstime );
        $fwrite(outfile,"nmvf          VDS     leaving   OCA (  .. -1.500 V ) at %7.4r  %M\n", $abstime );
        VDS_retc=-1;
        VDS_cnt=VDS_cnt-1;
        $fclose(outfile);
      end
      if((VDS >= -1.5) &&  (VDS <= 32) && (VDS_retc!=0))
      begin
        outfile=$fopen(errFileName,"a");
        $strobe("nmvf          VDS     entering SOCA ( -1.500 V .. 32.000 V ) at %7.4r  %M", $abstime );
        $fwrite(outfile,"nmvf          VDS     entering SOCA ( -1.500 V .. 32.000 V ) at %7.4r  %M\n", $abstime );
        VDS_retc=0;
        VDS_cnt=VDS_cnt-1;
        $fclose(outfile);
      end
      if((VDS > 32) &&  (VDS_retc!=1))
      begin
        outfile=$fopen(errFileName,"a");
        $strobe("nmvf          VDS     leaving   OCA ( 32.000 V ..  ) at %7.4r  %M", $abstime );
        $fwrite(outfile,"nmvf          VDS     leaving   OCA ( 32.000 V ..  ) at %7.4r  %M\n", $abstime );
        VDS_retc=1;
        VDS_cnt=VDS_cnt-1;
        $fclose(outfile);
      end
   end
   else
   begin
      if(VDS_cnt==0)
      begin
        outfile=$fopen(errFileName,"a");
        $strobe("nmvf          VDS     error limit ( %d ) reached at %7.4r  %M", maxEv, $abstime );
        $fwrite(outfile,"nmvf          VDS     error limit ( %d ) reached at %7.4r  %M\n", maxEv, $abstime );
        VDS_cnt=VDS_cnt-1;
        $fclose(outfile);
      end
   end

//      VDB
   VDB = V_D_B;
   if((VDB_cnt>0) || ( maxEv_flg==0 ))   begin
      if( (VDB < -1.5) && (VDB_retc!=-1))
      begin
        outfile=$fopen(errFileName,"a");
        $strobe("nmvf          VDB     leaving   OCA (  .. -1.500 V ) at %7.4r  %M", $abstime );
        $fwrite(outfile,"nmvf          VDB     leaving   OCA (  .. -1.500 V ) at %7.4r  %M\n", $abstime );
        VDB_retc=-1;
        VDB_cnt=VDB_cnt-1;
        $fclose(outfile);
      end
      if((VDB >= -1.5) &&  (VDB <= 32) && (VDB_retc!=0))
      begin
        outfile=$fopen(errFileName,"a");
        $strobe("nmvf          VDB     entering SOCA ( -1.500 V .. 32.000 V ) at %7.4r  %M", $abstime );
        $fwrite(outfile,"nmvf          VDB     entering SOCA ( -1.500 V .. 32.000 V ) at %7.4r  %M\n", $abstime );
        VDB_retc=0;
        VDB_cnt=VDB_cnt-1;
        $fclose(outfile);
      end
      if((VDB > 32) &&  (VDB_retc!=1))
      begin
        outfile=$fopen(errFileName,"a");
        $strobe("nmvf          VDB     leaving   OCA ( 32.000 V ..  ) at %7.4r  %M", $abstime );
        $fwrite(outfile,"nmvf          VDB     leaving   OCA ( 32.000 V ..  ) at %7.4r  %M\n", $abstime );
        VDB_retc=1;
        VDB_cnt=VDB_cnt-1;
        $fclose(outfile);
      end
   end
   else
   begin
      if(VDB_cnt==0)
      begin
        outfile=$fopen(errFileName,"a");
        $strobe("nmvf          VDB     error limit ( %d ) reached at %7.4r  %M", maxEv, $abstime );
        $fwrite(outfile,"nmvf          VDB     error limit ( %d ) reached at %7.4r  %M\n", maxEv, $abstime );
        VDB_cnt=VDB_cnt-1;
        $fclose(outfile);
      end
   end

//      VDHW
   VDHW = V_D_HW;
   if((VDHW_cnt>0) || ( maxEv_flg==0 ))   begin
      if( (VDHW < -25) && (VDHW_retc!=-1))
      begin
        outfile=$fopen(errFileName,"a");
        $strobe("nmvf          VDHW    leaving   OCA (  .. -25.000 V ) at %7.4r  %M", $abstime );
        $fwrite(outfile,"nmvf          VDHW    leaving   OCA (  .. -25.000 V ) at %7.4r  %M\n", $abstime );
        VDHW_retc=-1;
        VDHW_cnt=VDHW_cnt-1;
        $fclose(outfile);
      end
      if((VDHW >= -25) &&  (VDHW <= 400) && (VDHW_retc!=0))
      begin
        outfile=$fopen(errFileName,"a");
        $strobe("nmvf          VDHW    entering SOCA ( -25.000 V .. 400.000 V ) at %7.4r  %M", $abstime );
        $fwrite(outfile,"nmvf          VDHW    entering SOCA ( -25.000 V .. 400.000 V ) at %7.4r  %M\n", $abstime );
        VDHW_retc=0;
        VDHW_cnt=VDHW_cnt-1;
        $fclose(outfile);
      end
      if((VDHW > 400) &&  (VDHW_retc!=1))
      begin
        outfile=$fopen(errFileName,"a");
        $strobe("nmvf          VDHW    leaving   OCA ( 400.000 V ..  ) at %7.4r  %M", $abstime );
        $fwrite(outfile,"nmvf          VDHW    leaving   OCA ( 400.000 V ..  ) at %7.4r  %M\n", $abstime );
        VDHW_retc=1;
        VDHW_cnt=VDHW_cnt-1;
        $fclose(outfile);
      end
   end
   else
   begin
      if(VDHW_cnt==0)
      begin
        outfile=$fopen(errFileName,"a");
        $strobe("nmvf          VDHW    error limit ( %d ) reached at %7.4r  %M", maxEv, $abstime );
        $fwrite(outfile,"nmvf          VDHW    error limit ( %d ) reached at %7.4r  %M\n", maxEv, $abstime );
        VDHW_cnt=VDHW_cnt-1;
        $fclose(outfile);
      end
   end

end // analog
endmodule // nmvf

// Verilog-A OC Watch for device ndmvd Parameters  VGS VGD VDS VDB VDHW
module ndmvd_ahdl(D,G,S,B,HW);
parameter tstep_occ=100n;
parameter errFileName="./occ.err";
parameter maxEv = 25;
parameter maxEv_flg = 0;
inout D,G,S,B,HW;
electrical D,G,S,B,HW;

integer outfile;
real V_D_HW;
real V_D_B;
real V_D_S;
real V_G_D;
real V_G_S;
real VGS;
integer VGS_retc;
integer VGS_cnt;
real VGD;
integer VGD_retc;
integer VGD_cnt;
real VDS;
integer VDS_retc;
integer VDS_cnt;
real VDB;
integer VDB_retc;
integer VDB_cnt;
real VDHW;
integer VDHW_retc;
integer VDHW_cnt;

analog begin
   $bound_step( tstep_occ );
   @(initial_step) begin
      VGS_retc=0;
      VGS_cnt = maxEv;
      VGD_retc=0;
      VGD_cnt = maxEv;
      VDS_retc=0;
      VDS_cnt = maxEv;
      VDB_retc=0;
      VDB_cnt = maxEv;
      VDHW_retc=0;
      VDHW_cnt = maxEv;
   end
   V_D_HW = V(D,HW);
   V_D_B = V(D,B);
   V_D_S = V(D,S);
   V_G_D = V(G,D);
   V_G_S = V(G,S);

//      VGS
   VGS = V_G_S;
   if((VGS_cnt>0) || ( maxEv_flg==0 ))   begin
      if( (VGS < -5.5) && (VGS_retc!=-1))
      begin
        outfile=$fopen(errFileName,"a");
        $strobe("ndmvd         VGS     leaving   OCA (  .. -5.500 V ) at %7.4r  %M", $abstime );
        $fwrite(outfile,"ndmvd         VGS     leaving   OCA (  .. -5.500 V ) at %7.4r  %M\n", $abstime );
        VGS_retc=-1;
        VGS_cnt=VGS_cnt-1;
        $fclose(outfile);
      end
      if((VGS >= -5.5) &&  (VGS <= 5.5) && (VGS_retc!=0))
      begin
        outfile=$fopen(errFileName,"a");
        $strobe("ndmvd         VGS     entering SOCA ( -5.500 V .. 5.500 V ) at %7.4r  %M", $abstime );
        $fwrite(outfile,"ndmvd         VGS     entering SOCA ( -5.500 V .. 5.500 V ) at %7.4r  %M\n", $abstime );
        VGS_retc=0;
        VGS_cnt=VGS_cnt-1;
        $fclose(outfile);
      end
      if((VGS > 5.5) &&  (VGS_retc!=1))
      begin
        outfile=$fopen(errFileName,"a");
        $strobe("ndmvd         VGS     leaving   OCA ( 5.500 V ..  ) at %7.4r  %M", $abstime );
        $fwrite(outfile,"ndmvd         VGS     leaving   OCA ( 5.500 V ..  ) at %7.4r  %M\n", $abstime );
        VGS_retc=1;
        VGS_cnt=VGS_cnt-1;
        $fclose(outfile);
      end
   end
   else
   begin
      if(VGS_cnt==0)
      begin
        outfile=$fopen(errFileName,"a");
        $strobe("ndmvd         VGS     error limit ( %d ) reached at %7.4r  %M", maxEv, $abstime );
        $fwrite(outfile,"ndmvd         VGS     error limit ( %d ) reached at %7.4r  %M\n", maxEv, $abstime );
        VGS_cnt=VGS_cnt-1;
        $fclose(outfile);
      end
   end

//      VGD
   VGD = V_G_D;
   if((VGD_cnt>0) || ( maxEv_flg==0 ))   begin
      if( (VGD < -20) && (VGD_retc!=-1))
      begin
        outfile=$fopen(errFileName,"a");
        $strobe("ndmvd         VGD     leaving   OCA (  .. -20.000 V ) at %7.4r  %M", $abstime );
        $fwrite(outfile,"ndmvd         VGD     leaving   OCA (  .. -20.000 V ) at %7.4r  %M\n", $abstime );
        VGD_retc=-1;
        VGD_cnt=VGD_cnt-1;
        $fclose(outfile);
      end
      if((VGD >= -20) &&  (VGD <= 5.5) && (VGD_retc!=0))
      begin
        outfile=$fopen(errFileName,"a");
        $strobe("ndmvd         VGD     entering SOCA ( -20.000 V .. 5.500 V ) at %7.4r  %M", $abstime );
        $fwrite(outfile,"ndmvd         VGD     entering SOCA ( -20.000 V .. 5.500 V ) at %7.4r  %M\n", $abstime );
        VGD_retc=0;
        VGD_cnt=VGD_cnt-1;
        $fclose(outfile);
      end
      if((VGD > 5.5) &&  (VGD_retc!=1))
      begin
        outfile=$fopen(errFileName,"a");
        $strobe("ndmvd         VGD     leaving   OCA ( 5.500 V ..  ) at %7.4r  %M", $abstime );
        $fwrite(outfile,"ndmvd         VGD     leaving   OCA ( 5.500 V ..  ) at %7.4r  %M\n", $abstime );
        VGD_retc=1;
        VGD_cnt=VGD_cnt-1;
        $fclose(outfile);
      end
   end
   else
   begin
      if(VGD_cnt==0)
      begin
        outfile=$fopen(errFileName,"a");
        $strobe("ndmvd         VGD     error limit ( %d ) reached at %7.4r  %M", maxEv, $abstime );
        $fwrite(outfile,"ndmvd         VGD     error limit ( %d ) reached at %7.4r  %M\n", maxEv, $abstime );
        VGD_cnt=VGD_cnt-1;
        $fclose(outfile);
      end
   end

//      VDS
   VDS = V_D_S;
   if((VDS_cnt>0) || ( maxEv_flg==0 ))   begin
      if( (VDS < -0.1) && (VDS_retc!=-1))
      begin
        outfile=$fopen(errFileName,"a");
        $strobe("ndmvd         VDS     leaving   OCA (  .. -0.100 V ) at %7.4r  %M", $abstime );
        $fwrite(outfile,"ndmvd         VDS     leaving   OCA (  .. -0.100 V ) at %7.4r  %M\n", $abstime );
        VDS_retc=-1;
        VDS_cnt=VDS_cnt-1;
        $fclose(outfile);
      end
      if((VDS >= -0.1) &&  (VDS <= 20) && (VDS_retc!=0))
      begin
        outfile=$fopen(errFileName,"a");
        $strobe("ndmvd         VDS     entering SOCA ( -0.100 V .. 20.000 V ) at %7.4r  %M", $abstime );
        $fwrite(outfile,"ndmvd         VDS     entering SOCA ( -0.100 V .. 20.000 V ) at %7.4r  %M\n", $abstime );
        VDS_retc=0;
        VDS_cnt=VDS_cnt-1;
        $fclose(outfile);
      end
      if((VDS > 20) &&  (VDS_retc!=1))
      begin
        outfile=$fopen(errFileName,"a");
        $strobe("ndmvd         VDS     leaving   OCA ( 20.000 V ..  ) at %7.4r  %M", $abstime );
        $fwrite(outfile,"ndmvd         VDS     leaving   OCA ( 20.000 V ..  ) at %7.4r  %M\n", $abstime );
        VDS_retc=1;
        VDS_cnt=VDS_cnt-1;
        $fclose(outfile);
      end
   end
   else
   begin
      if(VDS_cnt==0)
      begin
        outfile=$fopen(errFileName,"a");
        $strobe("ndmvd         VDS     error limit ( %d ) reached at %7.4r  %M", maxEv, $abstime );
        $fwrite(outfile,"ndmvd         VDS     error limit ( %d ) reached at %7.4r  %M\n", maxEv, $abstime );
        VDS_cnt=VDS_cnt-1;
        $fclose(outfile);
      end
   end

//      VDB
   VDB = V_D_B;
   if((VDB_cnt>0) || ( maxEv_flg==0 ))   begin
      if( (VDB < -0.1) && (VDB_retc!=-1))
      begin
        outfile=$fopen(errFileName,"a");
        $strobe("ndmvd         VDB     leaving   OCA (  .. -0.100 V ) at %7.4r  %M", $abstime );
        $fwrite(outfile,"ndmvd         VDB     leaving   OCA (  .. -0.100 V ) at %7.4r  %M\n", $abstime );
        VDB_retc=-1;
        VDB_cnt=VDB_cnt-1;
        $fclose(outfile);
      end
      if((VDB >= -0.1) &&  (VDB <= 20) && (VDB_retc!=0))
      begin
        outfile=$fopen(errFileName,"a");
        $strobe("ndmvd         VDB     entering SOCA ( -0.100 V .. 20.000 V ) at %7.4r  %M", $abstime );
        $fwrite(outfile,"ndmvd         VDB     entering SOCA ( -0.100 V .. 20.000 V ) at %7.4r  %M\n", $abstime );
        VDB_retc=0;
        VDB_cnt=VDB_cnt-1;
        $fclose(outfile);
      end
      if((VDB > 20) &&  (VDB_retc!=1))
      begin
        outfile=$fopen(errFileName,"a");
        $strobe("ndmvd         VDB     leaving   OCA ( 20.000 V ..  ) at %7.4r  %M", $abstime );
        $fwrite(outfile,"ndmvd         VDB     leaving   OCA ( 20.000 V ..  ) at %7.4r  %M\n", $abstime );
        VDB_retc=1;
        VDB_cnt=VDB_cnt-1;
        $fclose(outfile);
      end
   end
   else
   begin
      if(VDB_cnt==0)
      begin
        outfile=$fopen(errFileName,"a");
        $strobe("ndmvd         VDB     error limit ( %d ) reached at %7.4r  %M", maxEv, $abstime );
        $fwrite(outfile,"ndmvd         VDB     error limit ( %d ) reached at %7.4r  %M\n", maxEv, $abstime );
        VDB_cnt=VDB_cnt-1;
        $fclose(outfile);
      end
   end

//      VDHW
   VDHW = V_D_HW;
   if((VDHW_cnt>0) || ( maxEv_flg==0 ))   begin
      if( (VDHW < -25) && (VDHW_retc!=-1))
      begin
        outfile=$fopen(errFileName,"a");
        $strobe("ndmvd         VDHW    leaving   OCA (  .. -25.000 V ) at %7.4r  %M", $abstime );
        $fwrite(outfile,"ndmvd         VDHW    leaving   OCA (  .. -25.000 V ) at %7.4r  %M\n", $abstime );
        VDHW_retc=-1;
        VDHW_cnt=VDHW_cnt-1;
        $fclose(outfile);
      end
      if((VDHW >= -25) &&  (VDHW <= 400) && (VDHW_retc!=0))
      begin
        outfile=$fopen(errFileName,"a");
        $strobe("ndmvd         VDHW    entering SOCA ( -25.000 V .. 400.000 V ) at %7.4r  %M", $abstime );
        $fwrite(outfile,"ndmvd         VDHW    entering SOCA ( -25.000 V .. 400.000 V ) at %7.4r  %M\n", $abstime );
        VDHW_retc=0;
        VDHW_cnt=VDHW_cnt-1;
        $fclose(outfile);
      end
      if((VDHW > 400) &&  (VDHW_retc!=1))
      begin
        outfile=$fopen(errFileName,"a");
        $strobe("ndmvd         VDHW    leaving   OCA ( 400.000 V ..  ) at %7.4r  %M", $abstime );
        $fwrite(outfile,"ndmvd         VDHW    leaving   OCA ( 400.000 V ..  ) at %7.4r  %M\n", $abstime );
        VDHW_retc=1;
        VDHW_cnt=VDHW_cnt-1;
        $fclose(outfile);
      end
   end
   else
   begin
      if(VDHW_cnt==0)
      begin
        outfile=$fopen(errFileName,"a");
        $strobe("ndmvd         VDHW    error limit ( %d ) reached at %7.4r  %M", maxEv, $abstime );
        $fwrite(outfile,"ndmvd         VDHW    error limit ( %d ) reached at %7.4r  %M\n", maxEv, $abstime );
        VDHW_cnt=VDHW_cnt-1;
        $fclose(outfile);
      end
   end

end // analog
endmodule // ndmvd

// Verilog-A OC Watch for device ndmvf Parameters  VGS VGD VDS VDB VDHW
module ndmvf_ahdl(D,G,S,B,HW);
parameter tstep_occ=100n;
parameter errFileName="./occ.err";
parameter maxEv = 25;
parameter maxEv_flg = 0;
inout D,G,S,B,HW;
electrical D,G,S,B,HW;

integer outfile;
real V_D_HW;
real V_D_B;
real V_D_S;
real V_G_D;
real V_G_S;
real VGS;
integer VGS_retc;
integer VGS_cnt;
real VGD;
integer VGD_retc;
integer VGD_cnt;
real VDS;
integer VDS_retc;
integer VDS_cnt;
real VDB;
integer VDB_retc;
integer VDB_cnt;
real VDHW;
integer VDHW_retc;
integer VDHW_cnt;

analog begin
   $bound_step( tstep_occ );
   @(initial_step) begin
      VGS_retc=0;
      VGS_cnt = maxEv;
      VGD_retc=0;
      VGD_cnt = maxEv;
      VDS_retc=0;
      VDS_cnt = maxEv;
      VDB_retc=0;
      VDB_cnt = maxEv;
      VDHW_retc=0;
      VDHW_cnt = maxEv;
   end
   V_D_HW = V(D,HW);
   V_D_B = V(D,B);
   V_D_S = V(D,S);
   V_G_D = V(G,D);
   V_G_S = V(G,S);

//      VGS
   VGS = V_G_S;
   if((VGS_cnt>0) || ( maxEv_flg==0 ))   begin
      if( (VGS < -5.5) && (VGS_retc!=-1))
      begin
        outfile=$fopen(errFileName,"a");
        $strobe("ndmvf         VGS     leaving   OCA (  .. -5.500 V ) at %7.4r  %M", $abstime );
        $fwrite(outfile,"ndmvf         VGS     leaving   OCA (  .. -5.500 V ) at %7.4r  %M\n", $abstime );
        VGS_retc=-1;
        VGS_cnt=VGS_cnt-1;
        $fclose(outfile);
      end
      if((VGS >= -5.5) &&  (VGS <= 5.5) && (VGS_retc!=0))
      begin
        outfile=$fopen(errFileName,"a");
        $strobe("ndmvf         VGS     entering SOCA ( -5.500 V .. 5.500 V ) at %7.4r  %M", $abstime );
        $fwrite(outfile,"ndmvf         VGS     entering SOCA ( -5.500 V .. 5.500 V ) at %7.4r  %M\n", $abstime );
        VGS_retc=0;
        VGS_cnt=VGS_cnt-1;
        $fclose(outfile);
      end
      if((VGS > 5.5) &&  (VGS_retc!=1))
      begin
        outfile=$fopen(errFileName,"a");
        $strobe("ndmvf         VGS     leaving   OCA ( 5.500 V ..  ) at %7.4r  %M", $abstime );
        $fwrite(outfile,"ndmvf         VGS     leaving   OCA ( 5.500 V ..  ) at %7.4r  %M\n", $abstime );
        VGS_retc=1;
        VGS_cnt=VGS_cnt-1;
        $fclose(outfile);
      end
   end
   else
   begin
      if(VGS_cnt==0)
      begin
        outfile=$fopen(errFileName,"a");
        $strobe("ndmvf         VGS     error limit ( %d ) reached at %7.4r  %M", maxEv, $abstime );
        $fwrite(outfile,"ndmvf         VGS     error limit ( %d ) reached at %7.4r  %M\n", maxEv, $abstime );
        VGS_cnt=VGS_cnt-1;
        $fclose(outfile);
      end
   end

//      VGD
   VGD = V_G_D;
   if((VGD_cnt>0) || ( maxEv_flg==0 ))   begin
      if( (VGD < -32) && (VGD_retc!=-1))
      begin
        outfile=$fopen(errFileName,"a");
        $strobe("ndmvf         VGD     leaving   OCA (  .. -32.000 V ) at %7.4r  %M", $abstime );
        $fwrite(outfile,"ndmvf         VGD     leaving   OCA (  .. -32.000 V ) at %7.4r  %M\n", $abstime );
        VGD_retc=-1;
        VGD_cnt=VGD_cnt-1;
        $fclose(outfile);
      end
      if((VGD >= -32) &&  (VGD <= 5.5) && (VGD_retc!=0))
      begin
        outfile=$fopen(errFileName,"a");
        $strobe("ndmvf         VGD     entering SOCA ( -32.000 V .. 5.500 V ) at %7.4r  %M", $abstime );
        $fwrite(outfile,"ndmvf         VGD     entering SOCA ( -32.000 V .. 5.500 V ) at %7.4r  %M\n", $abstime );
        VGD_retc=0;
        VGD_cnt=VGD_cnt-1;
        $fclose(outfile);
      end
      if((VGD > 5.5) &&  (VGD_retc!=1))
      begin
        outfile=$fopen(errFileName,"a");
        $strobe("ndmvf         VGD     leaving   OCA ( 5.500 V ..  ) at %7.4r  %M", $abstime );
        $fwrite(outfile,"ndmvf         VGD     leaving   OCA ( 5.500 V ..  ) at %7.4r  %M\n", $abstime );
        VGD_retc=1;
        VGD_cnt=VGD_cnt-1;
        $fclose(outfile);
      end
   end
   else
   begin
      if(VGD_cnt==0)
      begin
        outfile=$fopen(errFileName,"a");
        $strobe("ndmvf         VGD     error limit ( %d ) reached at %7.4r  %M", maxEv, $abstime );
        $fwrite(outfile,"ndmvf         VGD     error limit ( %d ) reached at %7.4r  %M\n", maxEv, $abstime );
        VGD_cnt=VGD_cnt-1;
        $fclose(outfile);
      end
   end

//      VDS
   VDS = V_D_S;
   if((VDS_cnt>0) || ( maxEv_flg==0 ))   begin
      if( (VDS < -0.1) && (VDS_retc!=-1))
      begin
        outfile=$fopen(errFileName,"a");
        $strobe("ndmvf         VDS     leaving   OCA (  .. -0.100 V ) at %7.4r  %M", $abstime );
        $fwrite(outfile,"ndmvf         VDS     leaving   OCA (  .. -0.100 V ) at %7.4r  %M\n", $abstime );
        VDS_retc=-1;
        VDS_cnt=VDS_cnt-1;
        $fclose(outfile);
      end
      if((VDS >= -0.1) &&  (VDS <= 32) && (VDS_retc!=0))
      begin
        outfile=$fopen(errFileName,"a");
        $strobe("ndmvf         VDS     entering SOCA ( -0.100 V .. 32.000 V ) at %7.4r  %M", $abstime );
        $fwrite(outfile,"ndmvf         VDS     entering SOCA ( -0.100 V .. 32.000 V ) at %7.4r  %M\n", $abstime );
        VDS_retc=0;
        VDS_cnt=VDS_cnt-1;
        $fclose(outfile);
      end
      if((VDS > 32) &&  (VDS_retc!=1))
      begin
        outfile=$fopen(errFileName,"a");
        $strobe("ndmvf         VDS     leaving   OCA ( 32.000 V ..  ) at %7.4r  %M", $abstime );
        $fwrite(outfile,"ndmvf         VDS     leaving   OCA ( 32.000 V ..  ) at %7.4r  %M\n", $abstime );
        VDS_retc=1;
        VDS_cnt=VDS_cnt-1;
        $fclose(outfile);
      end
   end
   else
   begin
      if(VDS_cnt==0)
      begin
        outfile=$fopen(errFileName,"a");
        $strobe("ndmvf         VDS     error limit ( %d ) reached at %7.4r  %M", maxEv, $abstime );
        $fwrite(outfile,"ndmvf         VDS     error limit ( %d ) reached at %7.4r  %M\n", maxEv, $abstime );
        VDS_cnt=VDS_cnt-1;
        $fclose(outfile);
      end
   end

//      VDB
   VDB = V_D_B;
   if((VDB_cnt>0) || ( maxEv_flg==0 ))   begin
      if( (VDB < -0.1) && (VDB_retc!=-1))
      begin
        outfile=$fopen(errFileName,"a");
        $strobe("ndmvf         VDB     leaving   OCA (  .. -0.100 V ) at %7.4r  %M", $abstime );
        $fwrite(outfile,"ndmvf         VDB     leaving   OCA (  .. -0.100 V ) at %7.4r  %M\n", $abstime );
        VDB_retc=-1;
        VDB_cnt=VDB_cnt-1;
        $fclose(outfile);
      end
      if((VDB >= -0.1) &&  (VDB <= 32) && (VDB_retc!=0))
      begin
        outfile=$fopen(errFileName,"a");
        $strobe("ndmvf         VDB     entering SOCA ( -0.100 V .. 32.000 V ) at %7.4r  %M", $abstime );
        $fwrite(outfile,"ndmvf         VDB     entering SOCA ( -0.100 V .. 32.000 V ) at %7.4r  %M\n", $abstime );
        VDB_retc=0;
        VDB_cnt=VDB_cnt-1;
        $fclose(outfile);
      end
      if((VDB > 32) &&  (VDB_retc!=1))
      begin
        outfile=$fopen(errFileName,"a");
        $strobe("ndmvf         VDB     leaving   OCA ( 32.000 V ..  ) at %7.4r  %M", $abstime );
        $fwrite(outfile,"ndmvf         VDB     leaving   OCA ( 32.000 V ..  ) at %7.4r  %M\n", $abstime );
        VDB_retc=1;
        VDB_cnt=VDB_cnt-1;
        $fclose(outfile);
      end
   end
   else
   begin
      if(VDB_cnt==0)
      begin
        outfile=$fopen(errFileName,"a");
        $strobe("ndmvf         VDB     error limit ( %d ) reached at %7.4r  %M", maxEv, $abstime );
        $fwrite(outfile,"ndmvf         VDB     error limit ( %d ) reached at %7.4r  %M\n", maxEv, $abstime );
        VDB_cnt=VDB_cnt-1;
        $fclose(outfile);
      end
   end

//      VDHW
   VDHW = V_D_HW;
   if((VDHW_cnt>0) || ( maxEv_flg==0 ))   begin
      if( (VDHW < -25) && (VDHW_retc!=-1))
      begin
        outfile=$fopen(errFileName,"a");
        $strobe("ndmvf         VDHW    leaving   OCA (  .. -25.000 V ) at %7.4r  %M", $abstime );
        $fwrite(outfile,"ndmvf         VDHW    leaving   OCA (  .. -25.000 V ) at %7.4r  %M\n", $abstime );
        VDHW_retc=-1;
        VDHW_cnt=VDHW_cnt-1;
        $fclose(outfile);
      end
      if((VDHW >= -25) &&  (VDHW <= 400) && (VDHW_retc!=0))
      begin
        outfile=$fopen(errFileName,"a");
        $strobe("ndmvf         VDHW    entering SOCA ( -25.000 V .. 400.000 V ) at %7.4r  %M", $abstime );
        $fwrite(outfile,"ndmvf         VDHW    entering SOCA ( -25.000 V .. 400.000 V ) at %7.4r  %M\n", $abstime );
        VDHW_retc=0;
        VDHW_cnt=VDHW_cnt-1;
        $fclose(outfile);
      end
      if((VDHW > 400) &&  (VDHW_retc!=1))
      begin
        outfile=$fopen(errFileName,"a");
        $strobe("ndmvf         VDHW    leaving   OCA ( 400.000 V ..  ) at %7.4r  %M", $abstime );
        $fwrite(outfile,"ndmvf         VDHW    leaving   OCA ( 400.000 V ..  ) at %7.4r  %M\n", $abstime );
        VDHW_retc=1;
        VDHW_cnt=VDHW_cnt-1;
        $fclose(outfile);
      end
   end
   else
   begin
      if(VDHW_cnt==0)
      begin
        outfile=$fopen(errFileName,"a");
        $strobe("ndmvf         VDHW    error limit ( %d ) reached at %7.4r  %M", maxEv, $abstime );
        $fwrite(outfile,"ndmvf         VDHW    error limit ( %d ) reached at %7.4r  %M\n", maxEv, $abstime );
        VDHW_cnt=VDHW_cnt-1;
        $fclose(outfile);
      end
   end

end // analog
endmodule // ndmvf

// Verilog-A OC Watch for device pmvaa Parameters  VGS VGD VDS VDB
module pmvaa_ahdl(D,G,S,B);
parameter tstep_occ=100n;
parameter errFileName="./occ.err";
parameter maxEv = 25;
parameter maxEv_flg = 0;
inout D,G,S,B;
electrical D,G,S,B;

integer outfile;
real V_D_B;
real V_D_S;
real V_G_D;
real V_G_S;
real VGS;
integer VGS_retc;
integer VGS_cnt;
real VGD;
integer VGD_retc;
integer VGD_cnt;
real VDS;
integer VDS_retc;
integer VDS_cnt;
real VDB;
integer VDB_retc;
integer VDB_cnt;

analog begin
   $bound_step( tstep_occ );
   @(initial_step) begin
      VGS_retc=0;
      VGS_cnt = maxEv;
      VGD_retc=0;
      VGD_cnt = maxEv;
      VDS_retc=0;
      VDS_cnt = maxEv;
      VDB_retc=0;
      VDB_cnt = maxEv;
   end
   V_D_B = V(D,B);
   V_D_S = V(D,S);
   V_G_D = V(G,D);
   V_G_S = V(G,S);

//      VGS
   VGS = V_G_S;
   if((VGS_cnt>0) || ( maxEv_flg==0 ))   begin
      if( (VGS < -5.5) && (VGS_retc!=-1))
      begin
        outfile=$fopen(errFileName,"a");
        $strobe("pmvaa         VGS     leaving   OCA (  .. -5.500 V ) at %7.4r  %M", $abstime );
        $fwrite(outfile,"pmvaa         VGS     leaving   OCA (  .. -5.500 V ) at %7.4r  %M\n", $abstime );
        VGS_retc=-1;
        VGS_cnt=VGS_cnt-1;
        $fclose(outfile);
      end
      if((VGS >= -5.5) &&  (VGS <= 5.5) && (VGS_retc!=0))
      begin
        outfile=$fopen(errFileName,"a");
        $strobe("pmvaa         VGS     entering SOCA ( -5.500 V .. 5.500 V ) at %7.4r  %M", $abstime );
        $fwrite(outfile,"pmvaa         VGS     entering SOCA ( -5.500 V .. 5.500 V ) at %7.4r  %M\n", $abstime );
        VGS_retc=0;
        VGS_cnt=VGS_cnt-1;
        $fclose(outfile);
      end
      if((VGS > 5.5) &&  (VGS_retc!=1))
      begin
        outfile=$fopen(errFileName,"a");
        $strobe("pmvaa         VGS     leaving   OCA ( 5.500 V ..  ) at %7.4r  %M", $abstime );
        $fwrite(outfile,"pmvaa         VGS     leaving   OCA ( 5.500 V ..  ) at %7.4r  %M\n", $abstime );
        VGS_retc=1;
        VGS_cnt=VGS_cnt-1;
        $fclose(outfile);
      end
   end
   else
   begin
      if(VGS_cnt==0)
      begin
        outfile=$fopen(errFileName,"a");
        $strobe("pmvaa         VGS     error limit ( %d ) reached at %7.4r  %M", maxEv, $abstime );
        $fwrite(outfile,"pmvaa         VGS     error limit ( %d ) reached at %7.4r  %M\n", maxEv, $abstime );
        VGS_cnt=VGS_cnt-1;
        $fclose(outfile);
      end
   end

//      VGD
   VGD = V_G_D;
   if((VGD_cnt>0) || ( maxEv_flg==0 ))   begin
      if( (VGD < -5.5) && (VGD_retc!=-1))
      begin
        outfile=$fopen(errFileName,"a");
        $strobe("pmvaa         VGD     leaving   OCA (  .. -5.500 V ) at %7.4r  %M", $abstime );
        $fwrite(outfile,"pmvaa         VGD     leaving   OCA (  .. -5.500 V ) at %7.4r  %M\n", $abstime );
        VGD_retc=-1;
        VGD_cnt=VGD_cnt-1;
        $fclose(outfile);
      end
      if((VGD >= -5.5) &&  (VGD <= 10) && (VGD_retc!=0))
      begin
        outfile=$fopen(errFileName,"a");
        $strobe("pmvaa         VGD     entering SOCA ( -5.500 V .. 10.000 V ) at %7.4r  %M", $abstime );
        $fwrite(outfile,"pmvaa         VGD     entering SOCA ( -5.500 V .. 10.000 V ) at %7.4r  %M\n", $abstime );
        VGD_retc=0;
        VGD_cnt=VGD_cnt-1;
        $fclose(outfile);
      end
      if((VGD > 10) &&  (VGD_retc!=1))
      begin
        outfile=$fopen(errFileName,"a");
        $strobe("pmvaa         VGD     leaving   OCA ( 10.000 V ..  ) at %7.4r  %M", $abstime );
        $fwrite(outfile,"pmvaa         VGD     leaving   OCA ( 10.000 V ..  ) at %7.4r  %M\n", $abstime );
        VGD_retc=1;
        VGD_cnt=VGD_cnt-1;
        $fclose(outfile);
      end
   end
   else
   begin
      if(VGD_cnt==0)
      begin
        outfile=$fopen(errFileName,"a");
        $strobe("pmvaa         VGD     error limit ( %d ) reached at %7.4r  %M", maxEv, $abstime );
        $fwrite(outfile,"pmvaa         VGD     error limit ( %d ) reached at %7.4r  %M\n", maxEv, $abstime );
        VGD_cnt=VGD_cnt-1;
        $fclose(outfile);
      end
   end

//      VDS
   VDS = V_D_S;
   if((VDS_cnt>0) || ( maxEv_flg==0 ))   begin
      if( (VDS < -10) && (VDS_retc!=-1))
      begin
        outfile=$fopen(errFileName,"a");
        $strobe("pmvaa         VDS     leaving   OCA (  .. -10.000 V ) at %7.4r  %M", $abstime );
        $fwrite(outfile,"pmvaa         VDS     leaving   OCA (  .. -10.000 V ) at %7.4r  %M\n", $abstime );
        VDS_retc=-1;
        VDS_cnt=VDS_cnt-1;
        $fclose(outfile);
      end
      if((VDS >= -10) &&  (VDS <= 1.5) && (VDS_retc!=0))
      begin
        outfile=$fopen(errFileName,"a");
        $strobe("pmvaa         VDS     entering SOCA ( -10.000 V .. 1.500 V ) at %7.4r  %M", $abstime );
        $fwrite(outfile,"pmvaa         VDS     entering SOCA ( -10.000 V .. 1.500 V ) at %7.4r  %M\n", $abstime );
        VDS_retc=0;
        VDS_cnt=VDS_cnt-1;
        $fclose(outfile);
      end
      if((VDS > 1.5) &&  (VDS_retc!=1))
      begin
        outfile=$fopen(errFileName,"a");
        $strobe("pmvaa         VDS     leaving   OCA ( 1.500 V ..  ) at %7.4r  %M", $abstime );
        $fwrite(outfile,"pmvaa         VDS     leaving   OCA ( 1.500 V ..  ) at %7.4r  %M\n", $abstime );
        VDS_retc=1;
        VDS_cnt=VDS_cnt-1;
        $fclose(outfile);
      end
   end
   else
   begin
      if(VDS_cnt==0)
      begin
        outfile=$fopen(errFileName,"a");
        $strobe("pmvaa         VDS     error limit ( %d ) reached at %7.4r  %M", maxEv, $abstime );
        $fwrite(outfile,"pmvaa         VDS     error limit ( %d ) reached at %7.4r  %M\n", maxEv, $abstime );
        VDS_cnt=VDS_cnt-1;
        $fclose(outfile);
      end
   end

//      VDB
   VDB = V_D_B;
   if((VDB_cnt>0) || ( maxEv_flg==0 ))   begin
      if( (VDB < -10) && (VDB_retc!=-1))
      begin
        outfile=$fopen(errFileName,"a");
        $strobe("pmvaa         VDB     leaving   OCA (  .. -10.000 V ) at %7.4r  %M", $abstime );
        $fwrite(outfile,"pmvaa         VDB     leaving   OCA (  .. -10.000 V ) at %7.4r  %M\n", $abstime );
        VDB_retc=-1;
        VDB_cnt=VDB_cnt-1;
        $fclose(outfile);
      end
      if((VDB >= -10) &&  (VDB <= 1.5) && (VDB_retc!=0))
      begin
        outfile=$fopen(errFileName,"a");
        $strobe("pmvaa         VDB     entering SOCA ( -10.000 V .. 1.500 V ) at %7.4r  %M", $abstime );
        $fwrite(outfile,"pmvaa         VDB     entering SOCA ( -10.000 V .. 1.500 V ) at %7.4r  %M\n", $abstime );
        VDB_retc=0;
        VDB_cnt=VDB_cnt-1;
        $fclose(outfile);
      end
      if((VDB > 1.5) &&  (VDB_retc!=1))
      begin
        outfile=$fopen(errFileName,"a");
        $strobe("pmvaa         VDB     leaving   OCA ( 1.500 V ..  ) at %7.4r  %M", $abstime );
        $fwrite(outfile,"pmvaa         VDB     leaving   OCA ( 1.500 V ..  ) at %7.4r  %M\n", $abstime );
        VDB_retc=1;
        VDB_cnt=VDB_cnt-1;
        $fclose(outfile);
      end
   end
   else
   begin
      if(VDB_cnt==0)
      begin
        outfile=$fopen(errFileName,"a");
        $strobe("pmvaa         VDB     error limit ( %d ) reached at %7.4r  %M", maxEv, $abstime );
        $fwrite(outfile,"pmvaa         VDB     error limit ( %d ) reached at %7.4r  %M\n", maxEv, $abstime );
        VDB_cnt=VDB_cnt-1;
        $fclose(outfile);
      end
   end

end // analog
endmodule // pmvaa

// Verilog-A OC Watch for device pmvab Parameters  VGS VGD VDS VDB
module pmvab_ahdl(D,G,S,B);
parameter tstep_occ=100n;
parameter errFileName="./occ.err";
parameter maxEv = 25;
parameter maxEv_flg = 0;
inout D,G,S,B;
electrical D,G,S,B;

integer outfile;
real V_D_B;
real V_D_S;
real V_G_D;
real V_G_S;
real VGS;
integer VGS_retc;
integer VGS_cnt;
real VGD;
integer VGD_retc;
integer VGD_cnt;
real VDS;
integer VDS_retc;
integer VDS_cnt;
real VDB;
integer VDB_retc;
integer VDB_cnt;

analog begin
   $bound_step( tstep_occ );
   @(initial_step) begin
      VGS_retc=0;
      VGS_cnt = maxEv;
      VGD_retc=0;
      VGD_cnt = maxEv;
      VDS_retc=0;
      VDS_cnt = maxEv;
      VDB_retc=0;
      VDB_cnt = maxEv;
   end
   V_D_B = V(D,B);
   V_D_S = V(D,S);
   V_G_D = V(G,D);
   V_G_S = V(G,S);

//      VGS
   VGS = V_G_S;
   if((VGS_cnt>0) || ( maxEv_flg==0 ))   begin
      if( (VGS < -5.5) && (VGS_retc!=-1))
      begin
        outfile=$fopen(errFileName,"a");
        $strobe("pmvab         VGS     leaving   OCA (  .. -5.500 V ) at %7.4r  %M", $abstime );
        $fwrite(outfile,"pmvab         VGS     leaving   OCA (  .. -5.500 V ) at %7.4r  %M\n", $abstime );
        VGS_retc=-1;
        VGS_cnt=VGS_cnt-1;
        $fclose(outfile);
      end
      if((VGS >= -5.5) &&  (VGS <= 5.5) && (VGS_retc!=0))
      begin
        outfile=$fopen(errFileName,"a");
        $strobe("pmvab         VGS     entering SOCA ( -5.500 V .. 5.500 V ) at %7.4r  %M", $abstime );
        $fwrite(outfile,"pmvab         VGS     entering SOCA ( -5.500 V .. 5.500 V ) at %7.4r  %M\n", $abstime );
        VGS_retc=0;
        VGS_cnt=VGS_cnt-1;
        $fclose(outfile);
      end
      if((VGS > 5.5) &&  (VGS_retc!=1))
      begin
        outfile=$fopen(errFileName,"a");
        $strobe("pmvab         VGS     leaving   OCA ( 5.500 V ..  ) at %7.4r  %M", $abstime );
        $fwrite(outfile,"pmvab         VGS     leaving   OCA ( 5.500 V ..  ) at %7.4r  %M\n", $abstime );
        VGS_retc=1;
        VGS_cnt=VGS_cnt-1;
        $fclose(outfile);
      end
   end
   else
   begin
      if(VGS_cnt==0)
      begin
        outfile=$fopen(errFileName,"a");
        $strobe("pmvab         VGS     error limit ( %d ) reached at %7.4r  %M", maxEv, $abstime );
        $fwrite(outfile,"pmvab         VGS     error limit ( %d ) reached at %7.4r  %M\n", maxEv, $abstime );
        VGS_cnt=VGS_cnt-1;
        $fclose(outfile);
      end
   end

//      VGD
   VGD = V_G_D;
   if((VGD_cnt>0) || ( maxEv_flg==0 ))   begin
      if( (VGD < -5.5) && (VGD_retc!=-1))
      begin
        outfile=$fopen(errFileName,"a");
        $strobe("pmvab         VGD     leaving   OCA (  .. -5.500 V ) at %7.4r  %M", $abstime );
        $fwrite(outfile,"pmvab         VGD     leaving   OCA (  .. -5.500 V ) at %7.4r  %M\n", $abstime );
        VGD_retc=-1;
        VGD_cnt=VGD_cnt-1;
        $fclose(outfile);
      end
      if((VGD >= -5.5) &&  (VGD <= 10) && (VGD_retc!=0))
      begin
        outfile=$fopen(errFileName,"a");
        $strobe("pmvab         VGD     entering SOCA ( -5.500 V .. 10.000 V ) at %7.4r  %M", $abstime );
        $fwrite(outfile,"pmvab         VGD     entering SOCA ( -5.500 V .. 10.000 V ) at %7.4r  %M\n", $abstime );
        VGD_retc=0;
        VGD_cnt=VGD_cnt-1;
        $fclose(outfile);
      end
      if((VGD > 10) &&  (VGD_retc!=1))
      begin
        outfile=$fopen(errFileName,"a");
        $strobe("pmvab         VGD     leaving   OCA ( 10.000 V ..  ) at %7.4r  %M", $abstime );
        $fwrite(outfile,"pmvab         VGD     leaving   OCA ( 10.000 V ..  ) at %7.4r  %M\n", $abstime );
        VGD_retc=1;
        VGD_cnt=VGD_cnt-1;
        $fclose(outfile);
      end
   end
   else
   begin
      if(VGD_cnt==0)
      begin
        outfile=$fopen(errFileName,"a");
        $strobe("pmvab         VGD     error limit ( %d ) reached at %7.4r  %M", maxEv, $abstime );
        $fwrite(outfile,"pmvab         VGD     error limit ( %d ) reached at %7.4r  %M\n", maxEv, $abstime );
        VGD_cnt=VGD_cnt-1;
        $fclose(outfile);
      end
   end

//      VDS
   VDS = V_D_S;
   if((VDS_cnt>0) || ( maxEv_flg==0 ))   begin
      if( (VDS < -10) && (VDS_retc!=-1))
      begin
        outfile=$fopen(errFileName,"a");
        $strobe("pmvab         VDS     leaving   OCA (  .. -10.000 V ) at %7.4r  %M", $abstime );
        $fwrite(outfile,"pmvab         VDS     leaving   OCA (  .. -10.000 V ) at %7.4r  %M\n", $abstime );
        VDS_retc=-1;
        VDS_cnt=VDS_cnt-1;
        $fclose(outfile);
      end
      if((VDS >= -10) &&  (VDS <= 1.5) && (VDS_retc!=0))
      begin
        outfile=$fopen(errFileName,"a");
        $strobe("pmvab         VDS     entering SOCA ( -10.000 V .. 1.500 V ) at %7.4r  %M", $abstime );
        $fwrite(outfile,"pmvab         VDS     entering SOCA ( -10.000 V .. 1.500 V ) at %7.4r  %M\n", $abstime );
        VDS_retc=0;
        VDS_cnt=VDS_cnt-1;
        $fclose(outfile);
      end
      if((VDS > 1.5) &&  (VDS_retc!=1))
      begin
        outfile=$fopen(errFileName,"a");
        $strobe("pmvab         VDS     leaving   OCA ( 1.500 V ..  ) at %7.4r  %M", $abstime );
        $fwrite(outfile,"pmvab         VDS     leaving   OCA ( 1.500 V ..  ) at %7.4r  %M\n", $abstime );
        VDS_retc=1;
        VDS_cnt=VDS_cnt-1;
        $fclose(outfile);
      end
   end
   else
   begin
      if(VDS_cnt==0)
      begin
        outfile=$fopen(errFileName,"a");
        $strobe("pmvab         VDS     error limit ( %d ) reached at %7.4r  %M", maxEv, $abstime );
        $fwrite(outfile,"pmvab         VDS     error limit ( %d ) reached at %7.4r  %M\n", maxEv, $abstime );
        VDS_cnt=VDS_cnt-1;
        $fclose(outfile);
      end
   end

//      VDB
   VDB = V_D_B;
   if((VDB_cnt>0) || ( maxEv_flg==0 ))   begin
      if( (VDB < -10) && (VDB_retc!=-1))
      begin
        outfile=$fopen(errFileName,"a");
        $strobe("pmvab         VDB     leaving   OCA (  .. -10.000 V ) at %7.4r  %M", $abstime );
        $fwrite(outfile,"pmvab         VDB     leaving   OCA (  .. -10.000 V ) at %7.4r  %M\n", $abstime );
        VDB_retc=-1;
        VDB_cnt=VDB_cnt-1;
        $fclose(outfile);
      end
      if((VDB >= -10) &&  (VDB <= 1.5) && (VDB_retc!=0))
      begin
        outfile=$fopen(errFileName,"a");
        $strobe("pmvab         VDB     entering SOCA ( -10.000 V .. 1.500 V ) at %7.4r  %M", $abstime );
        $fwrite(outfile,"pmvab         VDB     entering SOCA ( -10.000 V .. 1.500 V ) at %7.4r  %M\n", $abstime );
        VDB_retc=0;
        VDB_cnt=VDB_cnt-1;
        $fclose(outfile);
      end
      if((VDB > 1.5) &&  (VDB_retc!=1))
      begin
        outfile=$fopen(errFileName,"a");
        $strobe("pmvab         VDB     leaving   OCA ( 1.500 V ..  ) at %7.4r  %M", $abstime );
        $fwrite(outfile,"pmvab         VDB     leaving   OCA ( 1.500 V ..  ) at %7.4r  %M\n", $abstime );
        VDB_retc=1;
        VDB_cnt=VDB_cnt-1;
        $fclose(outfile);
      end
   end
   else
   begin
      if(VDB_cnt==0)
      begin
        outfile=$fopen(errFileName,"a");
        $strobe("pmvab         VDB     error limit ( %d ) reached at %7.4r  %M", maxEv, $abstime );
        $fwrite(outfile,"pmvab         VDB     error limit ( %d ) reached at %7.4r  %M\n", maxEv, $abstime );
        VDB_cnt=VDB_cnt-1;
        $fclose(outfile);
      end
   end

end // analog
endmodule // pmvab

// Verilog-A OC Watch for device pmvb Parameters  VGS VGD VDS VDB VSHW
module pmvb_ahdl(D,G,S,B,HW);
parameter tstep_occ=100n;
parameter errFileName="./occ.err";
parameter maxEv = 25;
parameter maxEv_flg = 0;
inout D,G,S,B,HW;
electrical D,G,S,B,HW;

integer outfile;
real V_S_HW;
real V_D_B;
real V_D_S;
real V_G_D;
real V_G_S;
real VGS;
integer VGS_retc;
integer VGS_cnt;
real VGD;
integer VGD_retc;
integer VGD_cnt;
real VDS;
integer VDS_retc;
integer VDS_cnt;
real VDB;
integer VDB_retc;
integer VDB_cnt;
real VSHW;
integer VSHW_retc;
integer VSHW_cnt;

analog begin
   $bound_step( tstep_occ );
   @(initial_step) begin
      VGS_retc=0;
      VGS_cnt = maxEv;
      VGD_retc=0;
      VGD_cnt = maxEv;
      VDS_retc=0;
      VDS_cnt = maxEv;
      VDB_retc=0;
      VDB_cnt = maxEv;
      VSHW_retc=0;
      VSHW_cnt = maxEv;
   end
   V_S_HW = V(S,HW);
   V_D_B = V(D,B);
   V_D_S = V(D,S);
   V_G_D = V(G,D);
   V_G_S = V(G,S);

//      VGS
   VGS = V_G_S;
   if((VGS_cnt>0) || ( maxEv_flg==0 ))   begin
      if( (VGS < -5.5) && (VGS_retc!=-1))
      begin
        outfile=$fopen(errFileName,"a");
        $strobe("pmvb          VGS     leaving   OCA (  .. -5.500 V ) at %7.4r  %M", $abstime );
        $fwrite(outfile,"pmvb          VGS     leaving   OCA (  .. -5.500 V ) at %7.4r  %M\n", $abstime );
        VGS_retc=-1;
        VGS_cnt=VGS_cnt-1;
        $fclose(outfile);
      end
      if((VGS >= -5.5) &&  (VGS <= 5.5) && (VGS_retc!=0))
      begin
        outfile=$fopen(errFileName,"a");
        $strobe("pmvb          VGS     entering SOCA ( -5.500 V .. 5.500 V ) at %7.4r  %M", $abstime );
        $fwrite(outfile,"pmvb          VGS     entering SOCA ( -5.500 V .. 5.500 V ) at %7.4r  %M\n", $abstime );
        VGS_retc=0;
        VGS_cnt=VGS_cnt-1;
        $fclose(outfile);
      end
      if((VGS > 5.5) &&  (VGS_retc!=1))
      begin
        outfile=$fopen(errFileName,"a");
        $strobe("pmvb          VGS     leaving   OCA ( 5.500 V ..  ) at %7.4r  %M", $abstime );
        $fwrite(outfile,"pmvb          VGS     leaving   OCA ( 5.500 V ..  ) at %7.4r  %M\n", $abstime );
        VGS_retc=1;
        VGS_cnt=VGS_cnt-1;
        $fclose(outfile);
      end
   end
   else
   begin
      if(VGS_cnt==0)
      begin
        outfile=$fopen(errFileName,"a");
        $strobe("pmvb          VGS     error limit ( %d ) reached at %7.4r  %M", maxEv, $abstime );
        $fwrite(outfile,"pmvb          VGS     error limit ( %d ) reached at %7.4r  %M\n", maxEv, $abstime );
        VGS_cnt=VGS_cnt-1;
        $fclose(outfile);
      end
   end

//      VGD
   VGD = V_G_D;
   if((VGD_cnt>0) || ( maxEv_flg==0 ))   begin
      if( (VGD < -5.5) && (VGD_retc!=-1))
      begin
        outfile=$fopen(errFileName,"a");
        $strobe("pmvb          VGD     leaving   OCA (  .. -5.500 V ) at %7.4r  %M", $abstime );
        $fwrite(outfile,"pmvb          VGD     leaving   OCA (  .. -5.500 V ) at %7.4r  %M\n", $abstime );
        VGD_retc=-1;
        VGD_cnt=VGD_cnt-1;
        $fclose(outfile);
      end
      if((VGD >= -5.5) &&  (VGD <= 12) && (VGD_retc!=0))
      begin
        outfile=$fopen(errFileName,"a");
        $strobe("pmvb          VGD     entering SOCA ( -5.500 V .. 12.000 V ) at %7.4r  %M", $abstime );
        $fwrite(outfile,"pmvb          VGD     entering SOCA ( -5.500 V .. 12.000 V ) at %7.4r  %M\n", $abstime );
        VGD_retc=0;
        VGD_cnt=VGD_cnt-1;
        $fclose(outfile);
      end
      if((VGD > 12) &&  (VGD_retc!=1))
      begin
        outfile=$fopen(errFileName,"a");
        $strobe("pmvb          VGD     leaving   OCA ( 12.000 V ..  ) at %7.4r  %M", $abstime );
        $fwrite(outfile,"pmvb          VGD     leaving   OCA ( 12.000 V ..  ) at %7.4r  %M\n", $abstime );
        VGD_retc=1;
        VGD_cnt=VGD_cnt-1;
        $fclose(outfile);
      end
   end
   else
   begin
      if(VGD_cnt==0)
      begin
        outfile=$fopen(errFileName,"a");
        $strobe("pmvb          VGD     error limit ( %d ) reached at %7.4r  %M", maxEv, $abstime );
        $fwrite(outfile,"pmvb          VGD     error limit ( %d ) reached at %7.4r  %M\n", maxEv, $abstime );
        VGD_cnt=VGD_cnt-1;
        $fclose(outfile);
      end
   end

//      VDS
   VDS = V_D_S;
   if((VDS_cnt>0) || ( maxEv_flg==0 ))   begin
      if( (VDS < -12) && (VDS_retc!=-1))
      begin
        outfile=$fopen(errFileName,"a");
        $strobe("pmvb          VDS     leaving   OCA (  .. -12.000 V ) at %7.4r  %M", $abstime );
        $fwrite(outfile,"pmvb          VDS     leaving   OCA (  .. -12.000 V ) at %7.4r  %M\n", $abstime );
        VDS_retc=-1;
        VDS_cnt=VDS_cnt-1;
        $fclose(outfile);
      end
      if((VDS >= -12) &&  (VDS <= 1.5) && (VDS_retc!=0))
      begin
        outfile=$fopen(errFileName,"a");
        $strobe("pmvb          VDS     entering SOCA ( -12.000 V .. 1.500 V ) at %7.4r  %M", $abstime );
        $fwrite(outfile,"pmvb          VDS     entering SOCA ( -12.000 V .. 1.500 V ) at %7.4r  %M\n", $abstime );
        VDS_retc=0;
        VDS_cnt=VDS_cnt-1;
        $fclose(outfile);
      end
      if((VDS > 1.5) &&  (VDS_retc!=1))
      begin
        outfile=$fopen(errFileName,"a");
        $strobe("pmvb          VDS     leaving   OCA ( 1.500 V ..  ) at %7.4r  %M", $abstime );
        $fwrite(outfile,"pmvb          VDS     leaving   OCA ( 1.500 V ..  ) at %7.4r  %M\n", $abstime );
        VDS_retc=1;
        VDS_cnt=VDS_cnt-1;
        $fclose(outfile);
      end
   end
   else
   begin
      if(VDS_cnt==0)
      begin
        outfile=$fopen(errFileName,"a");
        $strobe("pmvb          VDS     error limit ( %d ) reached at %7.4r  %M", maxEv, $abstime );
        $fwrite(outfile,"pmvb          VDS     error limit ( %d ) reached at %7.4r  %M\n", maxEv, $abstime );
        VDS_cnt=VDS_cnt-1;
        $fclose(outfile);
      end
   end

//      VDB
   VDB = V_D_B;
   if((VDB_cnt>0) || ( maxEv_flg==0 ))   begin
      if( (VDB < -12) && (VDB_retc!=-1))
      begin
        outfile=$fopen(errFileName,"a");
        $strobe("pmvb          VDB     leaving   OCA (  .. -12.000 V ) at %7.4r  %M", $abstime );
        $fwrite(outfile,"pmvb          VDB     leaving   OCA (  .. -12.000 V ) at %7.4r  %M\n", $abstime );
        VDB_retc=-1;
        VDB_cnt=VDB_cnt-1;
        $fclose(outfile);
      end
      if((VDB >= -12) &&  (VDB <= 1.5) && (VDB_retc!=0))
      begin
        outfile=$fopen(errFileName,"a");
        $strobe("pmvb          VDB     entering SOCA ( -12.000 V .. 1.500 V ) at %7.4r  %M", $abstime );
        $fwrite(outfile,"pmvb          VDB     entering SOCA ( -12.000 V .. 1.500 V ) at %7.4r  %M\n", $abstime );
        VDB_retc=0;
        VDB_cnt=VDB_cnt-1;
        $fclose(outfile);
      end
      if((VDB > 1.5) &&  (VDB_retc!=1))
      begin
        outfile=$fopen(errFileName,"a");
        $strobe("pmvb          VDB     leaving   OCA ( 1.500 V ..  ) at %7.4r  %M", $abstime );
        $fwrite(outfile,"pmvb          VDB     leaving   OCA ( 1.500 V ..  ) at %7.4r  %M\n", $abstime );
        VDB_retc=1;
        VDB_cnt=VDB_cnt-1;
        $fclose(outfile);
      end
   end
   else
   begin
      if(VDB_cnt==0)
      begin
        outfile=$fopen(errFileName,"a");
        $strobe("pmvb          VDB     error limit ( %d ) reached at %7.4r  %M", maxEv, $abstime );
        $fwrite(outfile,"pmvb          VDB     error limit ( %d ) reached at %7.4r  %M\n", maxEv, $abstime );
        VDB_cnt=VDB_cnt-1;
        $fclose(outfile);
      end
   end

//      VSHW
   VSHW = V_S_HW;
   if((VSHW_cnt>0) || ( maxEv_flg==0 ))   begin
      if( (VSHW < -25) && (VSHW_retc!=-1))
      begin
        outfile=$fopen(errFileName,"a");
        $strobe("pmvb          VSHW    leaving   OCA (  .. -25.000 V ) at %7.4r  %M", $abstime );
        $fwrite(outfile,"pmvb          VSHW    leaving   OCA (  .. -25.000 V ) at %7.4r  %M\n", $abstime );
        VSHW_retc=-1;
        VSHW_cnt=VSHW_cnt-1;
        $fclose(outfile);
      end
      if((VSHW >= -25) &&  (VSHW <= 400) && (VSHW_retc!=0))
      begin
        outfile=$fopen(errFileName,"a");
        $strobe("pmvb          VSHW    entering SOCA ( -25.000 V .. 400.000 V ) at %7.4r  %M", $abstime );
        $fwrite(outfile,"pmvb          VSHW    entering SOCA ( -25.000 V .. 400.000 V ) at %7.4r  %M\n", $abstime );
        VSHW_retc=0;
        VSHW_cnt=VSHW_cnt-1;
        $fclose(outfile);
      end
      if((VSHW > 400) &&  (VSHW_retc!=1))
      begin
        outfile=$fopen(errFileName,"a");
        $strobe("pmvb          VSHW    leaving   OCA ( 400.000 V ..  ) at %7.4r  %M", $abstime );
        $fwrite(outfile,"pmvb          VSHW    leaving   OCA ( 400.000 V ..  ) at %7.4r  %M\n", $abstime );
        VSHW_retc=1;
        VSHW_cnt=VSHW_cnt-1;
        $fclose(outfile);
      end
   end
   else
   begin
      if(VSHW_cnt==0)
      begin
        outfile=$fopen(errFileName,"a");
        $strobe("pmvb          VSHW    error limit ( %d ) reached at %7.4r  %M", maxEv, $abstime );
        $fwrite(outfile,"pmvb          VSHW    error limit ( %d ) reached at %7.4r  %M\n", maxEv, $abstime );
        VSHW_cnt=VSHW_cnt-1;
        $fclose(outfile);
      end
   end

end // analog
endmodule // pmvb

// Verilog-A OC Watch for device pmvd Parameters  VGS VGD VDS VDB VSHW
module pmvd_ahdl(D,G,S,B,HW);
parameter tstep_occ=100n;
parameter errFileName="./occ.err";
parameter maxEv = 25;
parameter maxEv_flg = 0;
inout D,G,S,B,HW;
electrical D,G,S,B,HW;

integer outfile;
real V_S_HW;
real V_D_B;
real V_D_S;
real V_G_D;
real V_G_S;
real VGS;
integer VGS_retc;
integer VGS_cnt;
real VGD;
integer VGD_retc;
integer VGD_cnt;
real VDS;
integer VDS_retc;
integer VDS_cnt;
real VDB;
integer VDB_retc;
integer VDB_cnt;
real VSHW;
integer VSHW_retc;
integer VSHW_cnt;

analog begin
   $bound_step( tstep_occ );
   @(initial_step) begin
      VGS_retc=0;
      VGS_cnt = maxEv;
      VGD_retc=0;
      VGD_cnt = maxEv;
      VDS_retc=0;
      VDS_cnt = maxEv;
      VDB_retc=0;
      VDB_cnt = maxEv;
      VSHW_retc=0;
      VSHW_cnt = maxEv;
   end
   V_S_HW = V(S,HW);
   V_D_B = V(D,B);
   V_D_S = V(D,S);
   V_G_D = V(G,D);
   V_G_S = V(G,S);

//      VGS
   VGS = V_G_S;
   if((VGS_cnt>0) || ( maxEv_flg==0 ))   begin
      if( (VGS < -5.5) && (VGS_retc!=-1))
      begin
        outfile=$fopen(errFileName,"a");
        $strobe("pmvd          VGS     leaving   OCA (  .. -5.500 V ) at %7.4r  %M", $abstime );
        $fwrite(outfile,"pmvd          VGS     leaving   OCA (  .. -5.500 V ) at %7.4r  %M\n", $abstime );
        VGS_retc=-1;
        VGS_cnt=VGS_cnt-1;
        $fclose(outfile);
      end
      if((VGS >= -5.5) &&  (VGS <= 5.5) && (VGS_retc!=0))
      begin
        outfile=$fopen(errFileName,"a");
        $strobe("pmvd          VGS     entering SOCA ( -5.500 V .. 5.500 V ) at %7.4r  %M", $abstime );
        $fwrite(outfile,"pmvd          VGS     entering SOCA ( -5.500 V .. 5.500 V ) at %7.4r  %M\n", $abstime );
        VGS_retc=0;
        VGS_cnt=VGS_cnt-1;
        $fclose(outfile);
      end
      if((VGS > 5.5) &&  (VGS_retc!=1))
      begin
        outfile=$fopen(errFileName,"a");
        $strobe("pmvd          VGS     leaving   OCA ( 5.500 V ..  ) at %7.4r  %M", $abstime );
        $fwrite(outfile,"pmvd          VGS     leaving   OCA ( 5.500 V ..  ) at %7.4r  %M\n", $abstime );
        VGS_retc=1;
        VGS_cnt=VGS_cnt-1;
        $fclose(outfile);
      end
   end
   else
   begin
      if(VGS_cnt==0)
      begin
        outfile=$fopen(errFileName,"a");
        $strobe("pmvd          VGS     error limit ( %d ) reached at %7.4r  %M", maxEv, $abstime );
        $fwrite(outfile,"pmvd          VGS     error limit ( %d ) reached at %7.4r  %M\n", maxEv, $abstime );
        VGS_cnt=VGS_cnt-1;
        $fclose(outfile);
      end
   end

//      VGD
   VGD = V_G_D;
   if((VGD_cnt>0) || ( maxEv_flg==0 ))   begin
      if( (VGD < -5.5) && (VGD_retc!=-1))
      begin
        outfile=$fopen(errFileName,"a");
        $strobe("pmvd          VGD     leaving   OCA (  .. -5.500 V ) at %7.4r  %M", $abstime );
        $fwrite(outfile,"pmvd          VGD     leaving   OCA (  .. -5.500 V ) at %7.4r  %M\n", $abstime );
        VGD_retc=-1;
        VGD_cnt=VGD_cnt-1;
        $fclose(outfile);
      end
      if((VGD >= -5.5) &&  (VGD <= 18) && (VGD_retc!=0))
      begin
        outfile=$fopen(errFileName,"a");
        $strobe("pmvd          VGD     entering SOCA ( -5.500 V .. 18.000 V ) at %7.4r  %M", $abstime );
        $fwrite(outfile,"pmvd          VGD     entering SOCA ( -5.500 V .. 18.000 V ) at %7.4r  %M\n", $abstime );
        VGD_retc=0;
        VGD_cnt=VGD_cnt-1;
        $fclose(outfile);
      end
      if((VGD > 18) &&  (VGD_retc!=1))
      begin
        outfile=$fopen(errFileName,"a");
        $strobe("pmvd          VGD     leaving   OCA ( 18.000 V ..  ) at %7.4r  %M", $abstime );
        $fwrite(outfile,"pmvd          VGD     leaving   OCA ( 18.000 V ..  ) at %7.4r  %M\n", $abstime );
        VGD_retc=1;
        VGD_cnt=VGD_cnt-1;
        $fclose(outfile);
      end
   end
   else
   begin
      if(VGD_cnt==0)
      begin
        outfile=$fopen(errFileName,"a");
        $strobe("pmvd          VGD     error limit ( %d ) reached at %7.4r  %M", maxEv, $abstime );
        $fwrite(outfile,"pmvd          VGD     error limit ( %d ) reached at %7.4r  %M\n", maxEv, $abstime );
        VGD_cnt=VGD_cnt-1;
        $fclose(outfile);
      end
   end

//      VDS
   VDS = V_D_S;
   if((VDS_cnt>0) || ( maxEv_flg==0 ))   begin
      if( (VDS < -18) && (VDS_retc!=-1))
      begin
        outfile=$fopen(errFileName,"a");
        $strobe("pmvd          VDS     leaving   OCA (  .. -18.000 V ) at %7.4r  %M", $abstime );
        $fwrite(outfile,"pmvd          VDS     leaving   OCA (  .. -18.000 V ) at %7.4r  %M\n", $abstime );
        VDS_retc=-1;
        VDS_cnt=VDS_cnt-1;
        $fclose(outfile);
      end
      if((VDS >= -18) &&  (VDS <= 1.5) && (VDS_retc!=0))
      begin
        outfile=$fopen(errFileName,"a");
        $strobe("pmvd          VDS     entering SOCA ( -18.000 V .. 1.500 V ) at %7.4r  %M", $abstime );
        $fwrite(outfile,"pmvd          VDS     entering SOCA ( -18.000 V .. 1.500 V ) at %7.4r  %M\n", $abstime );
        VDS_retc=0;
        VDS_cnt=VDS_cnt-1;
        $fclose(outfile);
      end
      if((VDS > 1.5) &&  (VDS_retc!=1))
      begin
        outfile=$fopen(errFileName,"a");
        $strobe("pmvd          VDS     leaving   OCA ( 1.500 V ..  ) at %7.4r  %M", $abstime );
        $fwrite(outfile,"pmvd          VDS     leaving   OCA ( 1.500 V ..  ) at %7.4r  %M\n", $abstime );
        VDS_retc=1;
        VDS_cnt=VDS_cnt-1;
        $fclose(outfile);
      end
   end
   else
   begin
      if(VDS_cnt==0)
      begin
        outfile=$fopen(errFileName,"a");
        $strobe("pmvd          VDS     error limit ( %d ) reached at %7.4r  %M", maxEv, $abstime );
        $fwrite(outfile,"pmvd          VDS     error limit ( %d ) reached at %7.4r  %M\n", maxEv, $abstime );
        VDS_cnt=VDS_cnt-1;
        $fclose(outfile);
      end
   end

//      VDB
   VDB = V_D_B;
   if((VDB_cnt>0) || ( maxEv_flg==0 ))   begin
      if( (VDB < -18) && (VDB_retc!=-1))
      begin
        outfile=$fopen(errFileName,"a");
        $strobe("pmvd          VDB     leaving   OCA (  .. -18.000 V ) at %7.4r  %M", $abstime );
        $fwrite(outfile,"pmvd          VDB     leaving   OCA (  .. -18.000 V ) at %7.4r  %M\n", $abstime );
        VDB_retc=-1;
        VDB_cnt=VDB_cnt-1;
        $fclose(outfile);
      end
      if((VDB >= -18) &&  (VDB <= 1.5) && (VDB_retc!=0))
      begin
        outfile=$fopen(errFileName,"a");
        $strobe("pmvd          VDB     entering SOCA ( -18.000 V .. 1.500 V ) at %7.4r  %M", $abstime );
        $fwrite(outfile,"pmvd          VDB     entering SOCA ( -18.000 V .. 1.500 V ) at %7.4r  %M\n", $abstime );
        VDB_retc=0;
        VDB_cnt=VDB_cnt-1;
        $fclose(outfile);
      end
      if((VDB > 1.5) &&  (VDB_retc!=1))
      begin
        outfile=$fopen(errFileName,"a");
        $strobe("pmvd          VDB     leaving   OCA ( 1.500 V ..  ) at %7.4r  %M", $abstime );
        $fwrite(outfile,"pmvd          VDB     leaving   OCA ( 1.500 V ..  ) at %7.4r  %M\n", $abstime );
        VDB_retc=1;
        VDB_cnt=VDB_cnt-1;
        $fclose(outfile);
      end
   end
   else
   begin
      if(VDB_cnt==0)
      begin
        outfile=$fopen(errFileName,"a");
        $strobe("pmvd          VDB     error limit ( %d ) reached at %7.4r  %M", maxEv, $abstime );
        $fwrite(outfile,"pmvd          VDB     error limit ( %d ) reached at %7.4r  %M\n", maxEv, $abstime );
        VDB_cnt=VDB_cnt-1;
        $fclose(outfile);
      end
   end

//      VSHW
   VSHW = V_S_HW;
   if((VSHW_cnt>0) || ( maxEv_flg==0 ))   begin
      if( (VSHW < -25) && (VSHW_retc!=-1))
      begin
        outfile=$fopen(errFileName,"a");
        $strobe("pmvd          VSHW    leaving   OCA (  .. -25.000 V ) at %7.4r  %M", $abstime );
        $fwrite(outfile,"pmvd          VSHW    leaving   OCA (  .. -25.000 V ) at %7.4r  %M\n", $abstime );
        VSHW_retc=-1;
        VSHW_cnt=VSHW_cnt-1;
        $fclose(outfile);
      end
      if((VSHW >= -25) &&  (VSHW <= 400) && (VSHW_retc!=0))
      begin
        outfile=$fopen(errFileName,"a");
        $strobe("pmvd          VSHW    entering SOCA ( -25.000 V .. 400.000 V ) at %7.4r  %M", $abstime );
        $fwrite(outfile,"pmvd          VSHW    entering SOCA ( -25.000 V .. 400.000 V ) at %7.4r  %M\n", $abstime );
        VSHW_retc=0;
        VSHW_cnt=VSHW_cnt-1;
        $fclose(outfile);
      end
      if((VSHW > 400) &&  (VSHW_retc!=1))
      begin
        outfile=$fopen(errFileName,"a");
        $strobe("pmvd          VSHW    leaving   OCA ( 400.000 V ..  ) at %7.4r  %M", $abstime );
        $fwrite(outfile,"pmvd          VSHW    leaving   OCA ( 400.000 V ..  ) at %7.4r  %M\n", $abstime );
        VSHW_retc=1;
        VSHW_cnt=VSHW_cnt-1;
        $fclose(outfile);
      end
   end
   else
   begin
      if(VSHW_cnt==0)
      begin
        outfile=$fopen(errFileName,"a");
        $strobe("pmvd          VSHW    error limit ( %d ) reached at %7.4r  %M", maxEv, $abstime );
        $fwrite(outfile,"pmvd          VSHW    error limit ( %d ) reached at %7.4r  %M\n", maxEv, $abstime );
        VSHW_cnt=VSHW_cnt-1;
        $fclose(outfile);
      end
   end

end // analog
endmodule // pmvd

// Verilog-A OC Watch for device pmve Parameters  VGS VGD VDS VDB VSHW
module pmve_ahdl(D,G,S,B,HW);
parameter tstep_occ=100n;
parameter errFileName="./occ.err";
parameter maxEv = 25;
parameter maxEv_flg = 0;
inout D,G,S,B,HW;
electrical D,G,S,B,HW;

integer outfile;
real V_S_HW;
real V_D_B;
real V_D_S;
real V_G_D;
real V_G_S;
real VGS;
integer VGS_retc;
integer VGS_cnt;
real VGD;
integer VGD_retc;
integer VGD_cnt;
real VDS;
integer VDS_retc;
integer VDS_cnt;
real VDB;
integer VDB_retc;
integer VDB_cnt;
real VSHW;
integer VSHW_retc;
integer VSHW_cnt;

analog begin
   $bound_step( tstep_occ );
   @(initial_step) begin
      VGS_retc=0;
      VGS_cnt = maxEv;
      VGD_retc=0;
      VGD_cnt = maxEv;
      VDS_retc=0;
      VDS_cnt = maxEv;
      VDB_retc=0;
      VDB_cnt = maxEv;
      VSHW_retc=0;
      VSHW_cnt = maxEv;
   end
   V_S_HW = V(S,HW);
   V_D_B = V(D,B);
   V_D_S = V(D,S);
   V_G_D = V(G,D);
   V_G_S = V(G,S);

//      VGS
   VGS = V_G_S;
   if((VGS_cnt>0) || ( maxEv_flg==0 ))   begin
      if( (VGS < -5.5) && (VGS_retc!=-1))
      begin
        outfile=$fopen(errFileName,"a");
        $strobe("pmve          VGS     leaving   OCA (  .. -5.500 V ) at %7.4r  %M", $abstime );
        $fwrite(outfile,"pmve          VGS     leaving   OCA (  .. -5.500 V ) at %7.4r  %M\n", $abstime );
        VGS_retc=-1;
        VGS_cnt=VGS_cnt-1;
        $fclose(outfile);
      end
      if((VGS >= -5.5) &&  (VGS <= 5.5) && (VGS_retc!=0))
      begin
        outfile=$fopen(errFileName,"a");
        $strobe("pmve          VGS     entering SOCA ( -5.500 V .. 5.500 V ) at %7.4r  %M", $abstime );
        $fwrite(outfile,"pmve          VGS     entering SOCA ( -5.500 V .. 5.500 V ) at %7.4r  %M\n", $abstime );
        VGS_retc=0;
        VGS_cnt=VGS_cnt-1;
        $fclose(outfile);
      end
      if((VGS > 5.5) &&  (VGS_retc!=1))
      begin
        outfile=$fopen(errFileName,"a");
        $strobe("pmve          VGS     leaving   OCA ( 5.500 V ..  ) at %7.4r  %M", $abstime );
        $fwrite(outfile,"pmve          VGS     leaving   OCA ( 5.500 V ..  ) at %7.4r  %M\n", $abstime );
        VGS_retc=1;
        VGS_cnt=VGS_cnt-1;
        $fclose(outfile);
      end
   end
   else
   begin
      if(VGS_cnt==0)
      begin
        outfile=$fopen(errFileName,"a");
        $strobe("pmve          VGS     error limit ( %d ) reached at %7.4r  %M", maxEv, $abstime );
        $fwrite(outfile,"pmve          VGS     error limit ( %d ) reached at %7.4r  %M\n", maxEv, $abstime );
        VGS_cnt=VGS_cnt-1;
        $fclose(outfile);
      end
   end

//      VGD
   VGD = V_G_D;
   if((VGD_cnt>0) || ( maxEv_flg==0 ))   begin
      if( (VGD < -5.5) && (VGD_retc!=-1))
      begin
        outfile=$fopen(errFileName,"a");
        $strobe("pmve          VGD     leaving   OCA (  .. -5.500 V ) at %7.4r  %M", $abstime );
        $fwrite(outfile,"pmve          VGD     leaving   OCA (  .. -5.500 V ) at %7.4r  %M\n", $abstime );
        VGD_retc=-1;
        VGD_cnt=VGD_cnt-1;
        $fclose(outfile);
      end
      if((VGD >= -5.5) &&  (VGD <= 25) && (VGD_retc!=0))
      begin
        outfile=$fopen(errFileName,"a");
        $strobe("pmve          VGD     entering SOCA ( -5.500 V .. 25.000 V ) at %7.4r  %M", $abstime );
        $fwrite(outfile,"pmve          VGD     entering SOCA ( -5.500 V .. 25.000 V ) at %7.4r  %M\n", $abstime );
        VGD_retc=0;
        VGD_cnt=VGD_cnt-1;
        $fclose(outfile);
      end
      if((VGD > 25) &&  (VGD_retc!=1))
      begin
        outfile=$fopen(errFileName,"a");
        $strobe("pmve          VGD     leaving   OCA ( 25.000 V ..  ) at %7.4r  %M", $abstime );
        $fwrite(outfile,"pmve          VGD     leaving   OCA ( 25.000 V ..  ) at %7.4r  %M\n", $abstime );
        VGD_retc=1;
        VGD_cnt=VGD_cnt-1;
        $fclose(outfile);
      end
   end
   else
   begin
      if(VGD_cnt==0)
      begin
        outfile=$fopen(errFileName,"a");
        $strobe("pmve          VGD     error limit ( %d ) reached at %7.4r  %M", maxEv, $abstime );
        $fwrite(outfile,"pmve          VGD     error limit ( %d ) reached at %7.4r  %M\n", maxEv, $abstime );
        VGD_cnt=VGD_cnt-1;
        $fclose(outfile);
      end
   end

//      VDS
   VDS = V_D_S;
   if((VDS_cnt>0) || ( maxEv_flg==0 ))   begin
      if( (VDS < -25) && (VDS_retc!=-1))
      begin
        outfile=$fopen(errFileName,"a");
        $strobe("pmve          VDS     leaving   OCA (  .. -25.000 V ) at %7.4r  %M", $abstime );
        $fwrite(outfile,"pmve          VDS     leaving   OCA (  .. -25.000 V ) at %7.4r  %M\n", $abstime );
        VDS_retc=-1;
        VDS_cnt=VDS_cnt-1;
        $fclose(outfile);
      end
      if((VDS >= -25) &&  (VDS <= 1.5) && (VDS_retc!=0))
      begin
        outfile=$fopen(errFileName,"a");
        $strobe("pmve          VDS     entering SOCA ( -25.000 V .. 1.500 V ) at %7.4r  %M", $abstime );
        $fwrite(outfile,"pmve          VDS     entering SOCA ( -25.000 V .. 1.500 V ) at %7.4r  %M\n", $abstime );
        VDS_retc=0;
        VDS_cnt=VDS_cnt-1;
        $fclose(outfile);
      end
      if((VDS > 1.5) &&  (VDS_retc!=1))
      begin
        outfile=$fopen(errFileName,"a");
        $strobe("pmve          VDS     leaving   OCA ( 1.500 V ..  ) at %7.4r  %M", $abstime );
        $fwrite(outfile,"pmve          VDS     leaving   OCA ( 1.500 V ..  ) at %7.4r  %M\n", $abstime );
        VDS_retc=1;
        VDS_cnt=VDS_cnt-1;
        $fclose(outfile);
      end
   end
   else
   begin
      if(VDS_cnt==0)
      begin
        outfile=$fopen(errFileName,"a");
        $strobe("pmve          VDS     error limit ( %d ) reached at %7.4r  %M", maxEv, $abstime );
        $fwrite(outfile,"pmve          VDS     error limit ( %d ) reached at %7.4r  %M\n", maxEv, $abstime );
        VDS_cnt=VDS_cnt-1;
        $fclose(outfile);
      end
   end

//      VDB
   VDB = V_D_B;
   if((VDB_cnt>0) || ( maxEv_flg==0 ))   begin
      if( (VDB < -25) && (VDB_retc!=-1))
      begin
        outfile=$fopen(errFileName,"a");
        $strobe("pmve          VDB     leaving   OCA (  .. -25.000 V ) at %7.4r  %M", $abstime );
        $fwrite(outfile,"pmve          VDB     leaving   OCA (  .. -25.000 V ) at %7.4r  %M\n", $abstime );
        VDB_retc=-1;
        VDB_cnt=VDB_cnt-1;
        $fclose(outfile);
      end
      if((VDB >= -25) &&  (VDB <= 1.5) && (VDB_retc!=0))
      begin
        outfile=$fopen(errFileName,"a");
        $strobe("pmve          VDB     entering SOCA ( -25.000 V .. 1.500 V ) at %7.4r  %M", $abstime );
        $fwrite(outfile,"pmve          VDB     entering SOCA ( -25.000 V .. 1.500 V ) at %7.4r  %M\n", $abstime );
        VDB_retc=0;
        VDB_cnt=VDB_cnt-1;
        $fclose(outfile);
      end
      if((VDB > 1.5) &&  (VDB_retc!=1))
      begin
        outfile=$fopen(errFileName,"a");
        $strobe("pmve          VDB     leaving   OCA ( 1.500 V ..  ) at %7.4r  %M", $abstime );
        $fwrite(outfile,"pmve          VDB     leaving   OCA ( 1.500 V ..  ) at %7.4r  %M\n", $abstime );
        VDB_retc=1;
        VDB_cnt=VDB_cnt-1;
        $fclose(outfile);
      end
   end
   else
   begin
      if(VDB_cnt==0)
      begin
        outfile=$fopen(errFileName,"a");
        $strobe("pmve          VDB     error limit ( %d ) reached at %7.4r  %M", maxEv, $abstime );
        $fwrite(outfile,"pmve          VDB     error limit ( %d ) reached at %7.4r  %M\n", maxEv, $abstime );
        VDB_cnt=VDB_cnt-1;
        $fclose(outfile);
      end
   end

//      VSHW
   VSHW = V_S_HW;
   if((VSHW_cnt>0) || ( maxEv_flg==0 ))   begin
      if( (VSHW < -25) && (VSHW_retc!=-1))
      begin
        outfile=$fopen(errFileName,"a");
        $strobe("pmve          VSHW    leaving   OCA (  .. -25.000 V ) at %7.4r  %M", $abstime );
        $fwrite(outfile,"pmve          VSHW    leaving   OCA (  .. -25.000 V ) at %7.4r  %M\n", $abstime );
        VSHW_retc=-1;
        VSHW_cnt=VSHW_cnt-1;
        $fclose(outfile);
      end
      if((VSHW >= -25) &&  (VSHW <= 400) && (VSHW_retc!=0))
      begin
        outfile=$fopen(errFileName,"a");
        $strobe("pmve          VSHW    entering SOCA ( -25.000 V .. 400.000 V ) at %7.4r  %M", $abstime );
        $fwrite(outfile,"pmve          VSHW    entering SOCA ( -25.000 V .. 400.000 V ) at %7.4r  %M\n", $abstime );
        VSHW_retc=0;
        VSHW_cnt=VSHW_cnt-1;
        $fclose(outfile);
      end
      if((VSHW > 400) &&  (VSHW_retc!=1))
      begin
        outfile=$fopen(errFileName,"a");
        $strobe("pmve          VSHW    leaving   OCA ( 400.000 V ..  ) at %7.4r  %M", $abstime );
        $fwrite(outfile,"pmve          VSHW    leaving   OCA ( 400.000 V ..  ) at %7.4r  %M\n", $abstime );
        VSHW_retc=1;
        VSHW_cnt=VSHW_cnt-1;
        $fclose(outfile);
      end
   end
   else
   begin
      if(VSHW_cnt==0)
      begin
        outfile=$fopen(errFileName,"a");
        $strobe("pmve          VSHW    error limit ( %d ) reached at %7.4r  %M", maxEv, $abstime );
        $fwrite(outfile,"pmve          VSHW    error limit ( %d ) reached at %7.4r  %M\n", maxEv, $abstime );
        VSHW_cnt=VSHW_cnt-1;
        $fclose(outfile);
      end
   end

end // analog
endmodule // pmve

// Verilog-A OC Watch for device pmvf Parameters  VGS VGD VDS VDB VSHW
module pmvf_ahdl(D,G,S,B,HW);
parameter tstep_occ=100n;
parameter errFileName="./occ.err";
parameter maxEv = 25;
parameter maxEv_flg = 0;
inout D,G,S,B,HW;
electrical D,G,S,B,HW;

integer outfile;
real V_S_HW;
real V_D_B;
real V_D_S;
real V_G_D;
real V_G_S;
real VGS;
integer VGS_retc;
integer VGS_cnt;
real VGD;
integer VGD_retc;
integer VGD_cnt;
real VDS;
integer VDS_retc;
integer VDS_cnt;
real VDB;
integer VDB_retc;
integer VDB_cnt;
real VSHW;
integer VSHW_retc;
integer VSHW_cnt;

analog begin
   $bound_step( tstep_occ );
   @(initial_step) begin
      VGS_retc=0;
      VGS_cnt = maxEv;
      VGD_retc=0;
      VGD_cnt = maxEv;
      VDS_retc=0;
      VDS_cnt = maxEv;
      VDB_retc=0;
      VDB_cnt = maxEv;
      VSHW_retc=0;
      VSHW_cnt = maxEv;
   end
   V_S_HW = V(S,HW);
   V_D_B = V(D,B);
   V_D_S = V(D,S);
   V_G_D = V(G,D);
   V_G_S = V(G,S);

//      VGS
   VGS = V_G_S;
   if((VGS_cnt>0) || ( maxEv_flg==0 ))   begin
      if( (VGS < -5.5) && (VGS_retc!=-1))
      begin
        outfile=$fopen(errFileName,"a");
        $strobe("pmvf          VGS     leaving   OCA (  .. -5.500 V ) at %7.4r  %M", $abstime );
        $fwrite(outfile,"pmvf          VGS     leaving   OCA (  .. -5.500 V ) at %7.4r  %M\n", $abstime );
        VGS_retc=-1;
        VGS_cnt=VGS_cnt-1;
        $fclose(outfile);
      end
      if((VGS >= -5.5) &&  (VGS <= 5.5) && (VGS_retc!=0))
      begin
        outfile=$fopen(errFileName,"a");
        $strobe("pmvf          VGS     entering SOCA ( -5.500 V .. 5.500 V ) at %7.4r  %M", $abstime );
        $fwrite(outfile,"pmvf          VGS     entering SOCA ( -5.500 V .. 5.500 V ) at %7.4r  %M\n", $abstime );
        VGS_retc=0;
        VGS_cnt=VGS_cnt-1;
        $fclose(outfile);
      end
      if((VGS > 5.5) &&  (VGS_retc!=1))
      begin
        outfile=$fopen(errFileName,"a");
        $strobe("pmvf          VGS     leaving   OCA ( 5.500 V ..  ) at %7.4r  %M", $abstime );
        $fwrite(outfile,"pmvf          VGS     leaving   OCA ( 5.500 V ..  ) at %7.4r  %M\n", $abstime );
        VGS_retc=1;
        VGS_cnt=VGS_cnt-1;
        $fclose(outfile);
      end
   end
   else
   begin
      if(VGS_cnt==0)
      begin
        outfile=$fopen(errFileName,"a");
        $strobe("pmvf          VGS     error limit ( %d ) reached at %7.4r  %M", maxEv, $abstime );
        $fwrite(outfile,"pmvf          VGS     error limit ( %d ) reached at %7.4r  %M\n", maxEv, $abstime );
        VGS_cnt=VGS_cnt-1;
        $fclose(outfile);
      end
   end

//      VGD
   VGD = V_G_D;
   if((VGD_cnt>0) || ( maxEv_flg==0 ))   begin
      if( (VGD < -5.5) && (VGD_retc!=-1))
      begin
        outfile=$fopen(errFileName,"a");
        $strobe("pmvf          VGD     leaving   OCA (  .. -5.500 V ) at %7.4r  %M", $abstime );
        $fwrite(outfile,"pmvf          VGD     leaving   OCA (  .. -5.500 V ) at %7.4r  %M\n", $abstime );
        VGD_retc=-1;
        VGD_cnt=VGD_cnt-1;
        $fclose(outfile);
      end
      if((VGD >= -5.5) &&  (VGD <= 32) && (VGD_retc!=0))
      begin
        outfile=$fopen(errFileName,"a");
        $strobe("pmvf          VGD     entering SOCA ( -5.500 V .. 32.000 V ) at %7.4r  %M", $abstime );
        $fwrite(outfile,"pmvf          VGD     entering SOCA ( -5.500 V .. 32.000 V ) at %7.4r  %M\n", $abstime );
        VGD_retc=0;
        VGD_cnt=VGD_cnt-1;
        $fclose(outfile);
      end
      if((VGD > 32) &&  (VGD_retc!=1))
      begin
        outfile=$fopen(errFileName,"a");
        $strobe("pmvf          VGD     leaving   OCA ( 32.000 V ..  ) at %7.4r  %M", $abstime );
        $fwrite(outfile,"pmvf          VGD     leaving   OCA ( 32.000 V ..  ) at %7.4r  %M\n", $abstime );
        VGD_retc=1;
        VGD_cnt=VGD_cnt-1;
        $fclose(outfile);
      end
   end
   else
   begin
      if(VGD_cnt==0)
      begin
        outfile=$fopen(errFileName,"a");
        $strobe("pmvf          VGD     error limit ( %d ) reached at %7.4r  %M", maxEv, $abstime );
        $fwrite(outfile,"pmvf          VGD     error limit ( %d ) reached at %7.4r  %M\n", maxEv, $abstime );
        VGD_cnt=VGD_cnt-1;
        $fclose(outfile);
      end
   end

//      VDS
   VDS = V_D_S;
   if((VDS_cnt>0) || ( maxEv_flg==0 ))   begin
      if( (VDS < -32) && (VDS_retc!=-1))
      begin
        outfile=$fopen(errFileName,"a");
        $strobe("pmvf          VDS     leaving   OCA (  .. -32.000 V ) at %7.4r  %M", $abstime );
        $fwrite(outfile,"pmvf          VDS     leaving   OCA (  .. -32.000 V ) at %7.4r  %M\n", $abstime );
        VDS_retc=-1;
        VDS_cnt=VDS_cnt-1;
        $fclose(outfile);
      end
      if((VDS >= -32) &&  (VDS <= 1.5) && (VDS_retc!=0))
      begin
        outfile=$fopen(errFileName,"a");
        $strobe("pmvf          VDS     entering SOCA ( -32.000 V .. 1.500 V ) at %7.4r  %M", $abstime );
        $fwrite(outfile,"pmvf          VDS     entering SOCA ( -32.000 V .. 1.500 V ) at %7.4r  %M\n", $abstime );
        VDS_retc=0;
        VDS_cnt=VDS_cnt-1;
        $fclose(outfile);
      end
      if((VDS > 1.5) &&  (VDS_retc!=1))
      begin
        outfile=$fopen(errFileName,"a");
        $strobe("pmvf          VDS     leaving   OCA ( 1.500 V ..  ) at %7.4r  %M", $abstime );
        $fwrite(outfile,"pmvf          VDS     leaving   OCA ( 1.500 V ..  ) at %7.4r  %M\n", $abstime );
        VDS_retc=1;
        VDS_cnt=VDS_cnt-1;
        $fclose(outfile);
      end
   end
   else
   begin
      if(VDS_cnt==0)
      begin
        outfile=$fopen(errFileName,"a");
        $strobe("pmvf          VDS     error limit ( %d ) reached at %7.4r  %M", maxEv, $abstime );
        $fwrite(outfile,"pmvf          VDS     error limit ( %d ) reached at %7.4r  %M\n", maxEv, $abstime );
        VDS_cnt=VDS_cnt-1;
        $fclose(outfile);
      end
   end

//      VDB
   VDB = V_D_B;
   if((VDB_cnt>0) || ( maxEv_flg==0 ))   begin
      if( (VDB < -32) && (VDB_retc!=-1))
      begin
        outfile=$fopen(errFileName,"a");
        $strobe("pmvf          VDB     leaving   OCA (  .. -32.000 V ) at %7.4r  %M", $abstime );
        $fwrite(outfile,"pmvf          VDB     leaving   OCA (  .. -32.000 V ) at %7.4r  %M\n", $abstime );
        VDB_retc=-1;
        VDB_cnt=VDB_cnt-1;
        $fclose(outfile);
      end
      if((VDB >= -32) &&  (VDB <= 1.5) && (VDB_retc!=0))
      begin
        outfile=$fopen(errFileName,"a");
        $strobe("pmvf          VDB     entering SOCA ( -32.000 V .. 1.500 V ) at %7.4r  %M", $abstime );
        $fwrite(outfile,"pmvf          VDB     entering SOCA ( -32.000 V .. 1.500 V ) at %7.4r  %M\n", $abstime );
        VDB_retc=0;
        VDB_cnt=VDB_cnt-1;
        $fclose(outfile);
      end
      if((VDB > 1.5) &&  (VDB_retc!=1))
      begin
        outfile=$fopen(errFileName,"a");
        $strobe("pmvf          VDB     leaving   OCA ( 1.500 V ..  ) at %7.4r  %M", $abstime );
        $fwrite(outfile,"pmvf          VDB     leaving   OCA ( 1.500 V ..  ) at %7.4r  %M\n", $abstime );
        VDB_retc=1;
        VDB_cnt=VDB_cnt-1;
        $fclose(outfile);
      end
   end
   else
   begin
      if(VDB_cnt==0)
      begin
        outfile=$fopen(errFileName,"a");
        $strobe("pmvf          VDB     error limit ( %d ) reached at %7.4r  %M", maxEv, $abstime );
        $fwrite(outfile,"pmvf          VDB     error limit ( %d ) reached at %7.4r  %M\n", maxEv, $abstime );
        VDB_cnt=VDB_cnt-1;
        $fclose(outfile);
      end
   end

//      VSHW
   VSHW = V_S_HW;
   if((VSHW_cnt>0) || ( maxEv_flg==0 ))   begin
      if( (VSHW < -25) && (VSHW_retc!=-1))
      begin
        outfile=$fopen(errFileName,"a");
        $strobe("pmvf          VSHW    leaving   OCA (  .. -25.000 V ) at %7.4r  %M", $abstime );
        $fwrite(outfile,"pmvf          VSHW    leaving   OCA (  .. -25.000 V ) at %7.4r  %M\n", $abstime );
        VSHW_retc=-1;
        VSHW_cnt=VSHW_cnt-1;
        $fclose(outfile);
      end
      if((VSHW >= -25) &&  (VSHW <= 400) && (VSHW_retc!=0))
      begin
        outfile=$fopen(errFileName,"a");
        $strobe("pmvf          VSHW    entering SOCA ( -25.000 V .. 400.000 V ) at %7.4r  %M", $abstime );
        $fwrite(outfile,"pmvf          VSHW    entering SOCA ( -25.000 V .. 400.000 V ) at %7.4r  %M\n", $abstime );
        VSHW_retc=0;
        VSHW_cnt=VSHW_cnt-1;
        $fclose(outfile);
      end
      if((VSHW > 400) &&  (VSHW_retc!=1))
      begin
        outfile=$fopen(errFileName,"a");
        $strobe("pmvf          VSHW    leaving   OCA ( 400.000 V ..  ) at %7.4r  %M", $abstime );
        $fwrite(outfile,"pmvf          VSHW    leaving   OCA ( 400.000 V ..  ) at %7.4r  %M\n", $abstime );
        VSHW_retc=1;
        VSHW_cnt=VSHW_cnt-1;
        $fclose(outfile);
      end
   end
   else
   begin
      if(VSHW_cnt==0)
      begin
        outfile=$fopen(errFileName,"a");
        $strobe("pmvf          VSHW    error limit ( %d ) reached at %7.4r  %M", maxEv, $abstime );
        $fwrite(outfile,"pmvf          VSHW    error limit ( %d ) reached at %7.4r  %M\n", maxEv, $abstime );
        VSHW_cnt=VSHW_cnt-1;
        $fclose(outfile);
      end
   end

end // analog
endmodule // pmvf

// Verilog-A OC Watch for device nhvta Parameters  VGS VGD VDS VDB VDHW
module nhvta_ahdl(D,G,S,B,HW);
parameter tstep_occ=100n;
parameter errFileName="./occ.err";
parameter maxEv = 25;
parameter maxEv_flg = 0;
inout D,G,S,B,HW;
electrical D,G,S,B,HW;

integer outfile;
real V_D_HW;
real V_D_B;
real V_D_S;
real V_G_D;
real V_G_S;
real VGS;
integer VGS_retc;
integer VGS_cnt;
real VGD;
integer VGD_retc;
integer VGD_cnt;
real VDS;
integer VDS_retc;
integer VDS_cnt;
real VDB;
integer VDB_retc;
integer VDB_cnt;
real VDHW;
integer VDHW_retc;
integer VDHW_cnt;

analog begin
   $bound_step( tstep_occ );
   @(initial_step) begin
      VGS_retc=0;
      VGS_cnt = maxEv;
      VGD_retc=0;
      VGD_cnt = maxEv;
      VDS_retc=0;
      VDS_cnt = maxEv;
      VDB_retc=0;
      VDB_cnt = maxEv;
      VDHW_retc=0;
      VDHW_cnt = maxEv;
   end
   V_D_HW = V(D,HW);
   V_D_B = V(D,B);
   V_D_S = V(D,S);
   V_G_D = V(G,D);
   V_G_S = V(G,S);

//      VGS
   VGS = V_G_S;
   if((VGS_cnt>0) || ( maxEv_flg==0 ))   begin
      if( (VGS < -5.5) && (VGS_retc!=-1))
      begin
        outfile=$fopen(errFileName,"a");
        $strobe("nhvta         VGS     leaving   OCA (  .. -5.500 V ) at %7.4r  %M", $abstime );
        $fwrite(outfile,"nhvta         VGS     leaving   OCA (  .. -5.500 V ) at %7.4r  %M\n", $abstime );
        VGS_retc=-1;
        VGS_cnt=VGS_cnt-1;
        $fclose(outfile);
      end
      if((VGS >= -5.5) &&  (VGS <= 5.5) && (VGS_retc!=0))
      begin
        outfile=$fopen(errFileName,"a");
        $strobe("nhvta         VGS     entering SOCA ( -5.500 V .. 5.500 V ) at %7.4r  %M", $abstime );
        $fwrite(outfile,"nhvta         VGS     entering SOCA ( -5.500 V .. 5.500 V ) at %7.4r  %M\n", $abstime );
        VGS_retc=0;
        VGS_cnt=VGS_cnt-1;
        $fclose(outfile);
      end
      if((VGS > 5.5) &&  (VGS_retc!=1))
      begin
        outfile=$fopen(errFileName,"a");
        $strobe("nhvta         VGS     leaving   OCA ( 5.500 V ..  ) at %7.4r  %M", $abstime );
        $fwrite(outfile,"nhvta         VGS     leaving   OCA ( 5.500 V ..  ) at %7.4r  %M\n", $abstime );
        VGS_retc=1;
        VGS_cnt=VGS_cnt-1;
        $fclose(outfile);
      end
   end
   else
   begin
      if(VGS_cnt==0)
      begin
        outfile=$fopen(errFileName,"a");
        $strobe("nhvta         VGS     error limit ( %d ) reached at %7.4r  %M", maxEv, $abstime );
        $fwrite(outfile,"nhvta         VGS     error limit ( %d ) reached at %7.4r  %M\n", maxEv, $abstime );
        VGS_cnt=VGS_cnt-1;
        $fclose(outfile);
      end
   end

//      VGD
   VGD = V_G_D;
   if((VGD_cnt>0) || ( maxEv_flg==0 ))   begin
      if( (VGD < -40) && (VGD_retc!=-1))
      begin
        outfile=$fopen(errFileName,"a");
        $strobe("nhvta         VGD     leaving   OCA (  .. -40.000 V ) at %7.4r  %M", $abstime );
        $fwrite(outfile,"nhvta         VGD     leaving   OCA (  .. -40.000 V ) at %7.4r  %M\n", $abstime );
        VGD_retc=-1;
        VGD_cnt=VGD_cnt-1;
        $fclose(outfile);
      end
      if((VGD >= -40) &&  (VGD <= 5.5) && (VGD_retc!=0))
      begin
        outfile=$fopen(errFileName,"a");
        $strobe("nhvta         VGD     entering SOCA ( -40.000 V .. 5.500 V ) at %7.4r  %M", $abstime );
        $fwrite(outfile,"nhvta         VGD     entering SOCA ( -40.000 V .. 5.500 V ) at %7.4r  %M\n", $abstime );
        VGD_retc=0;
        VGD_cnt=VGD_cnt-1;
        $fclose(outfile);
      end
      if((VGD > 5.5) &&  (VGD_retc!=1))
      begin
        outfile=$fopen(errFileName,"a");
        $strobe("nhvta         VGD     leaving   OCA ( 5.500 V ..  ) at %7.4r  %M", $abstime );
        $fwrite(outfile,"nhvta         VGD     leaving   OCA ( 5.500 V ..  ) at %7.4r  %M\n", $abstime );
        VGD_retc=1;
        VGD_cnt=VGD_cnt-1;
        $fclose(outfile);
      end
   end
   else
   begin
      if(VGD_cnt==0)
      begin
        outfile=$fopen(errFileName,"a");
        $strobe("nhvta         VGD     error limit ( %d ) reached at %7.4r  %M", maxEv, $abstime );
        $fwrite(outfile,"nhvta         VGD     error limit ( %d ) reached at %7.4r  %M\n", maxEv, $abstime );
        VGD_cnt=VGD_cnt-1;
        $fclose(outfile);
      end
   end

//      VDS
   VDS = V_D_S;
   if((VDS_cnt>0) || ( maxEv_flg==0 ))   begin
      if( (VDS < -1.5) && (VDS_retc!=-1))
      begin
        outfile=$fopen(errFileName,"a");
        $strobe("nhvta         VDS     leaving   OCA (  .. -1.500 V ) at %7.4r  %M", $abstime );
        $fwrite(outfile,"nhvta         VDS     leaving   OCA (  .. -1.500 V ) at %7.4r  %M\n", $abstime );
        VDS_retc=-1;
        VDS_cnt=VDS_cnt-1;
        $fclose(outfile);
      end
      if((VDS >= -1.5) &&  (VDS <= 40) && (VDS_retc!=0))
      begin
        outfile=$fopen(errFileName,"a");
        $strobe("nhvta         VDS     entering SOCA ( -1.500 V .. 40.000 V ) at %7.4r  %M", $abstime );
        $fwrite(outfile,"nhvta         VDS     entering SOCA ( -1.500 V .. 40.000 V ) at %7.4r  %M\n", $abstime );
        VDS_retc=0;
        VDS_cnt=VDS_cnt-1;
        $fclose(outfile);
      end
      if((VDS > 40) &&  (VDS_retc!=1))
      begin
        outfile=$fopen(errFileName,"a");
        $strobe("nhvta         VDS     leaving   OCA ( 40.000 V ..  ) at %7.4r  %M", $abstime );
        $fwrite(outfile,"nhvta         VDS     leaving   OCA ( 40.000 V ..  ) at %7.4r  %M\n", $abstime );
        VDS_retc=1;
        VDS_cnt=VDS_cnt-1;
        $fclose(outfile);
      end
   end
   else
   begin
      if(VDS_cnt==0)
      begin
        outfile=$fopen(errFileName,"a");
        $strobe("nhvta         VDS     error limit ( %d ) reached at %7.4r  %M", maxEv, $abstime );
        $fwrite(outfile,"nhvta         VDS     error limit ( %d ) reached at %7.4r  %M\n", maxEv, $abstime );
        VDS_cnt=VDS_cnt-1;
        $fclose(outfile);
      end
   end

//      VDB
   VDB = V_D_B;
   if((VDB_cnt>0) || ( maxEv_flg==0 ))   begin
      if( (VDB < -1.5) && (VDB_retc!=-1))
      begin
        outfile=$fopen(errFileName,"a");
        $strobe("nhvta         VDB     leaving   OCA (  .. -1.500 V ) at %7.4r  %M", $abstime );
        $fwrite(outfile,"nhvta         VDB     leaving   OCA (  .. -1.500 V ) at %7.4r  %M\n", $abstime );
        VDB_retc=-1;
        VDB_cnt=VDB_cnt-1;
        $fclose(outfile);
      end
      if((VDB >= -1.5) &&  (VDB <= 40) && (VDB_retc!=0))
      begin
        outfile=$fopen(errFileName,"a");
        $strobe("nhvta         VDB     entering SOCA ( -1.500 V .. 40.000 V ) at %7.4r  %M", $abstime );
        $fwrite(outfile,"nhvta         VDB     entering SOCA ( -1.500 V .. 40.000 V ) at %7.4r  %M\n", $abstime );
        VDB_retc=0;
        VDB_cnt=VDB_cnt-1;
        $fclose(outfile);
      end
      if((VDB > 40) &&  (VDB_retc!=1))
      begin
        outfile=$fopen(errFileName,"a");
        $strobe("nhvta         VDB     leaving   OCA ( 40.000 V ..  ) at %7.4r  %M", $abstime );
        $fwrite(outfile,"nhvta         VDB     leaving   OCA ( 40.000 V ..  ) at %7.4r  %M\n", $abstime );
        VDB_retc=1;
        VDB_cnt=VDB_cnt-1;
        $fclose(outfile);
      end
   end
   else
   begin
      if(VDB_cnt==0)
      begin
        outfile=$fopen(errFileName,"a");
        $strobe("nhvta         VDB     error limit ( %d ) reached at %7.4r  %M", maxEv, $abstime );
        $fwrite(outfile,"nhvta         VDB     error limit ( %d ) reached at %7.4r  %M\n", maxEv, $abstime );
        VDB_cnt=VDB_cnt-1;
        $fclose(outfile);
      end
   end

//      VDHW
   VDHW = V_D_HW;
   if((VDHW_cnt>0) || ( maxEv_flg==0 ))   begin
      if( (VDHW < -100) && (VDHW_retc!=-1))
      begin
        outfile=$fopen(errFileName,"a");
        $strobe("nhvta         VDHW    leaving   OCA (  .. -100.000 V ) at %7.4r  %M", $abstime );
        $fwrite(outfile,"nhvta         VDHW    leaving   OCA (  .. -100.000 V ) at %7.4r  %M\n", $abstime );
        VDHW_retc=-1;
        VDHW_cnt=VDHW_cnt-1;
        $fclose(outfile);
      end
      if((VDHW >= -100) &&  (VDHW <= 200) && (VDHW_retc!=0))
      begin
        outfile=$fopen(errFileName,"a");
        $strobe("nhvta         VDHW    entering SOCA ( -100.000 V .. 200.000 V ) at %7.4r  %M", $abstime );
        $fwrite(outfile,"nhvta         VDHW    entering SOCA ( -100.000 V .. 200.000 V ) at %7.4r  %M\n", $abstime );
        VDHW_retc=0;
        VDHW_cnt=VDHW_cnt-1;
        $fclose(outfile);
      end
      if((VDHW > 200) &&  (VDHW_retc!=1))
      begin
        outfile=$fopen(errFileName,"a");
        $strobe("nhvta         VDHW    leaving   OCA ( 200.000 V ..  ) at %7.4r  %M", $abstime );
        $fwrite(outfile,"nhvta         VDHW    leaving   OCA ( 200.000 V ..  ) at %7.4r  %M\n", $abstime );
        VDHW_retc=1;
        VDHW_cnt=VDHW_cnt-1;
        $fclose(outfile);
      end
   end
   else
   begin
      if(VDHW_cnt==0)
      begin
        outfile=$fopen(errFileName,"a");
        $strobe("nhvta         VDHW    error limit ( %d ) reached at %7.4r  %M", maxEv, $abstime );
        $fwrite(outfile,"nhvta         VDHW    error limit ( %d ) reached at %7.4r  %M\n", maxEv, $abstime );
        VDHW_cnt=VDHW_cnt-1;
        $fclose(outfile);
      end
   end

end // analog
endmodule // nhvta

// Verilog-A OC Watch for device nhvtaa Parameters  VGS VGD VDS VDB VDHW
module nhvtaa_ahdl(D,G,S,B,HW);
parameter tstep_occ=100n;
parameter errFileName="./occ.err";
parameter maxEv = 25;
parameter maxEv_flg = 0;
inout D,G,S,B,HW;
electrical D,G,S,B,HW;

integer outfile;
real V_D_HW;
real V_D_B;
real V_D_S;
real V_G_D;
real V_G_S;
real VGS;
integer VGS_retc;
integer VGS_cnt;
real VGD;
integer VGD_retc;
integer VGD_cnt;
real VDS;
integer VDS_retc;
integer VDS_cnt;
real VDB;
integer VDB_retc;
integer VDB_cnt;
real VDHW;
integer VDHW_retc;
integer VDHW_cnt;

analog begin
   $bound_step( tstep_occ );
   @(initial_step) begin
      VGS_retc=0;
      VGS_cnt = maxEv;
      VGD_retc=0;
      VGD_cnt = maxEv;
      VDS_retc=0;
      VDS_cnt = maxEv;
      VDB_retc=0;
      VDB_cnt = maxEv;
      VDHW_retc=0;
      VDHW_cnt = maxEv;
   end
   V_D_HW = V(D,HW);
   V_D_B = V(D,B);
   V_D_S = V(D,S);
   V_G_D = V(G,D);
   V_G_S = V(G,S);

//      VGS
   VGS = V_G_S;
   if((VGS_cnt>0) || ( maxEv_flg==0 ))   begin
      if( (VGS < -5.5) && (VGS_retc!=-1))
      begin
        outfile=$fopen(errFileName,"a");
        $strobe("nhvtaa        VGS     leaving   OCA (  .. -5.500 V ) at %7.4r  %M", $abstime );
        $fwrite(outfile,"nhvtaa        VGS     leaving   OCA (  .. -5.500 V ) at %7.4r  %M\n", $abstime );
        VGS_retc=-1;
        VGS_cnt=VGS_cnt-1;
        $fclose(outfile);
      end
      if((VGS >= -5.5) &&  (VGS <= 5.5) && (VGS_retc!=0))
      begin
        outfile=$fopen(errFileName,"a");
        $strobe("nhvtaa        VGS     entering SOCA ( -5.500 V .. 5.500 V ) at %7.4r  %M", $abstime );
        $fwrite(outfile,"nhvtaa        VGS     entering SOCA ( -5.500 V .. 5.500 V ) at %7.4r  %M\n", $abstime );
        VGS_retc=0;
        VGS_cnt=VGS_cnt-1;
        $fclose(outfile);
      end
      if((VGS > 5.5) &&  (VGS_retc!=1))
      begin
        outfile=$fopen(errFileName,"a");
        $strobe("nhvtaa        VGS     leaving   OCA ( 5.500 V ..  ) at %7.4r  %M", $abstime );
        $fwrite(outfile,"nhvtaa        VGS     leaving   OCA ( 5.500 V ..  ) at %7.4r  %M\n", $abstime );
        VGS_retc=1;
        VGS_cnt=VGS_cnt-1;
        $fclose(outfile);
      end
   end
   else
   begin
      if(VGS_cnt==0)
      begin
        outfile=$fopen(errFileName,"a");
        $strobe("nhvtaa        VGS     error limit ( %d ) reached at %7.4r  %M", maxEv, $abstime );
        $fwrite(outfile,"nhvtaa        VGS     error limit ( %d ) reached at %7.4r  %M\n", maxEv, $abstime );
        VGS_cnt=VGS_cnt-1;
        $fclose(outfile);
      end
   end

//      VGD
   VGD = V_G_D;
   if((VGD_cnt>0) || ( maxEv_flg==0 ))   begin
      if( (VGD < -40) && (VGD_retc!=-1))
      begin
        outfile=$fopen(errFileName,"a");
        $strobe("nhvtaa        VGD     leaving   OCA (  .. -40.000 V ) at %7.4r  %M", $abstime );
        $fwrite(outfile,"nhvtaa        VGD     leaving   OCA (  .. -40.000 V ) at %7.4r  %M\n", $abstime );
        VGD_retc=-1;
        VGD_cnt=VGD_cnt-1;
        $fclose(outfile);
      end
      if((VGD >= -40) &&  (VGD <= 5.5) && (VGD_retc!=0))
      begin
        outfile=$fopen(errFileName,"a");
        $strobe("nhvtaa        VGD     entering SOCA ( -40.000 V .. 5.500 V ) at %7.4r  %M", $abstime );
        $fwrite(outfile,"nhvtaa        VGD     entering SOCA ( -40.000 V .. 5.500 V ) at %7.4r  %M\n", $abstime );
        VGD_retc=0;
        VGD_cnt=VGD_cnt-1;
        $fclose(outfile);
      end
      if((VGD > 5.5) &&  (VGD_retc!=1))
      begin
        outfile=$fopen(errFileName,"a");
        $strobe("nhvtaa        VGD     leaving   OCA ( 5.500 V ..  ) at %7.4r  %M", $abstime );
        $fwrite(outfile,"nhvtaa        VGD     leaving   OCA ( 5.500 V ..  ) at %7.4r  %M\n", $abstime );
        VGD_retc=1;
        VGD_cnt=VGD_cnt-1;
        $fclose(outfile);
      end
   end
   else
   begin
      if(VGD_cnt==0)
      begin
        outfile=$fopen(errFileName,"a");
        $strobe("nhvtaa        VGD     error limit ( %d ) reached at %7.4r  %M", maxEv, $abstime );
        $fwrite(outfile,"nhvtaa        VGD     error limit ( %d ) reached at %7.4r  %M\n", maxEv, $abstime );
        VGD_cnt=VGD_cnt-1;
        $fclose(outfile);
      end
   end

//      VDS
   VDS = V_D_S;
   if((VDS_cnt>0) || ( maxEv_flg==0 ))   begin
      if( (VDS < -1.5) && (VDS_retc!=-1))
      begin
        outfile=$fopen(errFileName,"a");
        $strobe("nhvtaa        VDS     leaving   OCA (  .. -1.500 V ) at %7.4r  %M", $abstime );
        $fwrite(outfile,"nhvtaa        VDS     leaving   OCA (  .. -1.500 V ) at %7.4r  %M\n", $abstime );
        VDS_retc=-1;
        VDS_cnt=VDS_cnt-1;
        $fclose(outfile);
      end
      if((VDS >= -1.5) &&  (VDS <= 40) && (VDS_retc!=0))
      begin
        outfile=$fopen(errFileName,"a");
        $strobe("nhvtaa        VDS     entering SOCA ( -1.500 V .. 40.000 V ) at %7.4r  %M", $abstime );
        $fwrite(outfile,"nhvtaa        VDS     entering SOCA ( -1.500 V .. 40.000 V ) at %7.4r  %M\n", $abstime );
        VDS_retc=0;
        VDS_cnt=VDS_cnt-1;
        $fclose(outfile);
      end
      if((VDS > 40) &&  (VDS_retc!=1))
      begin
        outfile=$fopen(errFileName,"a");
        $strobe("nhvtaa        VDS     leaving   OCA ( 40.000 V ..  ) at %7.4r  %M", $abstime );
        $fwrite(outfile,"nhvtaa        VDS     leaving   OCA ( 40.000 V ..  ) at %7.4r  %M\n", $abstime );
        VDS_retc=1;
        VDS_cnt=VDS_cnt-1;
        $fclose(outfile);
      end
   end
   else
   begin
      if(VDS_cnt==0)
      begin
        outfile=$fopen(errFileName,"a");
        $strobe("nhvtaa        VDS     error limit ( %d ) reached at %7.4r  %M", maxEv, $abstime );
        $fwrite(outfile,"nhvtaa        VDS     error limit ( %d ) reached at %7.4r  %M\n", maxEv, $abstime );
        VDS_cnt=VDS_cnt-1;
        $fclose(outfile);
      end
   end

//      VDB
   VDB = V_D_B;
   if((VDB_cnt>0) || ( maxEv_flg==0 ))   begin
      if( (VDB < -1.5) && (VDB_retc!=-1))
      begin
        outfile=$fopen(errFileName,"a");
        $strobe("nhvtaa        VDB     leaving   OCA (  .. -1.500 V ) at %7.4r  %M", $abstime );
        $fwrite(outfile,"nhvtaa        VDB     leaving   OCA (  .. -1.500 V ) at %7.4r  %M\n", $abstime );
        VDB_retc=-1;
        VDB_cnt=VDB_cnt-1;
        $fclose(outfile);
      end
      if((VDB >= -1.5) &&  (VDB <= 40) && (VDB_retc!=0))
      begin
        outfile=$fopen(errFileName,"a");
        $strobe("nhvtaa        VDB     entering SOCA ( -1.500 V .. 40.000 V ) at %7.4r  %M", $abstime );
        $fwrite(outfile,"nhvtaa        VDB     entering SOCA ( -1.500 V .. 40.000 V ) at %7.4r  %M\n", $abstime );
        VDB_retc=0;
        VDB_cnt=VDB_cnt-1;
        $fclose(outfile);
      end
      if((VDB > 40) &&  (VDB_retc!=1))
      begin
        outfile=$fopen(errFileName,"a");
        $strobe("nhvtaa        VDB     leaving   OCA ( 40.000 V ..  ) at %7.4r  %M", $abstime );
        $fwrite(outfile,"nhvtaa        VDB     leaving   OCA ( 40.000 V ..  ) at %7.4r  %M\n", $abstime );
        VDB_retc=1;
        VDB_cnt=VDB_cnt-1;
        $fclose(outfile);
      end
   end
   else
   begin
      if(VDB_cnt==0)
      begin
        outfile=$fopen(errFileName,"a");
        $strobe("nhvtaa        VDB     error limit ( %d ) reached at %7.4r  %M", maxEv, $abstime );
        $fwrite(outfile,"nhvtaa        VDB     error limit ( %d ) reached at %7.4r  %M\n", maxEv, $abstime );
        VDB_cnt=VDB_cnt-1;
        $fclose(outfile);
      end
   end

//      VDHW
   VDHW = V_D_HW;
   if((VDHW_cnt>0) || ( maxEv_flg==0 ))   begin
      if( (VDHW < -100) && (VDHW_retc!=-1))
      begin
        outfile=$fopen(errFileName,"a");
        $strobe("nhvtaa        VDHW    leaving   OCA (  .. -100.000 V ) at %7.4r  %M", $abstime );
        $fwrite(outfile,"nhvtaa        VDHW    leaving   OCA (  .. -100.000 V ) at %7.4r  %M\n", $abstime );
        VDHW_retc=-1;
        VDHW_cnt=VDHW_cnt-1;
        $fclose(outfile);
      end
      if((VDHW >= -100) &&  (VDHW <= 200) && (VDHW_retc!=0))
      begin
        outfile=$fopen(errFileName,"a");
        $strobe("nhvtaa        VDHW    entering SOCA ( -100.000 V .. 200.000 V ) at %7.4r  %M", $abstime );
        $fwrite(outfile,"nhvtaa        VDHW    entering SOCA ( -100.000 V .. 200.000 V ) at %7.4r  %M\n", $abstime );
        VDHW_retc=0;
        VDHW_cnt=VDHW_cnt-1;
        $fclose(outfile);
      end
      if((VDHW > 200) &&  (VDHW_retc!=1))
      begin
        outfile=$fopen(errFileName,"a");
        $strobe("nhvtaa        VDHW    leaving   OCA ( 200.000 V ..  ) at %7.4r  %M", $abstime );
        $fwrite(outfile,"nhvtaa        VDHW    leaving   OCA ( 200.000 V ..  ) at %7.4r  %M\n", $abstime );
        VDHW_retc=1;
        VDHW_cnt=VDHW_cnt-1;
        $fclose(outfile);
      end
   end
   else
   begin
      if(VDHW_cnt==0)
      begin
        outfile=$fopen(errFileName,"a");
        $strobe("nhvtaa        VDHW    error limit ( %d ) reached at %7.4r  %M", maxEv, $abstime );
        $fwrite(outfile,"nhvtaa        VDHW    error limit ( %d ) reached at %7.4r  %M\n", maxEv, $abstime );
        VDHW_cnt=VDHW_cnt-1;
        $fclose(outfile);
      end
   end

end // analog
endmodule // nhvtaa

// Verilog-A OC Watch for device nhvtb Parameters  VGS VGD VDS VDB VDHW
module nhvtb_ahdl(D,G,S,B,HW);
parameter tstep_occ=100n;
parameter errFileName="./occ.err";
parameter maxEv = 25;
parameter maxEv_flg = 0;
inout D,G,S,B,HW;
electrical D,G,S,B,HW;

integer outfile;
real V_D_HW;
real V_D_B;
real V_D_S;
real V_G_D;
real V_G_S;
real VGS;
integer VGS_retc;
integer VGS_cnt;
real VGD;
integer VGD_retc;
integer VGD_cnt;
real VDS;
integer VDS_retc;
integer VDS_cnt;
real VDB;
integer VDB_retc;
integer VDB_cnt;
real VDHW;
integer VDHW_retc;
integer VDHW_cnt;

analog begin
   $bound_step( tstep_occ );
   @(initial_step) begin
      VGS_retc=0;
      VGS_cnt = maxEv;
      VGD_retc=0;
      VGD_cnt = maxEv;
      VDS_retc=0;
      VDS_cnt = maxEv;
      VDB_retc=0;
      VDB_cnt = maxEv;
      VDHW_retc=0;
      VDHW_cnt = maxEv;
   end
   V_D_HW = V(D,HW);
   V_D_B = V(D,B);
   V_D_S = V(D,S);
   V_G_D = V(G,D);
   V_G_S = V(G,S);

//      VGS
   VGS = V_G_S;
   if((VGS_cnt>0) || ( maxEv_flg==0 ))   begin
      if( (VGS < -5.5) && (VGS_retc!=-1))
      begin
        outfile=$fopen(errFileName,"a");
        $strobe("nhvtb         VGS     leaving   OCA (  .. -5.500 V ) at %7.4r  %M", $abstime );
        $fwrite(outfile,"nhvtb         VGS     leaving   OCA (  .. -5.500 V ) at %7.4r  %M\n", $abstime );
        VGS_retc=-1;
        VGS_cnt=VGS_cnt-1;
        $fclose(outfile);
      end
      if((VGS >= -5.5) &&  (VGS <= 5.5) && (VGS_retc!=0))
      begin
        outfile=$fopen(errFileName,"a");
        $strobe("nhvtb         VGS     entering SOCA ( -5.500 V .. 5.500 V ) at %7.4r  %M", $abstime );
        $fwrite(outfile,"nhvtb         VGS     entering SOCA ( -5.500 V .. 5.500 V ) at %7.4r  %M\n", $abstime );
        VGS_retc=0;
        VGS_cnt=VGS_cnt-1;
        $fclose(outfile);
      end
      if((VGS > 5.5) &&  (VGS_retc!=1))
      begin
        outfile=$fopen(errFileName,"a");
        $strobe("nhvtb         VGS     leaving   OCA ( 5.500 V ..  ) at %7.4r  %M", $abstime );
        $fwrite(outfile,"nhvtb         VGS     leaving   OCA ( 5.500 V ..  ) at %7.4r  %M\n", $abstime );
        VGS_retc=1;
        VGS_cnt=VGS_cnt-1;
        $fclose(outfile);
      end
   end
   else
   begin
      if(VGS_cnt==0)
      begin
        outfile=$fopen(errFileName,"a");
        $strobe("nhvtb         VGS     error limit ( %d ) reached at %7.4r  %M", maxEv, $abstime );
        $fwrite(outfile,"nhvtb         VGS     error limit ( %d ) reached at %7.4r  %M\n", maxEv, $abstime );
        VGS_cnt=VGS_cnt-1;
        $fclose(outfile);
      end
   end

//      VGD
   VGD = V_G_D;
   if((VGD_cnt>0) || ( maxEv_flg==0 ))   begin
      if( (VGD < -40) && (VGD_retc!=-1))
      begin
        outfile=$fopen(errFileName,"a");
        $strobe("nhvtb         VGD     leaving   OCA (  .. -40.000 V ) at %7.4r  %M", $abstime );
        $fwrite(outfile,"nhvtb         VGD     leaving   OCA (  .. -40.000 V ) at %7.4r  %M\n", $abstime );
        VGD_retc=-1;
        VGD_cnt=VGD_cnt-1;
        $fclose(outfile);
      end
      if((VGD >= -40) &&  (VGD <= 5.5) && (VGD_retc!=0))
      begin
        outfile=$fopen(errFileName,"a");
        $strobe("nhvtb         VGD     entering SOCA ( -40.000 V .. 5.500 V ) at %7.4r  %M", $abstime );
        $fwrite(outfile,"nhvtb         VGD     entering SOCA ( -40.000 V .. 5.500 V ) at %7.4r  %M\n", $abstime );
        VGD_retc=0;
        VGD_cnt=VGD_cnt-1;
        $fclose(outfile);
      end
      if((VGD > 5.5) &&  (VGD_retc!=1))
      begin
        outfile=$fopen(errFileName,"a");
        $strobe("nhvtb         VGD     leaving   OCA ( 5.500 V ..  ) at %7.4r  %M", $abstime );
        $fwrite(outfile,"nhvtb         VGD     leaving   OCA ( 5.500 V ..  ) at %7.4r  %M\n", $abstime );
        VGD_retc=1;
        VGD_cnt=VGD_cnt-1;
        $fclose(outfile);
      end
   end
   else
   begin
      if(VGD_cnt==0)
      begin
        outfile=$fopen(errFileName,"a");
        $strobe("nhvtb         VGD     error limit ( %d ) reached at %7.4r  %M", maxEv, $abstime );
        $fwrite(outfile,"nhvtb         VGD     error limit ( %d ) reached at %7.4r  %M\n", maxEv, $abstime );
        VGD_cnt=VGD_cnt-1;
        $fclose(outfile);
      end
   end

//      VDS
   VDS = V_D_S;
   if((VDS_cnt>0) || ( maxEv_flg==0 ))   begin
      if( (VDS < -1.5) && (VDS_retc!=-1))
      begin
        outfile=$fopen(errFileName,"a");
        $strobe("nhvtb         VDS     leaving   OCA (  .. -1.500 V ) at %7.4r  %M", $abstime );
        $fwrite(outfile,"nhvtb         VDS     leaving   OCA (  .. -1.500 V ) at %7.4r  %M\n", $abstime );
        VDS_retc=-1;
        VDS_cnt=VDS_cnt-1;
        $fclose(outfile);
      end
      if((VDS >= -1.5) &&  (VDS <= 40) && (VDS_retc!=0))
      begin
        outfile=$fopen(errFileName,"a");
        $strobe("nhvtb         VDS     entering SOCA ( -1.500 V .. 40.000 V ) at %7.4r  %M", $abstime );
        $fwrite(outfile,"nhvtb         VDS     entering SOCA ( -1.500 V .. 40.000 V ) at %7.4r  %M\n", $abstime );
        VDS_retc=0;
        VDS_cnt=VDS_cnt-1;
        $fclose(outfile);
      end
      if((VDS > 40) &&  (VDS_retc!=1))
      begin
        outfile=$fopen(errFileName,"a");
        $strobe("nhvtb         VDS     leaving   OCA ( 40.000 V ..  ) at %7.4r  %M", $abstime );
        $fwrite(outfile,"nhvtb         VDS     leaving   OCA ( 40.000 V ..  ) at %7.4r  %M\n", $abstime );
        VDS_retc=1;
        VDS_cnt=VDS_cnt-1;
        $fclose(outfile);
      end
   end
   else
   begin
      if(VDS_cnt==0)
      begin
        outfile=$fopen(errFileName,"a");
        $strobe("nhvtb         VDS     error limit ( %d ) reached at %7.4r  %M", maxEv, $abstime );
        $fwrite(outfile,"nhvtb         VDS     error limit ( %d ) reached at %7.4r  %M\n", maxEv, $abstime );
        VDS_cnt=VDS_cnt-1;
        $fclose(outfile);
      end
   end

//      VDB
   VDB = V_D_B;
   if((VDB_cnt>0) || ( maxEv_flg==0 ))   begin
      if( (VDB < -1.5) && (VDB_retc!=-1))
      begin
        outfile=$fopen(errFileName,"a");
        $strobe("nhvtb         VDB     leaving   OCA (  .. -1.500 V ) at %7.4r  %M", $abstime );
        $fwrite(outfile,"nhvtb         VDB     leaving   OCA (  .. -1.500 V ) at %7.4r  %M\n", $abstime );
        VDB_retc=-1;
        VDB_cnt=VDB_cnt-1;
        $fclose(outfile);
      end
      if((VDB >= -1.5) &&  (VDB <= 40) && (VDB_retc!=0))
      begin
        outfile=$fopen(errFileName,"a");
        $strobe("nhvtb         VDB     entering SOCA ( -1.500 V .. 40.000 V ) at %7.4r  %M", $abstime );
        $fwrite(outfile,"nhvtb         VDB     entering SOCA ( -1.500 V .. 40.000 V ) at %7.4r  %M\n", $abstime );
        VDB_retc=0;
        VDB_cnt=VDB_cnt-1;
        $fclose(outfile);
      end
      if((VDB > 40) &&  (VDB_retc!=1))
      begin
        outfile=$fopen(errFileName,"a");
        $strobe("nhvtb         VDB     leaving   OCA ( 40.000 V ..  ) at %7.4r  %M", $abstime );
        $fwrite(outfile,"nhvtb         VDB     leaving   OCA ( 40.000 V ..  ) at %7.4r  %M\n", $abstime );
        VDB_retc=1;
        VDB_cnt=VDB_cnt-1;
        $fclose(outfile);
      end
   end
   else
   begin
      if(VDB_cnt==0)
      begin
        outfile=$fopen(errFileName,"a");
        $strobe("nhvtb         VDB     error limit ( %d ) reached at %7.4r  %M", maxEv, $abstime );
        $fwrite(outfile,"nhvtb         VDB     error limit ( %d ) reached at %7.4r  %M\n", maxEv, $abstime );
        VDB_cnt=VDB_cnt-1;
        $fclose(outfile);
      end
   end

//      VDHW
   VDHW = V_D_HW;
   if((VDHW_cnt>0) || ( maxEv_flg==0 ))   begin
      if( (VDHW < -100) && (VDHW_retc!=-1))
      begin
        outfile=$fopen(errFileName,"a");
        $strobe("nhvtb         VDHW    leaving   OCA (  .. -100.000 V ) at %7.4r  %M", $abstime );
        $fwrite(outfile,"nhvtb         VDHW    leaving   OCA (  .. -100.000 V ) at %7.4r  %M\n", $abstime );
        VDHW_retc=-1;
        VDHW_cnt=VDHW_cnt-1;
        $fclose(outfile);
      end
      if((VDHW >= -100) &&  (VDHW <= 200) && (VDHW_retc!=0))
      begin
        outfile=$fopen(errFileName,"a");
        $strobe("nhvtb         VDHW    entering SOCA ( -100.000 V .. 200.000 V ) at %7.4r  %M", $abstime );
        $fwrite(outfile,"nhvtb         VDHW    entering SOCA ( -100.000 V .. 200.000 V ) at %7.4r  %M\n", $abstime );
        VDHW_retc=0;
        VDHW_cnt=VDHW_cnt-1;
        $fclose(outfile);
      end
      if((VDHW > 200) &&  (VDHW_retc!=1))
      begin
        outfile=$fopen(errFileName,"a");
        $strobe("nhvtb         VDHW    leaving   OCA ( 200.000 V ..  ) at %7.4r  %M", $abstime );
        $fwrite(outfile,"nhvtb         VDHW    leaving   OCA ( 200.000 V ..  ) at %7.4r  %M\n", $abstime );
        VDHW_retc=1;
        VDHW_cnt=VDHW_cnt-1;
        $fclose(outfile);
      end
   end
   else
   begin
      if(VDHW_cnt==0)
      begin
        outfile=$fopen(errFileName,"a");
        $strobe("nhvtb         VDHW    error limit ( %d ) reached at %7.4r  %M", maxEv, $abstime );
        $fwrite(outfile,"nhvtb         VDHW    error limit ( %d ) reached at %7.4r  %M\n", maxEv, $abstime );
        VDHW_cnt=VDHW_cnt-1;
        $fclose(outfile);
      end
   end

end // analog
endmodule // nhvtb

// Verilog-A OC Watch for device nhvu Parameters  VGS VGD VDS VDB VDHW
module nhvu_ahdl(D,G,S,B,HW);
parameter tstep_occ=100n;
parameter errFileName="./occ.err";
parameter maxEv = 25;
parameter maxEv_flg = 0;
inout D,G,S,B,HW;
electrical D,G,S,B,HW;

integer outfile;
real V_D_HW;
real V_D_B;
real V_D_S;
real V_G_D;
real V_G_S;
real VGS;
integer VGS_retc;
integer VGS_cnt;
real VGD;
integer VGD_retc;
integer VGD_cnt;
real VDS;
integer VDS_retc;
integer VDS_cnt;
real VDB;
integer VDB_retc;
integer VDB_cnt;
real VDHW;
integer VDHW_retc;
integer VDHW_cnt;

analog begin
   $bound_step( tstep_occ );
   @(initial_step) begin
      VGS_retc=0;
      VGS_cnt = maxEv;
      VGD_retc=0;
      VGD_cnt = maxEv;
      VDS_retc=0;
      VDS_cnt = maxEv;
      VDB_retc=0;
      VDB_cnt = maxEv;
      VDHW_retc=0;
      VDHW_cnt = maxEv;
   end
   V_D_HW = V(D,HW);
   V_D_B = V(D,B);
   V_D_S = V(D,S);
   V_G_D = V(G,D);
   V_G_S = V(G,S);

//      VGS
   VGS = V_G_S;
   if((VGS_cnt>0) || ( maxEv_flg==0 ))   begin
      if( (VGS < -5.5) && (VGS_retc!=-1))
      begin
        outfile=$fopen(errFileName,"a");
        $strobe("nhvu          VGS     leaving   OCA (  .. -5.500 V ) at %7.4r  %M", $abstime );
        $fwrite(outfile,"nhvu          VGS     leaving   OCA (  .. -5.500 V ) at %7.4r  %M\n", $abstime );
        VGS_retc=-1;
        VGS_cnt=VGS_cnt-1;
        $fclose(outfile);
      end
      if((VGS >= -5.5) &&  (VGS <= 5.5) && (VGS_retc!=0))
      begin
        outfile=$fopen(errFileName,"a");
        $strobe("nhvu          VGS     entering SOCA ( -5.500 V .. 5.500 V ) at %7.4r  %M", $abstime );
        $fwrite(outfile,"nhvu          VGS     entering SOCA ( -5.500 V .. 5.500 V ) at %7.4r  %M\n", $abstime );
        VGS_retc=0;
        VGS_cnt=VGS_cnt-1;
        $fclose(outfile);
      end
      if((VGS > 5.5) &&  (VGS_retc!=1))
      begin
        outfile=$fopen(errFileName,"a");
        $strobe("nhvu          VGS     leaving   OCA ( 5.500 V ..  ) at %7.4r  %M", $abstime );
        $fwrite(outfile,"nhvu          VGS     leaving   OCA ( 5.500 V ..  ) at %7.4r  %M\n", $abstime );
        VGS_retc=1;
        VGS_cnt=VGS_cnt-1;
        $fclose(outfile);
      end
   end
   else
   begin
      if(VGS_cnt==0)
      begin
        outfile=$fopen(errFileName,"a");
        $strobe("nhvu          VGS     error limit ( %d ) reached at %7.4r  %M", maxEv, $abstime );
        $fwrite(outfile,"nhvu          VGS     error limit ( %d ) reached at %7.4r  %M\n", maxEv, $abstime );
        VGS_cnt=VGS_cnt-1;
        $fclose(outfile);
      end
   end

//      VGD
   VGD = V_G_D;
   if((VGD_cnt>0) || ( maxEv_flg==0 ))   begin
      if( (VGD < -60) && (VGD_retc!=-1))
      begin
        outfile=$fopen(errFileName,"a");
        $strobe("nhvu          VGD     leaving   OCA (  .. -60.000 V ) at %7.4r  %M", $abstime );
        $fwrite(outfile,"nhvu          VGD     leaving   OCA (  .. -60.000 V ) at %7.4r  %M\n", $abstime );
        VGD_retc=-1;
        VGD_cnt=VGD_cnt-1;
        $fclose(outfile);
      end
      if((VGD >= -60) &&  (VGD <= 5.5) && (VGD_retc!=0))
      begin
        outfile=$fopen(errFileName,"a");
        $strobe("nhvu          VGD     entering SOCA ( -60.000 V .. 5.500 V ) at %7.4r  %M", $abstime );
        $fwrite(outfile,"nhvu          VGD     entering SOCA ( -60.000 V .. 5.500 V ) at %7.4r  %M\n", $abstime );
        VGD_retc=0;
        VGD_cnt=VGD_cnt-1;
        $fclose(outfile);
      end
      if((VGD > 5.5) &&  (VGD_retc!=1))
      begin
        outfile=$fopen(errFileName,"a");
        $strobe("nhvu          VGD     leaving   OCA ( 5.500 V ..  ) at %7.4r  %M", $abstime );
        $fwrite(outfile,"nhvu          VGD     leaving   OCA ( 5.500 V ..  ) at %7.4r  %M\n", $abstime );
        VGD_retc=1;
        VGD_cnt=VGD_cnt-1;
        $fclose(outfile);
      end
   end
   else
   begin
      if(VGD_cnt==0)
      begin
        outfile=$fopen(errFileName,"a");
        $strobe("nhvu          VGD     error limit ( %d ) reached at %7.4r  %M", maxEv, $abstime );
        $fwrite(outfile,"nhvu          VGD     error limit ( %d ) reached at %7.4r  %M\n", maxEv, $abstime );
        VGD_cnt=VGD_cnt-1;
        $fclose(outfile);
      end
   end

//      VDS
   VDS = V_D_S;
   if((VDS_cnt>0) || ( maxEv_flg==0 ))   begin
      if( (VDS < -1.5) && (VDS_retc!=-1))
      begin
        outfile=$fopen(errFileName,"a");
        $strobe("nhvu          VDS     leaving   OCA (  .. -1.500 V ) at %7.4r  %M", $abstime );
        $fwrite(outfile,"nhvu          VDS     leaving   OCA (  .. -1.500 V ) at %7.4r  %M\n", $abstime );
        VDS_retc=-1;
        VDS_cnt=VDS_cnt-1;
        $fclose(outfile);
      end
      if((VDS >= -1.5) &&  (VDS <= 60) && (VDS_retc!=0))
      begin
        outfile=$fopen(errFileName,"a");
        $strobe("nhvu          VDS     entering SOCA ( -1.500 V .. 60.000 V ) at %7.4r  %M", $abstime );
        $fwrite(outfile,"nhvu          VDS     entering SOCA ( -1.500 V .. 60.000 V ) at %7.4r  %M\n", $abstime );
        VDS_retc=0;
        VDS_cnt=VDS_cnt-1;
        $fclose(outfile);
      end
      if((VDS > 60) &&  (VDS_retc!=1))
      begin
        outfile=$fopen(errFileName,"a");
        $strobe("nhvu          VDS     leaving   OCA ( 60.000 V ..  ) at %7.4r  %M", $abstime );
        $fwrite(outfile,"nhvu          VDS     leaving   OCA ( 60.000 V ..  ) at %7.4r  %M\n", $abstime );
        VDS_retc=1;
        VDS_cnt=VDS_cnt-1;
        $fclose(outfile);
      end
   end
   else
   begin
      if(VDS_cnt==0)
      begin
        outfile=$fopen(errFileName,"a");
        $strobe("nhvu          VDS     error limit ( %d ) reached at %7.4r  %M", maxEv, $abstime );
        $fwrite(outfile,"nhvu          VDS     error limit ( %d ) reached at %7.4r  %M\n", maxEv, $abstime );
        VDS_cnt=VDS_cnt-1;
        $fclose(outfile);
      end
   end

//      VDB
   VDB = V_D_B;
   if((VDB_cnt>0) || ( maxEv_flg==0 ))   begin
      if( (VDB < -1.5) && (VDB_retc!=-1))
      begin
        outfile=$fopen(errFileName,"a");
        $strobe("nhvu          VDB     leaving   OCA (  .. -1.500 V ) at %7.4r  %M", $abstime );
        $fwrite(outfile,"nhvu          VDB     leaving   OCA (  .. -1.500 V ) at %7.4r  %M\n", $abstime );
        VDB_retc=-1;
        VDB_cnt=VDB_cnt-1;
        $fclose(outfile);
      end
      if((VDB >= -1.5) &&  (VDB <= 60) && (VDB_retc!=0))
      begin
        outfile=$fopen(errFileName,"a");
        $strobe("nhvu          VDB     entering SOCA ( -1.500 V .. 60.000 V ) at %7.4r  %M", $abstime );
        $fwrite(outfile,"nhvu          VDB     entering SOCA ( -1.500 V .. 60.000 V ) at %7.4r  %M\n", $abstime );
        VDB_retc=0;
        VDB_cnt=VDB_cnt-1;
        $fclose(outfile);
      end
      if((VDB > 60) &&  (VDB_retc!=1))
      begin
        outfile=$fopen(errFileName,"a");
        $strobe("nhvu          VDB     leaving   OCA ( 60.000 V ..  ) at %7.4r  %M", $abstime );
        $fwrite(outfile,"nhvu          VDB     leaving   OCA ( 60.000 V ..  ) at %7.4r  %M\n", $abstime );
        VDB_retc=1;
        VDB_cnt=VDB_cnt-1;
        $fclose(outfile);
      end
   end
   else
   begin
      if(VDB_cnt==0)
      begin
        outfile=$fopen(errFileName,"a");
        $strobe("nhvu          VDB     error limit ( %d ) reached at %7.4r  %M", maxEv, $abstime );
        $fwrite(outfile,"nhvu          VDB     error limit ( %d ) reached at %7.4r  %M\n", maxEv, $abstime );
        VDB_cnt=VDB_cnt-1;
        $fclose(outfile);
      end
   end

//      VDHW
   VDHW = V_D_HW;
   if((VDHW_cnt>0) || ( maxEv_flg==0 ))   begin
      if( (VDHW < -100) && (VDHW_retc!=-1))
      begin
        outfile=$fopen(errFileName,"a");
        $strobe("nhvu          VDHW    leaving   OCA (  .. -100.000 V ) at %7.4r  %M", $abstime );
        $fwrite(outfile,"nhvu          VDHW    leaving   OCA (  .. -100.000 V ) at %7.4r  %M\n", $abstime );
        VDHW_retc=-1;
        VDHW_cnt=VDHW_cnt-1;
        $fclose(outfile);
      end
      if((VDHW >= -100) &&  (VDHW <= 60) && (VDHW_retc!=0))
      begin
        outfile=$fopen(errFileName,"a");
        $strobe("nhvu          VDHW    entering SOCA ( -100.000 V .. 60.000 V ) at %7.4r  %M", $abstime );
        $fwrite(outfile,"nhvu          VDHW    entering SOCA ( -100.000 V .. 60.000 V ) at %7.4r  %M\n", $abstime );
        VDHW_retc=0;
        VDHW_cnt=VDHW_cnt-1;
        $fclose(outfile);
      end
      if((VDHW > 60) &&  (VDHW_retc!=1))
      begin
        outfile=$fopen(errFileName,"a");
        $strobe("nhvu          VDHW    leaving   OCA ( 60.000 V ..  ) at %7.4r  %M", $abstime );
        $fwrite(outfile,"nhvu          VDHW    leaving   OCA ( 60.000 V ..  ) at %7.4r  %M\n", $abstime );
        VDHW_retc=1;
        VDHW_cnt=VDHW_cnt-1;
        $fclose(outfile);
      end
   end
   else
   begin
      if(VDHW_cnt==0)
      begin
        outfile=$fopen(errFileName,"a");
        $strobe("nhvu          VDHW    error limit ( %d ) reached at %7.4r  %M", maxEv, $abstime );
        $fwrite(outfile,"nhvu          VDHW    error limit ( %d ) reached at %7.4r  %M\n", maxEv, $abstime );
        VDHW_cnt=VDHW_cnt-1;
        $fclose(outfile);
      end
   end

end // analog
endmodule // nhvu

// Verilog-A OC Watch for device ndhvt Parameters  VGS VGD VDS VDB VDHW
module ndhvt_ahdl(D,G,S,B,HW);
parameter tstep_occ=100n;
parameter errFileName="./occ.err";
parameter maxEv = 25;
parameter maxEv_flg = 0;
inout D,G,S,B,HW;
electrical D,G,S,B,HW;

integer outfile;
real V_D_HW;
real V_D_B;
real V_D_S;
real V_G_D;
real V_G_S;
real VGS;
integer VGS_retc;
integer VGS_cnt;
real VGD;
integer VGD_retc;
integer VGD_cnt;
real VDS;
integer VDS_retc;
integer VDS_cnt;
real VDB;
integer VDB_retc;
integer VDB_cnt;
real VDHW;
integer VDHW_retc;
integer VDHW_cnt;

analog begin
   $bound_step( tstep_occ );
   @(initial_step) begin
      VGS_retc=0;
      VGS_cnt = maxEv;
      VGD_retc=0;
      VGD_cnt = maxEv;
      VDS_retc=0;
      VDS_cnt = maxEv;
      VDB_retc=0;
      VDB_cnt = maxEv;
      VDHW_retc=0;
      VDHW_cnt = maxEv;
   end
   V_D_HW = V(D,HW);
   V_D_B = V(D,B);
   V_D_S = V(D,S);
   V_G_D = V(G,D);
   V_G_S = V(G,S);

//      VGS
   VGS = V_G_S;
   if((VGS_cnt>0) || ( maxEv_flg==0 ))   begin
      if( (VGS < -5.5) && (VGS_retc!=-1))
      begin
        outfile=$fopen(errFileName,"a");
        $strobe("ndhvt         VGS     leaving   OCA (  .. -5.500 V ) at %7.4r  %M", $abstime );
        $fwrite(outfile,"ndhvt         VGS     leaving   OCA (  .. -5.500 V ) at %7.4r  %M\n", $abstime );
        VGS_retc=-1;
        VGS_cnt=VGS_cnt-1;
        $fclose(outfile);
      end
      if((VGS >= -5.5) &&  (VGS <= 5.5) && (VGS_retc!=0))
      begin
        outfile=$fopen(errFileName,"a");
        $strobe("ndhvt         VGS     entering SOCA ( -5.500 V .. 5.500 V ) at %7.4r  %M", $abstime );
        $fwrite(outfile,"ndhvt         VGS     entering SOCA ( -5.500 V .. 5.500 V ) at %7.4r  %M\n", $abstime );
        VGS_retc=0;
        VGS_cnt=VGS_cnt-1;
        $fclose(outfile);
      end
      if((VGS > 5.5) &&  (VGS_retc!=1))
      begin
        outfile=$fopen(errFileName,"a");
        $strobe("ndhvt         VGS     leaving   OCA ( 5.500 V ..  ) at %7.4r  %M", $abstime );
        $fwrite(outfile,"ndhvt         VGS     leaving   OCA ( 5.500 V ..  ) at %7.4r  %M\n", $abstime );
        VGS_retc=1;
        VGS_cnt=VGS_cnt-1;
        $fclose(outfile);
      end
   end
   else
   begin
      if(VGS_cnt==0)
      begin
        outfile=$fopen(errFileName,"a");
        $strobe("ndhvt         VGS     error limit ( %d ) reached at %7.4r  %M", maxEv, $abstime );
        $fwrite(outfile,"ndhvt         VGS     error limit ( %d ) reached at %7.4r  %M\n", maxEv, $abstime );
        VGS_cnt=VGS_cnt-1;
        $fclose(outfile);
      end
   end

//      VGD
   VGD = V_G_D;
   if((VGD_cnt>0) || ( maxEv_flg==0 ))   begin
      if( (VGD < -40) && (VGD_retc!=-1))
      begin
        outfile=$fopen(errFileName,"a");
        $strobe("ndhvt         VGD     leaving   OCA (  .. -40.000 V ) at %7.4r  %M", $abstime );
        $fwrite(outfile,"ndhvt         VGD     leaving   OCA (  .. -40.000 V ) at %7.4r  %M\n", $abstime );
        VGD_retc=-1;
        VGD_cnt=VGD_cnt-1;
        $fclose(outfile);
      end
      if((VGD >= -40) &&  (VGD <= 5.5) && (VGD_retc!=0))
      begin
        outfile=$fopen(errFileName,"a");
        $strobe("ndhvt         VGD     entering SOCA ( -40.000 V .. 5.500 V ) at %7.4r  %M", $abstime );
        $fwrite(outfile,"ndhvt         VGD     entering SOCA ( -40.000 V .. 5.500 V ) at %7.4r  %M\n", $abstime );
        VGD_retc=0;
        VGD_cnt=VGD_cnt-1;
        $fclose(outfile);
      end
      if((VGD > 5.5) &&  (VGD_retc!=1))
      begin
        outfile=$fopen(errFileName,"a");
        $strobe("ndhvt         VGD     leaving   OCA ( 5.500 V ..  ) at %7.4r  %M", $abstime );
        $fwrite(outfile,"ndhvt         VGD     leaving   OCA ( 5.500 V ..  ) at %7.4r  %M\n", $abstime );
        VGD_retc=1;
        VGD_cnt=VGD_cnt-1;
        $fclose(outfile);
      end
   end
   else
   begin
      if(VGD_cnt==0)
      begin
        outfile=$fopen(errFileName,"a");
        $strobe("ndhvt         VGD     error limit ( %d ) reached at %7.4r  %M", maxEv, $abstime );
        $fwrite(outfile,"ndhvt         VGD     error limit ( %d ) reached at %7.4r  %M\n", maxEv, $abstime );
        VGD_cnt=VGD_cnt-1;
        $fclose(outfile);
      end
   end

//      VDS
   VDS = V_D_S;
   if((VDS_cnt>0) || ( maxEv_flg==0 ))   begin
      if( (VDS < -0.1) && (VDS_retc!=-1))
      begin
        outfile=$fopen(errFileName,"a");
        $strobe("ndhvt         VDS     leaving   OCA (  .. -0.100 V ) at %7.4r  %M", $abstime );
        $fwrite(outfile,"ndhvt         VDS     leaving   OCA (  .. -0.100 V ) at %7.4r  %M\n", $abstime );
        VDS_retc=-1;
        VDS_cnt=VDS_cnt-1;
        $fclose(outfile);
      end
      if((VDS >= -0.1) &&  (VDS <= 40) && (VDS_retc!=0))
      begin
        outfile=$fopen(errFileName,"a");
        $strobe("ndhvt         VDS     entering SOCA ( -0.100 V .. 40.000 V ) at %7.4r  %M", $abstime );
        $fwrite(outfile,"ndhvt         VDS     entering SOCA ( -0.100 V .. 40.000 V ) at %7.4r  %M\n", $abstime );
        VDS_retc=0;
        VDS_cnt=VDS_cnt-1;
        $fclose(outfile);
      end
      if((VDS > 40) &&  (VDS_retc!=1))
      begin
        outfile=$fopen(errFileName,"a");
        $strobe("ndhvt         VDS     leaving   OCA ( 40.000 V ..  ) at %7.4r  %M", $abstime );
        $fwrite(outfile,"ndhvt         VDS     leaving   OCA ( 40.000 V ..  ) at %7.4r  %M\n", $abstime );
        VDS_retc=1;
        VDS_cnt=VDS_cnt-1;
        $fclose(outfile);
      end
   end
   else
   begin
      if(VDS_cnt==0)
      begin
        outfile=$fopen(errFileName,"a");
        $strobe("ndhvt         VDS     error limit ( %d ) reached at %7.4r  %M", maxEv, $abstime );
        $fwrite(outfile,"ndhvt         VDS     error limit ( %d ) reached at %7.4r  %M\n", maxEv, $abstime );
        VDS_cnt=VDS_cnt-1;
        $fclose(outfile);
      end
   end

//      VDB
   VDB = V_D_B;
   if((VDB_cnt>0) || ( maxEv_flg==0 ))   begin
      if( (VDB < -0.1) && (VDB_retc!=-1))
      begin
        outfile=$fopen(errFileName,"a");
        $strobe("ndhvt         VDB     leaving   OCA (  .. -0.100 V ) at %7.4r  %M", $abstime );
        $fwrite(outfile,"ndhvt         VDB     leaving   OCA (  .. -0.100 V ) at %7.4r  %M\n", $abstime );
        VDB_retc=-1;
        VDB_cnt=VDB_cnt-1;
        $fclose(outfile);
      end
      if((VDB >= -0.1) &&  (VDB <= 40) && (VDB_retc!=0))
      begin
        outfile=$fopen(errFileName,"a");
        $strobe("ndhvt         VDB     entering SOCA ( -0.100 V .. 40.000 V ) at %7.4r  %M", $abstime );
        $fwrite(outfile,"ndhvt         VDB     entering SOCA ( -0.100 V .. 40.000 V ) at %7.4r  %M\n", $abstime );
        VDB_retc=0;
        VDB_cnt=VDB_cnt-1;
        $fclose(outfile);
      end
      if((VDB > 40) &&  (VDB_retc!=1))
      begin
        outfile=$fopen(errFileName,"a");
        $strobe("ndhvt         VDB     leaving   OCA ( 40.000 V ..  ) at %7.4r  %M", $abstime );
        $fwrite(outfile,"ndhvt         VDB     leaving   OCA ( 40.000 V ..  ) at %7.4r  %M\n", $abstime );
        VDB_retc=1;
        VDB_cnt=VDB_cnt-1;
        $fclose(outfile);
      end
   end
   else
   begin
      if(VDB_cnt==0)
      begin
        outfile=$fopen(errFileName,"a");
        $strobe("ndhvt         VDB     error limit ( %d ) reached at %7.4r  %M", maxEv, $abstime );
        $fwrite(outfile,"ndhvt         VDB     error limit ( %d ) reached at %7.4r  %M\n", maxEv, $abstime );
        VDB_cnt=VDB_cnt-1;
        $fclose(outfile);
      end
   end

//      VDHW
   VDHW = V_D_HW;
   if((VDHW_cnt>0) || ( maxEv_flg==0 ))   begin
      if( (VDHW < -100) && (VDHW_retc!=-1))
      begin
        outfile=$fopen(errFileName,"a");
        $strobe("ndhvt         VDHW    leaving   OCA (  .. -100.000 V ) at %7.4r  %M", $abstime );
        $fwrite(outfile,"ndhvt         VDHW    leaving   OCA (  .. -100.000 V ) at %7.4r  %M\n", $abstime );
        VDHW_retc=-1;
        VDHW_cnt=VDHW_cnt-1;
        $fclose(outfile);
      end
      if((VDHW >= -100) &&  (VDHW <= 200) && (VDHW_retc!=0))
      begin
        outfile=$fopen(errFileName,"a");
        $strobe("ndhvt         VDHW    entering SOCA ( -100.000 V .. 200.000 V ) at %7.4r  %M", $abstime );
        $fwrite(outfile,"ndhvt         VDHW    entering SOCA ( -100.000 V .. 200.000 V ) at %7.4r  %M\n", $abstime );
        VDHW_retc=0;
        VDHW_cnt=VDHW_cnt-1;
        $fclose(outfile);
      end
      if((VDHW > 200) &&  (VDHW_retc!=1))
      begin
        outfile=$fopen(errFileName,"a");
        $strobe("ndhvt         VDHW    leaving   OCA ( 200.000 V ..  ) at %7.4r  %M", $abstime );
        $fwrite(outfile,"ndhvt         VDHW    leaving   OCA ( 200.000 V ..  ) at %7.4r  %M\n", $abstime );
        VDHW_retc=1;
        VDHW_cnt=VDHW_cnt-1;
        $fclose(outfile);
      end
   end
   else
   begin
      if(VDHW_cnt==0)
      begin
        outfile=$fopen(errFileName,"a");
        $strobe("ndhvt         VDHW    error limit ( %d ) reached at %7.4r  %M", maxEv, $abstime );
        $fwrite(outfile,"ndhvt         VDHW    error limit ( %d ) reached at %7.4r  %M\n", maxEv, $abstime );
        VDHW_cnt=VDHW_cnt-1;
        $fclose(outfile);
      end
   end

end // analog
endmodule // ndhvt

// Verilog-A OC Watch for device ndhvta Parameters  VGS VGD VDS VDB VDHW
module ndhvta_ahdl(D,G,S,B,HW);
parameter tstep_occ=100n;
parameter errFileName="./occ.err";
parameter maxEv = 25;
parameter maxEv_flg = 0;
inout D,G,S,B,HW;
electrical D,G,S,B,HW;

integer outfile;
real V_D_HW;
real V_D_B;
real V_D_S;
real V_G_D;
real V_G_S;
real VGS;
integer VGS_retc;
integer VGS_cnt;
real VGD;
integer VGD_retc;
integer VGD_cnt;
real VDS;
integer VDS_retc;
integer VDS_cnt;
real VDB;
integer VDB_retc;
integer VDB_cnt;
real VDHW;
integer VDHW_retc;
integer VDHW_cnt;

analog begin
   $bound_step( tstep_occ );
   @(initial_step) begin
      VGS_retc=0;
      VGS_cnt = maxEv;
      VGD_retc=0;
      VGD_cnt = maxEv;
      VDS_retc=0;
      VDS_cnt = maxEv;
      VDB_retc=0;
      VDB_cnt = maxEv;
      VDHW_retc=0;
      VDHW_cnt = maxEv;
   end
   V_D_HW = V(D,HW);
   V_D_B = V(D,B);
   V_D_S = V(D,S);
   V_G_D = V(G,D);
   V_G_S = V(G,S);

//      VGS
   VGS = V_G_S;
   if((VGS_cnt>0) || ( maxEv_flg==0 ))   begin
      if( (VGS < -5.5) && (VGS_retc!=-1))
      begin
        outfile=$fopen(errFileName,"a");
        $strobe("ndhvta        VGS     leaving   OCA (  .. -5.500 V ) at %7.4r  %M", $abstime );
        $fwrite(outfile,"ndhvta        VGS     leaving   OCA (  .. -5.500 V ) at %7.4r  %M\n", $abstime );
        VGS_retc=-1;
        VGS_cnt=VGS_cnt-1;
        $fclose(outfile);
      end
      if((VGS >= -5.5) &&  (VGS <= 5.5) && (VGS_retc!=0))
      begin
        outfile=$fopen(errFileName,"a");
        $strobe("ndhvta        VGS     entering SOCA ( -5.500 V .. 5.500 V ) at %7.4r  %M", $abstime );
        $fwrite(outfile,"ndhvta        VGS     entering SOCA ( -5.500 V .. 5.500 V ) at %7.4r  %M\n", $abstime );
        VGS_retc=0;
        VGS_cnt=VGS_cnt-1;
        $fclose(outfile);
      end
      if((VGS > 5.5) &&  (VGS_retc!=1))
      begin
        outfile=$fopen(errFileName,"a");
        $strobe("ndhvta        VGS     leaving   OCA ( 5.500 V ..  ) at %7.4r  %M", $abstime );
        $fwrite(outfile,"ndhvta        VGS     leaving   OCA ( 5.500 V ..  ) at %7.4r  %M\n", $abstime );
        VGS_retc=1;
        VGS_cnt=VGS_cnt-1;
        $fclose(outfile);
      end
   end
   else
   begin
      if(VGS_cnt==0)
      begin
        outfile=$fopen(errFileName,"a");
        $strobe("ndhvta        VGS     error limit ( %d ) reached at %7.4r  %M", maxEv, $abstime );
        $fwrite(outfile,"ndhvta        VGS     error limit ( %d ) reached at %7.4r  %M\n", maxEv, $abstime );
        VGS_cnt=VGS_cnt-1;
        $fclose(outfile);
      end
   end

//      VGD
   VGD = V_G_D;
   if((VGD_cnt>0) || ( maxEv_flg==0 ))   begin
      if( (VGD < -40) && (VGD_retc!=-1))
      begin
        outfile=$fopen(errFileName,"a");
        $strobe("ndhvta        VGD     leaving   OCA (  .. -40.000 V ) at %7.4r  %M", $abstime );
        $fwrite(outfile,"ndhvta        VGD     leaving   OCA (  .. -40.000 V ) at %7.4r  %M\n", $abstime );
        VGD_retc=-1;
        VGD_cnt=VGD_cnt-1;
        $fclose(outfile);
      end
      if((VGD >= -40) &&  (VGD <= 5.5) && (VGD_retc!=0))
      begin
        outfile=$fopen(errFileName,"a");
        $strobe("ndhvta        VGD     entering SOCA ( -40.000 V .. 5.500 V ) at %7.4r  %M", $abstime );
        $fwrite(outfile,"ndhvta        VGD     entering SOCA ( -40.000 V .. 5.500 V ) at %7.4r  %M\n", $abstime );
        VGD_retc=0;
        VGD_cnt=VGD_cnt-1;
        $fclose(outfile);
      end
      if((VGD > 5.5) &&  (VGD_retc!=1))
      begin
        outfile=$fopen(errFileName,"a");
        $strobe("ndhvta        VGD     leaving   OCA ( 5.500 V ..  ) at %7.4r  %M", $abstime );
        $fwrite(outfile,"ndhvta        VGD     leaving   OCA ( 5.500 V ..  ) at %7.4r  %M\n", $abstime );
        VGD_retc=1;
        VGD_cnt=VGD_cnt-1;
        $fclose(outfile);
      end
   end
   else
   begin
      if(VGD_cnt==0)
      begin
        outfile=$fopen(errFileName,"a");
        $strobe("ndhvta        VGD     error limit ( %d ) reached at %7.4r  %M", maxEv, $abstime );
        $fwrite(outfile,"ndhvta        VGD     error limit ( %d ) reached at %7.4r  %M\n", maxEv, $abstime );
        VGD_cnt=VGD_cnt-1;
        $fclose(outfile);
      end
   end

//      VDS
   VDS = V_D_S;
   if((VDS_cnt>0) || ( maxEv_flg==0 ))   begin
      if( (VDS < -0.1) && (VDS_retc!=-1))
      begin
        outfile=$fopen(errFileName,"a");
        $strobe("ndhvta        VDS     leaving   OCA (  .. -0.100 V ) at %7.4r  %M", $abstime );
        $fwrite(outfile,"ndhvta        VDS     leaving   OCA (  .. -0.100 V ) at %7.4r  %M\n", $abstime );
        VDS_retc=-1;
        VDS_cnt=VDS_cnt-1;
        $fclose(outfile);
      end
      if((VDS >= -0.1) &&  (VDS <= 40) && (VDS_retc!=0))
      begin
        outfile=$fopen(errFileName,"a");
        $strobe("ndhvta        VDS     entering SOCA ( -0.100 V .. 40.000 V ) at %7.4r  %M", $abstime );
        $fwrite(outfile,"ndhvta        VDS     entering SOCA ( -0.100 V .. 40.000 V ) at %7.4r  %M\n", $abstime );
        VDS_retc=0;
        VDS_cnt=VDS_cnt-1;
        $fclose(outfile);
      end
      if((VDS > 40) &&  (VDS_retc!=1))
      begin
        outfile=$fopen(errFileName,"a");
        $strobe("ndhvta        VDS     leaving   OCA ( 40.000 V ..  ) at %7.4r  %M", $abstime );
        $fwrite(outfile,"ndhvta        VDS     leaving   OCA ( 40.000 V ..  ) at %7.4r  %M\n", $abstime );
        VDS_retc=1;
        VDS_cnt=VDS_cnt-1;
        $fclose(outfile);
      end
   end
   else
   begin
      if(VDS_cnt==0)
      begin
        outfile=$fopen(errFileName,"a");
        $strobe("ndhvta        VDS     error limit ( %d ) reached at %7.4r  %M", maxEv, $abstime );
        $fwrite(outfile,"ndhvta        VDS     error limit ( %d ) reached at %7.4r  %M\n", maxEv, $abstime );
        VDS_cnt=VDS_cnt-1;
        $fclose(outfile);
      end
   end

//      VDB
   VDB = V_D_B;
   if((VDB_cnt>0) || ( maxEv_flg==0 ))   begin
      if( (VDB < -0.1) && (VDB_retc!=-1))
      begin
        outfile=$fopen(errFileName,"a");
        $strobe("ndhvta        VDB     leaving   OCA (  .. -0.100 V ) at %7.4r  %M", $abstime );
        $fwrite(outfile,"ndhvta        VDB     leaving   OCA (  .. -0.100 V ) at %7.4r  %M\n", $abstime );
        VDB_retc=-1;
        VDB_cnt=VDB_cnt-1;
        $fclose(outfile);
      end
      if((VDB >= -0.1) &&  (VDB <= 40) && (VDB_retc!=0))
      begin
        outfile=$fopen(errFileName,"a");
        $strobe("ndhvta        VDB     entering SOCA ( -0.100 V .. 40.000 V ) at %7.4r  %M", $abstime );
        $fwrite(outfile,"ndhvta        VDB     entering SOCA ( -0.100 V .. 40.000 V ) at %7.4r  %M\n", $abstime );
        VDB_retc=0;
        VDB_cnt=VDB_cnt-1;
        $fclose(outfile);
      end
      if((VDB > 40) &&  (VDB_retc!=1))
      begin
        outfile=$fopen(errFileName,"a");
        $strobe("ndhvta        VDB     leaving   OCA ( 40.000 V ..  ) at %7.4r  %M", $abstime );
        $fwrite(outfile,"ndhvta        VDB     leaving   OCA ( 40.000 V ..  ) at %7.4r  %M\n", $abstime );
        VDB_retc=1;
        VDB_cnt=VDB_cnt-1;
        $fclose(outfile);
      end
   end
   else
   begin
      if(VDB_cnt==0)
      begin
        outfile=$fopen(errFileName,"a");
        $strobe("ndhvta        VDB     error limit ( %d ) reached at %7.4r  %M", maxEv, $abstime );
        $fwrite(outfile,"ndhvta        VDB     error limit ( %d ) reached at %7.4r  %M\n", maxEv, $abstime );
        VDB_cnt=VDB_cnt-1;
        $fclose(outfile);
      end
   end

//      VDHW
   VDHW = V_D_HW;
   if((VDHW_cnt>0) || ( maxEv_flg==0 ))   begin
      if( (VDHW < -100) && (VDHW_retc!=-1))
      begin
        outfile=$fopen(errFileName,"a");
        $strobe("ndhvta        VDHW    leaving   OCA (  .. -100.000 V ) at %7.4r  %M", $abstime );
        $fwrite(outfile,"ndhvta        VDHW    leaving   OCA (  .. -100.000 V ) at %7.4r  %M\n", $abstime );
        VDHW_retc=-1;
        VDHW_cnt=VDHW_cnt-1;
        $fclose(outfile);
      end
      if((VDHW >= -100) &&  (VDHW <= 200) && (VDHW_retc!=0))
      begin
        outfile=$fopen(errFileName,"a");
        $strobe("ndhvta        VDHW    entering SOCA ( -100.000 V .. 200.000 V ) at %7.4r  %M", $abstime );
        $fwrite(outfile,"ndhvta        VDHW    entering SOCA ( -100.000 V .. 200.000 V ) at %7.4r  %M\n", $abstime );
        VDHW_retc=0;
        VDHW_cnt=VDHW_cnt-1;
        $fclose(outfile);
      end
      if((VDHW > 200) &&  (VDHW_retc!=1))
      begin
        outfile=$fopen(errFileName,"a");
        $strobe("ndhvta        VDHW    leaving   OCA ( 200.000 V ..  ) at %7.4r  %M", $abstime );
        $fwrite(outfile,"ndhvta        VDHW    leaving   OCA ( 200.000 V ..  ) at %7.4r  %M\n", $abstime );
        VDHW_retc=1;
        VDHW_cnt=VDHW_cnt-1;
        $fclose(outfile);
      end
   end
   else
   begin
      if(VDHW_cnt==0)
      begin
        outfile=$fopen(errFileName,"a");
        $strobe("ndhvta        VDHW    error limit ( %d ) reached at %7.4r  %M", maxEv, $abstime );
        $fwrite(outfile,"ndhvta        VDHW    error limit ( %d ) reached at %7.4r  %M\n", maxEv, $abstime );
        VDHW_cnt=VDHW_cnt-1;
        $fclose(outfile);
      end
   end

end // analog
endmodule // ndhvta

// Verilog-A OC Watch for device ndhvtaa Parameters  VGS VGD VDS VDB VDHW
module ndhvtaa_ahdl(D,G,S,B,HW);
parameter tstep_occ=100n;
parameter errFileName="./occ.err";
parameter maxEv = 25;
parameter maxEv_flg = 0;
inout D,G,S,B,HW;
electrical D,G,S,B,HW;

integer outfile;
real V_D_HW;
real V_D_B;
real V_D_S;
real V_G_D;
real V_G_S;
real VGS;
integer VGS_retc;
integer VGS_cnt;
real VGD;
integer VGD_retc;
integer VGD_cnt;
real VDS;
integer VDS_retc;
integer VDS_cnt;
real VDB;
integer VDB_retc;
integer VDB_cnt;
real VDHW;
integer VDHW_retc;
integer VDHW_cnt;

analog begin
   $bound_step( tstep_occ );
   @(initial_step) begin
      VGS_retc=0;
      VGS_cnt = maxEv;
      VGD_retc=0;
      VGD_cnt = maxEv;
      VDS_retc=0;
      VDS_cnt = maxEv;
      VDB_retc=0;
      VDB_cnt = maxEv;
      VDHW_retc=0;
      VDHW_cnt = maxEv;
   end
   V_D_HW = V(D,HW);
   V_D_B = V(D,B);
   V_D_S = V(D,S);
   V_G_D = V(G,D);
   V_G_S = V(G,S);

//      VGS
   VGS = V_G_S;
   if((VGS_cnt>0) || ( maxEv_flg==0 ))   begin
      if( (VGS < -5.5) && (VGS_retc!=-1))
      begin
        outfile=$fopen(errFileName,"a");
        $strobe("ndhvtaa       VGS     leaving   OCA (  .. -5.500 V ) at %7.4r  %M", $abstime );
        $fwrite(outfile,"ndhvtaa       VGS     leaving   OCA (  .. -5.500 V ) at %7.4r  %M\n", $abstime );
        VGS_retc=-1;
        VGS_cnt=VGS_cnt-1;
        $fclose(outfile);
      end
      if((VGS >= -5.5) &&  (VGS <= 5.5) && (VGS_retc!=0))
      begin
        outfile=$fopen(errFileName,"a");
        $strobe("ndhvtaa       VGS     entering SOCA ( -5.500 V .. 5.500 V ) at %7.4r  %M", $abstime );
        $fwrite(outfile,"ndhvtaa       VGS     entering SOCA ( -5.500 V .. 5.500 V ) at %7.4r  %M\n", $abstime );
        VGS_retc=0;
        VGS_cnt=VGS_cnt-1;
        $fclose(outfile);
      end
      if((VGS > 5.5) &&  (VGS_retc!=1))
      begin
        outfile=$fopen(errFileName,"a");
        $strobe("ndhvtaa       VGS     leaving   OCA ( 5.500 V ..  ) at %7.4r  %M", $abstime );
        $fwrite(outfile,"ndhvtaa       VGS     leaving   OCA ( 5.500 V ..  ) at %7.4r  %M\n", $abstime );
        VGS_retc=1;
        VGS_cnt=VGS_cnt-1;
        $fclose(outfile);
      end
   end
   else
   begin
      if(VGS_cnt==0)
      begin
        outfile=$fopen(errFileName,"a");
        $strobe("ndhvtaa       VGS     error limit ( %d ) reached at %7.4r  %M", maxEv, $abstime );
        $fwrite(outfile,"ndhvtaa       VGS     error limit ( %d ) reached at %7.4r  %M\n", maxEv, $abstime );
        VGS_cnt=VGS_cnt-1;
        $fclose(outfile);
      end
   end

//      VGD
   VGD = V_G_D;
   if((VGD_cnt>0) || ( maxEv_flg==0 ))   begin
      if( (VGD < -40) && (VGD_retc!=-1))
      begin
        outfile=$fopen(errFileName,"a");
        $strobe("ndhvtaa       VGD     leaving   OCA (  .. -40.000 V ) at %7.4r  %M", $abstime );
        $fwrite(outfile,"ndhvtaa       VGD     leaving   OCA (  .. -40.000 V ) at %7.4r  %M\n", $abstime );
        VGD_retc=-1;
        VGD_cnt=VGD_cnt-1;
        $fclose(outfile);
      end
      if((VGD >= -40) &&  (VGD <= 5.5) && (VGD_retc!=0))
      begin
        outfile=$fopen(errFileName,"a");
        $strobe("ndhvtaa       VGD     entering SOCA ( -40.000 V .. 5.500 V ) at %7.4r  %M", $abstime );
        $fwrite(outfile,"ndhvtaa       VGD     entering SOCA ( -40.000 V .. 5.500 V ) at %7.4r  %M\n", $abstime );
        VGD_retc=0;
        VGD_cnt=VGD_cnt-1;
        $fclose(outfile);
      end
      if((VGD > 5.5) &&  (VGD_retc!=1))
      begin
        outfile=$fopen(errFileName,"a");
        $strobe("ndhvtaa       VGD     leaving   OCA ( 5.500 V ..  ) at %7.4r  %M", $abstime );
        $fwrite(outfile,"ndhvtaa       VGD     leaving   OCA ( 5.500 V ..  ) at %7.4r  %M\n", $abstime );
        VGD_retc=1;
        VGD_cnt=VGD_cnt-1;
        $fclose(outfile);
      end
   end
   else
   begin
      if(VGD_cnt==0)
      begin
        outfile=$fopen(errFileName,"a");
        $strobe("ndhvtaa       VGD     error limit ( %d ) reached at %7.4r  %M", maxEv, $abstime );
        $fwrite(outfile,"ndhvtaa       VGD     error limit ( %d ) reached at %7.4r  %M\n", maxEv, $abstime );
        VGD_cnt=VGD_cnt-1;
        $fclose(outfile);
      end
   end

//      VDS
   VDS = V_D_S;
   if((VDS_cnt>0) || ( maxEv_flg==0 ))   begin
      if( (VDS < -0.1) && (VDS_retc!=-1))
      begin
        outfile=$fopen(errFileName,"a");
        $strobe("ndhvtaa       VDS     leaving   OCA (  .. -0.100 V ) at %7.4r  %M", $abstime );
        $fwrite(outfile,"ndhvtaa       VDS     leaving   OCA (  .. -0.100 V ) at %7.4r  %M\n", $abstime );
        VDS_retc=-1;
        VDS_cnt=VDS_cnt-1;
        $fclose(outfile);
      end
      if((VDS >= -0.1) &&  (VDS <= 40) && (VDS_retc!=0))
      begin
        outfile=$fopen(errFileName,"a");
        $strobe("ndhvtaa       VDS     entering SOCA ( -0.100 V .. 40.000 V ) at %7.4r  %M", $abstime );
        $fwrite(outfile,"ndhvtaa       VDS     entering SOCA ( -0.100 V .. 40.000 V ) at %7.4r  %M\n", $abstime );
        VDS_retc=0;
        VDS_cnt=VDS_cnt-1;
        $fclose(outfile);
      end
      if((VDS > 40) &&  (VDS_retc!=1))
      begin
        outfile=$fopen(errFileName,"a");
        $strobe("ndhvtaa       VDS     leaving   OCA ( 40.000 V ..  ) at %7.4r  %M", $abstime );
        $fwrite(outfile,"ndhvtaa       VDS     leaving   OCA ( 40.000 V ..  ) at %7.4r  %M\n", $abstime );
        VDS_retc=1;
        VDS_cnt=VDS_cnt-1;
        $fclose(outfile);
      end
   end
   else
   begin
      if(VDS_cnt==0)
      begin
        outfile=$fopen(errFileName,"a");
        $strobe("ndhvtaa       VDS     error limit ( %d ) reached at %7.4r  %M", maxEv, $abstime );
        $fwrite(outfile,"ndhvtaa       VDS     error limit ( %d ) reached at %7.4r  %M\n", maxEv, $abstime );
        VDS_cnt=VDS_cnt-1;
        $fclose(outfile);
      end
   end

//      VDB
   VDB = V_D_B;
   if((VDB_cnt>0) || ( maxEv_flg==0 ))   begin
      if( (VDB < -0.1) && (VDB_retc!=-1))
      begin
        outfile=$fopen(errFileName,"a");
        $strobe("ndhvtaa       VDB     leaving   OCA (  .. -0.100 V ) at %7.4r  %M", $abstime );
        $fwrite(outfile,"ndhvtaa       VDB     leaving   OCA (  .. -0.100 V ) at %7.4r  %M\n", $abstime );
        VDB_retc=-1;
        VDB_cnt=VDB_cnt-1;
        $fclose(outfile);
      end
      if((VDB >= -0.1) &&  (VDB <= 40) && (VDB_retc!=0))
      begin
        outfile=$fopen(errFileName,"a");
        $strobe("ndhvtaa       VDB     entering SOCA ( -0.100 V .. 40.000 V ) at %7.4r  %M", $abstime );
        $fwrite(outfile,"ndhvtaa       VDB     entering SOCA ( -0.100 V .. 40.000 V ) at %7.4r  %M\n", $abstime );
        VDB_retc=0;
        VDB_cnt=VDB_cnt-1;
        $fclose(outfile);
      end
      if((VDB > 40) &&  (VDB_retc!=1))
      begin
        outfile=$fopen(errFileName,"a");
        $strobe("ndhvtaa       VDB     leaving   OCA ( 40.000 V ..  ) at %7.4r  %M", $abstime );
        $fwrite(outfile,"ndhvtaa       VDB     leaving   OCA ( 40.000 V ..  ) at %7.4r  %M\n", $abstime );
        VDB_retc=1;
        VDB_cnt=VDB_cnt-1;
        $fclose(outfile);
      end
   end
   else
   begin
      if(VDB_cnt==0)
      begin
        outfile=$fopen(errFileName,"a");
        $strobe("ndhvtaa       VDB     error limit ( %d ) reached at %7.4r  %M", maxEv, $abstime );
        $fwrite(outfile,"ndhvtaa       VDB     error limit ( %d ) reached at %7.4r  %M\n", maxEv, $abstime );
        VDB_cnt=VDB_cnt-1;
        $fclose(outfile);
      end
   end

//      VDHW
   VDHW = V_D_HW;
   if((VDHW_cnt>0) || ( maxEv_flg==0 ))   begin
      if( (VDHW < -100) && (VDHW_retc!=-1))
      begin
        outfile=$fopen(errFileName,"a");
        $strobe("ndhvtaa       VDHW    leaving   OCA (  .. -100.000 V ) at %7.4r  %M", $abstime );
        $fwrite(outfile,"ndhvtaa       VDHW    leaving   OCA (  .. -100.000 V ) at %7.4r  %M\n", $abstime );
        VDHW_retc=-1;
        VDHW_cnt=VDHW_cnt-1;
        $fclose(outfile);
      end
      if((VDHW >= -100) &&  (VDHW <= 200) && (VDHW_retc!=0))
      begin
        outfile=$fopen(errFileName,"a");
        $strobe("ndhvtaa       VDHW    entering SOCA ( -100.000 V .. 200.000 V ) at %7.4r  %M", $abstime );
        $fwrite(outfile,"ndhvtaa       VDHW    entering SOCA ( -100.000 V .. 200.000 V ) at %7.4r  %M\n", $abstime );
        VDHW_retc=0;
        VDHW_cnt=VDHW_cnt-1;
        $fclose(outfile);
      end
      if((VDHW > 200) &&  (VDHW_retc!=1))
      begin
        outfile=$fopen(errFileName,"a");
        $strobe("ndhvtaa       VDHW    leaving   OCA ( 200.000 V ..  ) at %7.4r  %M", $abstime );
        $fwrite(outfile,"ndhvtaa       VDHW    leaving   OCA ( 200.000 V ..  ) at %7.4r  %M\n", $abstime );
        VDHW_retc=1;
        VDHW_cnt=VDHW_cnt-1;
        $fclose(outfile);
      end
   end
   else
   begin
      if(VDHW_cnt==0)
      begin
        outfile=$fopen(errFileName,"a");
        $strobe("ndhvtaa       VDHW    error limit ( %d ) reached at %7.4r  %M", maxEv, $abstime );
        $fwrite(outfile,"ndhvtaa       VDHW    error limit ( %d ) reached at %7.4r  %M\n", maxEv, $abstime );
        VDHW_cnt=VDHW_cnt-1;
        $fclose(outfile);
      end
   end

end // analog
endmodule // ndhvtaa

// Verilog-A OC Watch for device phvta Parameters  VGS VGD VDS VDB VSHW
module phvta_ahdl(D,G,S,B,HW);
parameter tstep_occ=100n;
parameter errFileName="./occ.err";
parameter maxEv = 25;
parameter maxEv_flg = 0;
inout D,G,S,B,HW;
electrical D,G,S,B,HW;

integer outfile;
real V_S_HW;
real V_D_B;
real V_D_S;
real V_G_D;
real V_G_S;
real VGS;
integer VGS_retc;
integer VGS_cnt;
real VGD;
integer VGD_retc;
integer VGD_cnt;
real VDS;
integer VDS_retc;
integer VDS_cnt;
real VDB;
integer VDB_retc;
integer VDB_cnt;
real VSHW;
integer VSHW_retc;
integer VSHW_cnt;

analog begin
   $bound_step( tstep_occ );
   @(initial_step) begin
      VGS_retc=0;
      VGS_cnt = maxEv;
      VGD_retc=0;
      VGD_cnt = maxEv;
      VDS_retc=0;
      VDS_cnt = maxEv;
      VDB_retc=0;
      VDB_cnt = maxEv;
      VSHW_retc=0;
      VSHW_cnt = maxEv;
   end
   V_S_HW = V(S,HW);
   V_D_B = V(D,B);
   V_D_S = V(D,S);
   V_G_D = V(G,D);
   V_G_S = V(G,S);

//      VGS
   VGS = V_G_S;
   if((VGS_cnt>0) || ( maxEv_flg==0 ))   begin
      if( (VGS < -5.5) && (VGS_retc!=-1))
      begin
        outfile=$fopen(errFileName,"a");
        $strobe("phvta         VGS     leaving   OCA (  .. -5.500 V ) at %7.4r  %M", $abstime );
        $fwrite(outfile,"phvta         VGS     leaving   OCA (  .. -5.500 V ) at %7.4r  %M\n", $abstime );
        VGS_retc=-1;
        VGS_cnt=VGS_cnt-1;
        $fclose(outfile);
      end
      if((VGS >= -5.5) &&  (VGS <= 5.5) && (VGS_retc!=0))
      begin
        outfile=$fopen(errFileName,"a");
        $strobe("phvta         VGS     entering SOCA ( -5.500 V .. 5.500 V ) at %7.4r  %M", $abstime );
        $fwrite(outfile,"phvta         VGS     entering SOCA ( -5.500 V .. 5.500 V ) at %7.4r  %M\n", $abstime );
        VGS_retc=0;
        VGS_cnt=VGS_cnt-1;
        $fclose(outfile);
      end
      if((VGS > 5.5) &&  (VGS_retc!=1))
      begin
        outfile=$fopen(errFileName,"a");
        $strobe("phvta         VGS     leaving   OCA ( 5.500 V ..  ) at %7.4r  %M", $abstime );
        $fwrite(outfile,"phvta         VGS     leaving   OCA ( 5.500 V ..  ) at %7.4r  %M\n", $abstime );
        VGS_retc=1;
        VGS_cnt=VGS_cnt-1;
        $fclose(outfile);
      end
   end
   else
   begin
      if(VGS_cnt==0)
      begin
        outfile=$fopen(errFileName,"a");
        $strobe("phvta         VGS     error limit ( %d ) reached at %7.4r  %M", maxEv, $abstime );
        $fwrite(outfile,"phvta         VGS     error limit ( %d ) reached at %7.4r  %M\n", maxEv, $abstime );
        VGS_cnt=VGS_cnt-1;
        $fclose(outfile);
      end
   end

//      VGD
   VGD = V_G_D;
   if((VGD_cnt>0) || ( maxEv_flg==0 ))   begin
      if( (VGD < -5.5) && (VGD_retc!=-1))
      begin
        outfile=$fopen(errFileName,"a");
        $strobe("phvta         VGD     leaving   OCA (  .. -5.500 V ) at %7.4r  %M", $abstime );
        $fwrite(outfile,"phvta         VGD     leaving   OCA (  .. -5.500 V ) at %7.4r  %M\n", $abstime );
        VGD_retc=-1;
        VGD_cnt=VGD_cnt-1;
        $fclose(outfile);
      end
      if((VGD >= -5.5) &&  (VGD <= 40) && (VGD_retc!=0))
      begin
        outfile=$fopen(errFileName,"a");
        $strobe("phvta         VGD     entering SOCA ( -5.500 V .. 40.000 V ) at %7.4r  %M", $abstime );
        $fwrite(outfile,"phvta         VGD     entering SOCA ( -5.500 V .. 40.000 V ) at %7.4r  %M\n", $abstime );
        VGD_retc=0;
        VGD_cnt=VGD_cnt-1;
        $fclose(outfile);
      end
      if((VGD > 40) &&  (VGD_retc!=1))
      begin
        outfile=$fopen(errFileName,"a");
        $strobe("phvta         VGD     leaving   OCA ( 40.000 V ..  ) at %7.4r  %M", $abstime );
        $fwrite(outfile,"phvta         VGD     leaving   OCA ( 40.000 V ..  ) at %7.4r  %M\n", $abstime );
        VGD_retc=1;
        VGD_cnt=VGD_cnt-1;
        $fclose(outfile);
      end
   end
   else
   begin
      if(VGD_cnt==0)
      begin
        outfile=$fopen(errFileName,"a");
        $strobe("phvta         VGD     error limit ( %d ) reached at %7.4r  %M", maxEv, $abstime );
        $fwrite(outfile,"phvta         VGD     error limit ( %d ) reached at %7.4r  %M\n", maxEv, $abstime );
        VGD_cnt=VGD_cnt-1;
        $fclose(outfile);
      end
   end

//      VDS
   VDS = V_D_S;
   if((VDS_cnt>0) || ( maxEv_flg==0 ))   begin
      if( (VDS < -40) && (VDS_retc!=-1))
      begin
        outfile=$fopen(errFileName,"a");
        $strobe("phvta         VDS     leaving   OCA (  .. -40.000 V ) at %7.4r  %M", $abstime );
        $fwrite(outfile,"phvta         VDS     leaving   OCA (  .. -40.000 V ) at %7.4r  %M\n", $abstime );
        VDS_retc=-1;
        VDS_cnt=VDS_cnt-1;
        $fclose(outfile);
      end
      if((VDS >= -40) &&  (VDS <= 1.5) && (VDS_retc!=0))
      begin
        outfile=$fopen(errFileName,"a");
        $strobe("phvta         VDS     entering SOCA ( -40.000 V .. 1.500 V ) at %7.4r  %M", $abstime );
        $fwrite(outfile,"phvta         VDS     entering SOCA ( -40.000 V .. 1.500 V ) at %7.4r  %M\n", $abstime );
        VDS_retc=0;
        VDS_cnt=VDS_cnt-1;
        $fclose(outfile);
      end
      if((VDS > 1.5) &&  (VDS_retc!=1))
      begin
        outfile=$fopen(errFileName,"a");
        $strobe("phvta         VDS     leaving   OCA ( 1.500 V ..  ) at %7.4r  %M", $abstime );
        $fwrite(outfile,"phvta         VDS     leaving   OCA ( 1.500 V ..  ) at %7.4r  %M\n", $abstime );
        VDS_retc=1;
        VDS_cnt=VDS_cnt-1;
        $fclose(outfile);
      end
   end
   else
   begin
      if(VDS_cnt==0)
      begin
        outfile=$fopen(errFileName,"a");
        $strobe("phvta         VDS     error limit ( %d ) reached at %7.4r  %M", maxEv, $abstime );
        $fwrite(outfile,"phvta         VDS     error limit ( %d ) reached at %7.4r  %M\n", maxEv, $abstime );
        VDS_cnt=VDS_cnt-1;
        $fclose(outfile);
      end
   end

//      VDB
   VDB = V_D_B;
   if((VDB_cnt>0) || ( maxEv_flg==0 ))   begin
      if( (VDB < -40) && (VDB_retc!=-1))
      begin
        outfile=$fopen(errFileName,"a");
        $strobe("phvta         VDB     leaving   OCA (  .. -40.000 V ) at %7.4r  %M", $abstime );
        $fwrite(outfile,"phvta         VDB     leaving   OCA (  .. -40.000 V ) at %7.4r  %M\n", $abstime );
        VDB_retc=-1;
        VDB_cnt=VDB_cnt-1;
        $fclose(outfile);
      end
      if((VDB >= -40) &&  (VDB <= 1.5) && (VDB_retc!=0))
      begin
        outfile=$fopen(errFileName,"a");
        $strobe("phvta         VDB     entering SOCA ( -40.000 V .. 1.500 V ) at %7.4r  %M", $abstime );
        $fwrite(outfile,"phvta         VDB     entering SOCA ( -40.000 V .. 1.500 V ) at %7.4r  %M\n", $abstime );
        VDB_retc=0;
        VDB_cnt=VDB_cnt-1;
        $fclose(outfile);
      end
      if((VDB > 1.5) &&  (VDB_retc!=1))
      begin
        outfile=$fopen(errFileName,"a");
        $strobe("phvta         VDB     leaving   OCA ( 1.500 V ..  ) at %7.4r  %M", $abstime );
        $fwrite(outfile,"phvta         VDB     leaving   OCA ( 1.500 V ..  ) at %7.4r  %M\n", $abstime );
        VDB_retc=1;
        VDB_cnt=VDB_cnt-1;
        $fclose(outfile);
      end
   end
   else
   begin
      if(VDB_cnt==0)
      begin
        outfile=$fopen(errFileName,"a");
        $strobe("phvta         VDB     error limit ( %d ) reached at %7.4r  %M", maxEv, $abstime );
        $fwrite(outfile,"phvta         VDB     error limit ( %d ) reached at %7.4r  %M\n", maxEv, $abstime );
        VDB_cnt=VDB_cnt-1;
        $fclose(outfile);
      end
   end

//      VSHW
   VSHW = V_S_HW;
   if((VSHW_cnt>0) || ( maxEv_flg==0 ))   begin
      if( (VSHW < -15) && (VSHW_retc!=-1))
      begin
        outfile=$fopen(errFileName,"a");
        $strobe("phvta         VSHW    leaving   OCA (  .. -15.000 V ) at %7.4r  %M", $abstime );
        $fwrite(outfile,"phvta         VSHW    leaving   OCA (  .. -15.000 V ) at %7.4r  %M\n", $abstime );
        VSHW_retc=-1;
        VSHW_cnt=VSHW_cnt-1;
        $fclose(outfile);
      end
      if((VSHW >= -15) &&  (VSHW <= 200) && (VSHW_retc!=0))
      begin
        outfile=$fopen(errFileName,"a");
        $strobe("phvta         VSHW    entering SOCA ( -15.000 V .. 200.000 V ) at %7.4r  %M", $abstime );
        $fwrite(outfile,"phvta         VSHW    entering SOCA ( -15.000 V .. 200.000 V ) at %7.4r  %M\n", $abstime );
        VSHW_retc=0;
        VSHW_cnt=VSHW_cnt-1;
        $fclose(outfile);
      end
      if((VSHW > 200) &&  (VSHW_retc!=1))
      begin
        outfile=$fopen(errFileName,"a");
        $strobe("phvta         VSHW    leaving   OCA ( 200.000 V ..  ) at %7.4r  %M", $abstime );
        $fwrite(outfile,"phvta         VSHW    leaving   OCA ( 200.000 V ..  ) at %7.4r  %M\n", $abstime );
        VSHW_retc=1;
        VSHW_cnt=VSHW_cnt-1;
        $fclose(outfile);
      end
   end
   else
   begin
      if(VSHW_cnt==0)
      begin
        outfile=$fopen(errFileName,"a");
        $strobe("phvta         VSHW    error limit ( %d ) reached at %7.4r  %M", maxEv, $abstime );
        $fwrite(outfile,"phvta         VSHW    error limit ( %d ) reached at %7.4r  %M\n", maxEv, $abstime );
        VSHW_cnt=VSHW_cnt-1;
        $fclose(outfile);
      end
   end

end // analog
endmodule // phvta

// Verilog-A OC Watch for device phvtb Parameters  VGS VGD VDS VDB VSHW
module phvtb_ahdl(D,G,S,B,HW);
parameter tstep_occ=100n;
parameter errFileName="./occ.err";
parameter maxEv = 25;
parameter maxEv_flg = 0;
inout D,G,S,B,HW;
electrical D,G,S,B,HW;

integer outfile;
real V_S_HW;
real V_D_B;
real V_D_S;
real V_G_D;
real V_G_S;
real VGS;
integer VGS_retc;
integer VGS_cnt;
real VGD;
integer VGD_retc;
integer VGD_cnt;
real VDS;
integer VDS_retc;
integer VDS_cnt;
real VDB;
integer VDB_retc;
integer VDB_cnt;
real VSHW;
integer VSHW_retc;
integer VSHW_cnt;

analog begin
   $bound_step( tstep_occ );
   @(initial_step) begin
      VGS_retc=0;
      VGS_cnt = maxEv;
      VGD_retc=0;
      VGD_cnt = maxEv;
      VDS_retc=0;
      VDS_cnt = maxEv;
      VDB_retc=0;
      VDB_cnt = maxEv;
      VSHW_retc=0;
      VSHW_cnt = maxEv;
   end
   V_S_HW = V(S,HW);
   V_D_B = V(D,B);
   V_D_S = V(D,S);
   V_G_D = V(G,D);
   V_G_S = V(G,S);

//      VGS
   VGS = V_G_S;
   if((VGS_cnt>0) || ( maxEv_flg==0 ))   begin
      if( (VGS < -5.5) && (VGS_retc!=-1))
      begin
        outfile=$fopen(errFileName,"a");
        $strobe("phvtb         VGS     leaving   OCA (  .. -5.500 V ) at %7.4r  %M", $abstime );
        $fwrite(outfile,"phvtb         VGS     leaving   OCA (  .. -5.500 V ) at %7.4r  %M\n", $abstime );
        VGS_retc=-1;
        VGS_cnt=VGS_cnt-1;
        $fclose(outfile);
      end
      if((VGS >= -5.5) &&  (VGS <= 5.5) && (VGS_retc!=0))
      begin
        outfile=$fopen(errFileName,"a");
        $strobe("phvtb         VGS     entering SOCA ( -5.500 V .. 5.500 V ) at %7.4r  %M", $abstime );
        $fwrite(outfile,"phvtb         VGS     entering SOCA ( -5.500 V .. 5.500 V ) at %7.4r  %M\n", $abstime );
        VGS_retc=0;
        VGS_cnt=VGS_cnt-1;
        $fclose(outfile);
      end
      if((VGS > 5.5) &&  (VGS_retc!=1))
      begin
        outfile=$fopen(errFileName,"a");
        $strobe("phvtb         VGS     leaving   OCA ( 5.500 V ..  ) at %7.4r  %M", $abstime );
        $fwrite(outfile,"phvtb         VGS     leaving   OCA ( 5.500 V ..  ) at %7.4r  %M\n", $abstime );
        VGS_retc=1;
        VGS_cnt=VGS_cnt-1;
        $fclose(outfile);
      end
   end
   else
   begin
      if(VGS_cnt==0)
      begin
        outfile=$fopen(errFileName,"a");
        $strobe("phvtb         VGS     error limit ( %d ) reached at %7.4r  %M", maxEv, $abstime );
        $fwrite(outfile,"phvtb         VGS     error limit ( %d ) reached at %7.4r  %M\n", maxEv, $abstime );
        VGS_cnt=VGS_cnt-1;
        $fclose(outfile);
      end
   end

//      VGD
   VGD = V_G_D;
   if((VGD_cnt>0) || ( maxEv_flg==0 ))   begin
      if( (VGD < -5.5) && (VGD_retc!=-1))
      begin
        outfile=$fopen(errFileName,"a");
        $strobe("phvtb         VGD     leaving   OCA (  .. -5.500 V ) at %7.4r  %M", $abstime );
        $fwrite(outfile,"phvtb         VGD     leaving   OCA (  .. -5.500 V ) at %7.4r  %M\n", $abstime );
        VGD_retc=-1;
        VGD_cnt=VGD_cnt-1;
        $fclose(outfile);
      end
      if((VGD >= -5.5) &&  (VGD <= 40) && (VGD_retc!=0))
      begin
        outfile=$fopen(errFileName,"a");
        $strobe("phvtb         VGD     entering SOCA ( -5.500 V .. 40.000 V ) at %7.4r  %M", $abstime );
        $fwrite(outfile,"phvtb         VGD     entering SOCA ( -5.500 V .. 40.000 V ) at %7.4r  %M\n", $abstime );
        VGD_retc=0;
        VGD_cnt=VGD_cnt-1;
        $fclose(outfile);
      end
      if((VGD > 40) &&  (VGD_retc!=1))
      begin
        outfile=$fopen(errFileName,"a");
        $strobe("phvtb         VGD     leaving   OCA ( 40.000 V ..  ) at %7.4r  %M", $abstime );
        $fwrite(outfile,"phvtb         VGD     leaving   OCA ( 40.000 V ..  ) at %7.4r  %M\n", $abstime );
        VGD_retc=1;
        VGD_cnt=VGD_cnt-1;
        $fclose(outfile);
      end
   end
   else
   begin
      if(VGD_cnt==0)
      begin
        outfile=$fopen(errFileName,"a");
        $strobe("phvtb         VGD     error limit ( %d ) reached at %7.4r  %M", maxEv, $abstime );
        $fwrite(outfile,"phvtb         VGD     error limit ( %d ) reached at %7.4r  %M\n", maxEv, $abstime );
        VGD_cnt=VGD_cnt-1;
        $fclose(outfile);
      end
   end

//      VDS
   VDS = V_D_S;
   if((VDS_cnt>0) || ( maxEv_flg==0 ))   begin
      if( (VDS < -40) && (VDS_retc!=-1))
      begin
        outfile=$fopen(errFileName,"a");
        $strobe("phvtb         VDS     leaving   OCA (  .. -40.000 V ) at %7.4r  %M", $abstime );
        $fwrite(outfile,"phvtb         VDS     leaving   OCA (  .. -40.000 V ) at %7.4r  %M\n", $abstime );
        VDS_retc=-1;
        VDS_cnt=VDS_cnt-1;
        $fclose(outfile);
      end
      if((VDS >= -40) &&  (VDS <= 1.5) && (VDS_retc!=0))
      begin
        outfile=$fopen(errFileName,"a");
        $strobe("phvtb         VDS     entering SOCA ( -40.000 V .. 1.500 V ) at %7.4r  %M", $abstime );
        $fwrite(outfile,"phvtb         VDS     entering SOCA ( -40.000 V .. 1.500 V ) at %7.4r  %M\n", $abstime );
        VDS_retc=0;
        VDS_cnt=VDS_cnt-1;
        $fclose(outfile);
      end
      if((VDS > 1.5) &&  (VDS_retc!=1))
      begin
        outfile=$fopen(errFileName,"a");
        $strobe("phvtb         VDS     leaving   OCA ( 1.500 V ..  ) at %7.4r  %M", $abstime );
        $fwrite(outfile,"phvtb         VDS     leaving   OCA ( 1.500 V ..  ) at %7.4r  %M\n", $abstime );
        VDS_retc=1;
        VDS_cnt=VDS_cnt-1;
        $fclose(outfile);
      end
   end
   else
   begin
      if(VDS_cnt==0)
      begin
        outfile=$fopen(errFileName,"a");
        $strobe("phvtb         VDS     error limit ( %d ) reached at %7.4r  %M", maxEv, $abstime );
        $fwrite(outfile,"phvtb         VDS     error limit ( %d ) reached at %7.4r  %M\n", maxEv, $abstime );
        VDS_cnt=VDS_cnt-1;
        $fclose(outfile);
      end
   end

//      VDB
   VDB = V_D_B;
   if((VDB_cnt>0) || ( maxEv_flg==0 ))   begin
      if( (VDB < -40) && (VDB_retc!=-1))
      begin
        outfile=$fopen(errFileName,"a");
        $strobe("phvtb         VDB     leaving   OCA (  .. -40.000 V ) at %7.4r  %M", $abstime );
        $fwrite(outfile,"phvtb         VDB     leaving   OCA (  .. -40.000 V ) at %7.4r  %M\n", $abstime );
        VDB_retc=-1;
        VDB_cnt=VDB_cnt-1;
        $fclose(outfile);
      end
      if((VDB >= -40) &&  (VDB <= 1.5) && (VDB_retc!=0))
      begin
        outfile=$fopen(errFileName,"a");
        $strobe("phvtb         VDB     entering SOCA ( -40.000 V .. 1.500 V ) at %7.4r  %M", $abstime );
        $fwrite(outfile,"phvtb         VDB     entering SOCA ( -40.000 V .. 1.500 V ) at %7.4r  %M\n", $abstime );
        VDB_retc=0;
        VDB_cnt=VDB_cnt-1;
        $fclose(outfile);
      end
      if((VDB > 1.5) &&  (VDB_retc!=1))
      begin
        outfile=$fopen(errFileName,"a");
        $strobe("phvtb         VDB     leaving   OCA ( 1.500 V ..  ) at %7.4r  %M", $abstime );
        $fwrite(outfile,"phvtb         VDB     leaving   OCA ( 1.500 V ..  ) at %7.4r  %M\n", $abstime );
        VDB_retc=1;
        VDB_cnt=VDB_cnt-1;
        $fclose(outfile);
      end
   end
   else
   begin
      if(VDB_cnt==0)
      begin
        outfile=$fopen(errFileName,"a");
        $strobe("phvtb         VDB     error limit ( %d ) reached at %7.4r  %M", maxEv, $abstime );
        $fwrite(outfile,"phvtb         VDB     error limit ( %d ) reached at %7.4r  %M\n", maxEv, $abstime );
        VDB_cnt=VDB_cnt-1;
        $fclose(outfile);
      end
   end

//      VSHW
   VSHW = V_S_HW;
   if((VSHW_cnt>0) || ( maxEv_flg==0 ))   begin
      if( (VSHW < -20) && (VSHW_retc!=-1))
      begin
        outfile=$fopen(errFileName,"a");
        $strobe("phvtb         VSHW    leaving   OCA (  .. -20.000 V ) at %7.4r  %M", $abstime );
        $fwrite(outfile,"phvtb         VSHW    leaving   OCA (  .. -20.000 V ) at %7.4r  %M\n", $abstime );
        VSHW_retc=-1;
        VSHW_cnt=VSHW_cnt-1;
        $fclose(outfile);
      end
      if((VSHW >= -20) &&  (VSHW <= 200) && (VSHW_retc!=0))
      begin
        outfile=$fopen(errFileName,"a");
        $strobe("phvtb         VSHW    entering SOCA ( -20.000 V .. 200.000 V ) at %7.4r  %M", $abstime );
        $fwrite(outfile,"phvtb         VSHW    entering SOCA ( -20.000 V .. 200.000 V ) at %7.4r  %M\n", $abstime );
        VSHW_retc=0;
        VSHW_cnt=VSHW_cnt-1;
        $fclose(outfile);
      end
      if((VSHW > 200) &&  (VSHW_retc!=1))
      begin
        outfile=$fopen(errFileName,"a");
        $strobe("phvtb         VSHW    leaving   OCA ( 200.000 V ..  ) at %7.4r  %M", $abstime );
        $fwrite(outfile,"phvtb         VSHW    leaving   OCA ( 200.000 V ..  ) at %7.4r  %M\n", $abstime );
        VSHW_retc=1;
        VSHW_cnt=VSHW_cnt-1;
        $fclose(outfile);
      end
   end
   else
   begin
      if(VSHW_cnt==0)
      begin
        outfile=$fopen(errFileName,"a");
        $strobe("phvtb         VSHW    error limit ( %d ) reached at %7.4r  %M", maxEv, $abstime );
        $fwrite(outfile,"phvtb         VSHW    error limit ( %d ) reached at %7.4r  %M\n", maxEv, $abstime );
        VSHW_cnt=VSHW_cnt-1;
        $fclose(outfile);
      end
   end

end // analog
endmodule // phvtb

// Verilog-A OC Watch for device phvu Parameters  VGS VGD VDS VDB VSHW
module phvu_ahdl(D,G,S,B,HW);
parameter tstep_occ=100n;
parameter errFileName="./occ.err";
parameter maxEv = 25;
parameter maxEv_flg = 0;
inout D,G,S,B,HW;
electrical D,G,S,B,HW;

integer outfile;
real V_S_HW;
real V_D_B;
real V_D_S;
real V_G_D;
real V_G_S;
real VGS;
integer VGS_retc;
integer VGS_cnt;
real VGD;
integer VGD_retc;
integer VGD_cnt;
real VDS;
integer VDS_retc;
integer VDS_cnt;
real VDB;
integer VDB_retc;
integer VDB_cnt;
real VSHW;
integer VSHW_retc;
integer VSHW_cnt;

analog begin
   $bound_step( tstep_occ );
   @(initial_step) begin
      VGS_retc=0;
      VGS_cnt = maxEv;
      VGD_retc=0;
      VGD_cnt = maxEv;
      VDS_retc=0;
      VDS_cnt = maxEv;
      VDB_retc=0;
      VDB_cnt = maxEv;
      VSHW_retc=0;
      VSHW_cnt = maxEv;
   end
   V_S_HW = V(S,HW);
   V_D_B = V(D,B);
   V_D_S = V(D,S);
   V_G_D = V(G,D);
   V_G_S = V(G,S);

//      VGS
   VGS = V_G_S;
   if((VGS_cnt>0) || ( maxEv_flg==0 ))   begin
      if( (VGS < -5.5) && (VGS_retc!=-1))
      begin
        outfile=$fopen(errFileName,"a");
        $strobe("phvu          VGS     leaving   OCA (  .. -5.500 V ) at %7.4r  %M", $abstime );
        $fwrite(outfile,"phvu          VGS     leaving   OCA (  .. -5.500 V ) at %7.4r  %M\n", $abstime );
        VGS_retc=-1;
        VGS_cnt=VGS_cnt-1;
        $fclose(outfile);
      end
      if((VGS >= -5.5) &&  (VGS <= 5.5) && (VGS_retc!=0))
      begin
        outfile=$fopen(errFileName,"a");
        $strobe("phvu          VGS     entering SOCA ( -5.500 V .. 5.500 V ) at %7.4r  %M", $abstime );
        $fwrite(outfile,"phvu          VGS     entering SOCA ( -5.500 V .. 5.500 V ) at %7.4r  %M\n", $abstime );
        VGS_retc=0;
        VGS_cnt=VGS_cnt-1;
        $fclose(outfile);
      end
      if((VGS > 5.5) &&  (VGS_retc!=1))
      begin
        outfile=$fopen(errFileName,"a");
        $strobe("phvu          VGS     leaving   OCA ( 5.500 V ..  ) at %7.4r  %M", $abstime );
        $fwrite(outfile,"phvu          VGS     leaving   OCA ( 5.500 V ..  ) at %7.4r  %M\n", $abstime );
        VGS_retc=1;
        VGS_cnt=VGS_cnt-1;
        $fclose(outfile);
      end
   end
   else
   begin
      if(VGS_cnt==0)
      begin
        outfile=$fopen(errFileName,"a");
        $strobe("phvu          VGS     error limit ( %d ) reached at %7.4r  %M", maxEv, $abstime );
        $fwrite(outfile,"phvu          VGS     error limit ( %d ) reached at %7.4r  %M\n", maxEv, $abstime );
        VGS_cnt=VGS_cnt-1;
        $fclose(outfile);
      end
   end

//      VGD
   VGD = V_G_D;
   if((VGD_cnt>0) || ( maxEv_flg==0 ))   begin
      if( (VGD < -5.5) && (VGD_retc!=-1))
      begin
        outfile=$fopen(errFileName,"a");
        $strobe("phvu          VGD     leaving   OCA (  .. -5.500 V ) at %7.4r  %M", $abstime );
        $fwrite(outfile,"phvu          VGD     leaving   OCA (  .. -5.500 V ) at %7.4r  %M\n", $abstime );
        VGD_retc=-1;
        VGD_cnt=VGD_cnt-1;
        $fclose(outfile);
      end
      if((VGD >= -5.5) &&  (VGD <= 60) && (VGD_retc!=0))
      begin
        outfile=$fopen(errFileName,"a");
        $strobe("phvu          VGD     entering SOCA ( -5.500 V .. 60.000 V ) at %7.4r  %M", $abstime );
        $fwrite(outfile,"phvu          VGD     entering SOCA ( -5.500 V .. 60.000 V ) at %7.4r  %M\n", $abstime );
        VGD_retc=0;
        VGD_cnt=VGD_cnt-1;
        $fclose(outfile);
      end
      if((VGD > 60) &&  (VGD_retc!=1))
      begin
        outfile=$fopen(errFileName,"a");
        $strobe("phvu          VGD     leaving   OCA ( 60.000 V ..  ) at %7.4r  %M", $abstime );
        $fwrite(outfile,"phvu          VGD     leaving   OCA ( 60.000 V ..  ) at %7.4r  %M\n", $abstime );
        VGD_retc=1;
        VGD_cnt=VGD_cnt-1;
        $fclose(outfile);
      end
   end
   else
   begin
      if(VGD_cnt==0)
      begin
        outfile=$fopen(errFileName,"a");
        $strobe("phvu          VGD     error limit ( %d ) reached at %7.4r  %M", maxEv, $abstime );
        $fwrite(outfile,"phvu          VGD     error limit ( %d ) reached at %7.4r  %M\n", maxEv, $abstime );
        VGD_cnt=VGD_cnt-1;
        $fclose(outfile);
      end
   end

//      VDS
   VDS = V_D_S;
   if((VDS_cnt>0) || ( maxEv_flg==0 ))   begin
      if( (VDS < -60) && (VDS_retc!=-1))
      begin
        outfile=$fopen(errFileName,"a");
        $strobe("phvu          VDS     leaving   OCA (  .. -60.000 V ) at %7.4r  %M", $abstime );
        $fwrite(outfile,"phvu          VDS     leaving   OCA (  .. -60.000 V ) at %7.4r  %M\n", $abstime );
        VDS_retc=-1;
        VDS_cnt=VDS_cnt-1;
        $fclose(outfile);
      end
      if((VDS >= -60) &&  (VDS <= 1.5) && (VDS_retc!=0))
      begin
        outfile=$fopen(errFileName,"a");
        $strobe("phvu          VDS     entering SOCA ( -60.000 V .. 1.500 V ) at %7.4r  %M", $abstime );
        $fwrite(outfile,"phvu          VDS     entering SOCA ( -60.000 V .. 1.500 V ) at %7.4r  %M\n", $abstime );
        VDS_retc=0;
        VDS_cnt=VDS_cnt-1;
        $fclose(outfile);
      end
      if((VDS > 1.5) &&  (VDS_retc!=1))
      begin
        outfile=$fopen(errFileName,"a");
        $strobe("phvu          VDS     leaving   OCA ( 1.500 V ..  ) at %7.4r  %M", $abstime );
        $fwrite(outfile,"phvu          VDS     leaving   OCA ( 1.500 V ..  ) at %7.4r  %M\n", $abstime );
        VDS_retc=1;
        VDS_cnt=VDS_cnt-1;
        $fclose(outfile);
      end
   end
   else
   begin
      if(VDS_cnt==0)
      begin
        outfile=$fopen(errFileName,"a");
        $strobe("phvu          VDS     error limit ( %d ) reached at %7.4r  %M", maxEv, $abstime );
        $fwrite(outfile,"phvu          VDS     error limit ( %d ) reached at %7.4r  %M\n", maxEv, $abstime );
        VDS_cnt=VDS_cnt-1;
        $fclose(outfile);
      end
   end

//      VDB
   VDB = V_D_B;
   if((VDB_cnt>0) || ( maxEv_flg==0 ))   begin
      if( (VDB < -60) && (VDB_retc!=-1))
      begin
        outfile=$fopen(errFileName,"a");
        $strobe("phvu          VDB     leaving   OCA (  .. -60.000 V ) at %7.4r  %M", $abstime );
        $fwrite(outfile,"phvu          VDB     leaving   OCA (  .. -60.000 V ) at %7.4r  %M\n", $abstime );
        VDB_retc=-1;
        VDB_cnt=VDB_cnt-1;
        $fclose(outfile);
      end
      if((VDB >= -60) &&  (VDB <= 1.5) && (VDB_retc!=0))
      begin
        outfile=$fopen(errFileName,"a");
        $strobe("phvu          VDB     entering SOCA ( -60.000 V .. 1.500 V ) at %7.4r  %M", $abstime );
        $fwrite(outfile,"phvu          VDB     entering SOCA ( -60.000 V .. 1.500 V ) at %7.4r  %M\n", $abstime );
        VDB_retc=0;
        VDB_cnt=VDB_cnt-1;
        $fclose(outfile);
      end
      if((VDB > 1.5) &&  (VDB_retc!=1))
      begin
        outfile=$fopen(errFileName,"a");
        $strobe("phvu          VDB     leaving   OCA ( 1.500 V ..  ) at %7.4r  %M", $abstime );
        $fwrite(outfile,"phvu          VDB     leaving   OCA ( 1.500 V ..  ) at %7.4r  %M\n", $abstime );
        VDB_retc=1;
        VDB_cnt=VDB_cnt-1;
        $fclose(outfile);
      end
   end
   else
   begin
      if(VDB_cnt==0)
      begin
        outfile=$fopen(errFileName,"a");
        $strobe("phvu          VDB     error limit ( %d ) reached at %7.4r  %M", maxEv, $abstime );
        $fwrite(outfile,"phvu          VDB     error limit ( %d ) reached at %7.4r  %M\n", maxEv, $abstime );
        VDB_cnt=VDB_cnt-1;
        $fclose(outfile);
      end
   end

//      VSHW
   VSHW = V_S_HW;
   if((VSHW_cnt>0) || ( maxEv_flg==0 ))   begin
      if( (VSHW < -25) && (VSHW_retc!=-1))
      begin
        outfile=$fopen(errFileName,"a");
        $strobe("phvu          VSHW    leaving   OCA (  .. -25.000 V ) at %7.4r  %M", $abstime );
        $fwrite(outfile,"phvu          VSHW    leaving   OCA (  .. -25.000 V ) at %7.4r  %M\n", $abstime );
        VSHW_retc=-1;
        VSHW_cnt=VSHW_cnt-1;
        $fclose(outfile);
      end
      if((VSHW >= -25) &&  (VSHW <= 200) && (VSHW_retc!=0))
      begin
        outfile=$fopen(errFileName,"a");
        $strobe("phvu          VSHW    entering SOCA ( -25.000 V .. 200.000 V ) at %7.4r  %M", $abstime );
        $fwrite(outfile,"phvu          VSHW    entering SOCA ( -25.000 V .. 200.000 V ) at %7.4r  %M\n", $abstime );
        VSHW_retc=0;
        VSHW_cnt=VSHW_cnt-1;
        $fclose(outfile);
      end
      if((VSHW > 200) &&  (VSHW_retc!=1))
      begin
        outfile=$fopen(errFileName,"a");
        $strobe("phvu          VSHW    leaving   OCA ( 200.000 V ..  ) at %7.4r  %M", $abstime );
        $fwrite(outfile,"phvu          VSHW    leaving   OCA ( 200.000 V ..  ) at %7.4r  %M\n", $abstime );
        VSHW_retc=1;
        VSHW_cnt=VSHW_cnt-1;
        $fclose(outfile);
      end
   end
   else
   begin
      if(VSHW_cnt==0)
      begin
        outfile=$fopen(errFileName,"a");
        $strobe("phvu          VSHW    error limit ( %d ) reached at %7.4r  %M", maxEv, $abstime );
        $fwrite(outfile,"phvu          VSHW    error limit ( %d ) reached at %7.4r  %M\n", maxEv, $abstime );
        VSHW_cnt=VSHW_cnt-1;
        $fclose(outfile);
      end
   end

end // analog
endmodule // phvu

// Verilog-A OC Watch for device nhvra Parameters  VGS VGD VDS VDB VDHW
module nhvra_ahdl(D,G,S,B,HW);
parameter tstep_occ=100n;
parameter errFileName="./occ.err";
parameter maxEv = 25;
parameter maxEv_flg = 0;
inout D,G,S,B,HW;
electrical D,G,S,B,HW;

integer outfile;
real V_D_HW;
real V_D_B;
real V_D_S;
real V_G_D;
real V_G_S;
real VGS;
integer VGS_retc;
integer VGS_cnt;
real VGD;
integer VGD_retc;
integer VGD_cnt;
real VDS;
integer VDS_retc;
integer VDS_cnt;
real VDB;
integer VDB_retc;
integer VDB_cnt;
real VDHW;
integer VDHW_retc;
integer VDHW_cnt;

analog begin
   $bound_step( tstep_occ );
   @(initial_step) begin
      VGS_retc=0;
      VGS_cnt = maxEv;
      VGD_retc=0;
      VGD_cnt = maxEv;
      VDS_retc=0;
      VDS_cnt = maxEv;
      VDB_retc=0;
      VDB_cnt = maxEv;
      VDHW_retc=0;
      VDHW_cnt = maxEv;
   end
   V_D_HW = V(D,HW);
   V_D_B = V(D,B);
   V_D_S = V(D,S);
   V_G_D = V(G,D);
   V_G_S = V(G,S);

//      VGS
   VGS = V_G_S;
   if((VGS_cnt>0) || ( maxEv_flg==0 ))   begin
      if( (VGS < -5.5) && (VGS_retc!=-1))
      begin
        outfile=$fopen(errFileName,"a");
        $strobe("nhvra         VGS     leaving   OCA (  .. -5.500 V ) at %7.4r  %M", $abstime );
        $fwrite(outfile,"nhvra         VGS     leaving   OCA (  .. -5.500 V ) at %7.4r  %M\n", $abstime );
        VGS_retc=-1;
        VGS_cnt=VGS_cnt-1;
        $fclose(outfile);
      end
      if((VGS >= -5.5) &&  (VGS <= 5.5) && (VGS_retc!=0))
      begin
        outfile=$fopen(errFileName,"a");
        $strobe("nhvra         VGS     entering SOCA ( -5.500 V .. 5.500 V ) at %7.4r  %M", $abstime );
        $fwrite(outfile,"nhvra         VGS     entering SOCA ( -5.500 V .. 5.500 V ) at %7.4r  %M\n", $abstime );
        VGS_retc=0;
        VGS_cnt=VGS_cnt-1;
        $fclose(outfile);
      end
      if((VGS > 5.5) &&  (VGS_retc!=1))
      begin
        outfile=$fopen(errFileName,"a");
        $strobe("nhvra         VGS     leaving   OCA ( 5.500 V ..  ) at %7.4r  %M", $abstime );
        $fwrite(outfile,"nhvra         VGS     leaving   OCA ( 5.500 V ..  ) at %7.4r  %M\n", $abstime );
        VGS_retc=1;
        VGS_cnt=VGS_cnt-1;
        $fclose(outfile);
      end
   end
   else
   begin
      if(VGS_cnt==0)
      begin
        outfile=$fopen(errFileName,"a");
        $strobe("nhvra         VGS     error limit ( %d ) reached at %7.4r  %M", maxEv, $abstime );
        $fwrite(outfile,"nhvra         VGS     error limit ( %d ) reached at %7.4r  %M\n", maxEv, $abstime );
        VGS_cnt=VGS_cnt-1;
        $fclose(outfile);
      end
   end

//      VGD
   VGD = V_G_D;
   if((VGD_cnt>0) || ( maxEv_flg==0 ))   begin
      if( (VGD < -40) && (VGD_retc!=-1))
      begin
        outfile=$fopen(errFileName,"a");
        $strobe("nhvra         VGD     leaving   OCA (  .. -40.000 V ) at %7.4r  %M", $abstime );
        $fwrite(outfile,"nhvra         VGD     leaving   OCA (  .. -40.000 V ) at %7.4r  %M\n", $abstime );
        VGD_retc=-1;
        VGD_cnt=VGD_cnt-1;
        $fclose(outfile);
      end
      if((VGD >= -40) &&  (VGD <= 5.5) && (VGD_retc!=0))
      begin
        outfile=$fopen(errFileName,"a");
        $strobe("nhvra         VGD     entering SOCA ( -40.000 V .. 5.500 V ) at %7.4r  %M", $abstime );
        $fwrite(outfile,"nhvra         VGD     entering SOCA ( -40.000 V .. 5.500 V ) at %7.4r  %M\n", $abstime );
        VGD_retc=0;
        VGD_cnt=VGD_cnt-1;
        $fclose(outfile);
      end
      if((VGD > 5.5) &&  (VGD_retc!=1))
      begin
        outfile=$fopen(errFileName,"a");
        $strobe("nhvra         VGD     leaving   OCA ( 5.500 V ..  ) at %7.4r  %M", $abstime );
        $fwrite(outfile,"nhvra         VGD     leaving   OCA ( 5.500 V ..  ) at %7.4r  %M\n", $abstime );
        VGD_retc=1;
        VGD_cnt=VGD_cnt-1;
        $fclose(outfile);
      end
   end
   else
   begin
      if(VGD_cnt==0)
      begin
        outfile=$fopen(errFileName,"a");
        $strobe("nhvra         VGD     error limit ( %d ) reached at %7.4r  %M", maxEv, $abstime );
        $fwrite(outfile,"nhvra         VGD     error limit ( %d ) reached at %7.4r  %M\n", maxEv, $abstime );
        VGD_cnt=VGD_cnt-1;
        $fclose(outfile);
      end
   end

//      VDS
   VDS = V_D_S;
   if((VDS_cnt>0) || ( maxEv_flg==0 ))   begin
      if( (VDS < -1.5) && (VDS_retc!=-1))
      begin
        outfile=$fopen(errFileName,"a");
        $strobe("nhvra         VDS     leaving   OCA (  .. -1.500 V ) at %7.4r  %M", $abstime );
        $fwrite(outfile,"nhvra         VDS     leaving   OCA (  .. -1.500 V ) at %7.4r  %M\n", $abstime );
        VDS_retc=-1;
        VDS_cnt=VDS_cnt-1;
        $fclose(outfile);
      end
      if((VDS >= -1.5) &&  (VDS <= 40) && (VDS_retc!=0))
      begin
        outfile=$fopen(errFileName,"a");
        $strobe("nhvra         VDS     entering SOCA ( -1.500 V .. 40.000 V ) at %7.4r  %M", $abstime );
        $fwrite(outfile,"nhvra         VDS     entering SOCA ( -1.500 V .. 40.000 V ) at %7.4r  %M\n", $abstime );
        VDS_retc=0;
        VDS_cnt=VDS_cnt-1;
        $fclose(outfile);
      end
      if((VDS > 40) &&  (VDS_retc!=1))
      begin
        outfile=$fopen(errFileName,"a");
        $strobe("nhvra         VDS     leaving   OCA ( 40.000 V ..  ) at %7.4r  %M", $abstime );
        $fwrite(outfile,"nhvra         VDS     leaving   OCA ( 40.000 V ..  ) at %7.4r  %M\n", $abstime );
        VDS_retc=1;
        VDS_cnt=VDS_cnt-1;
        $fclose(outfile);
      end
   end
   else
   begin
      if(VDS_cnt==0)
      begin
        outfile=$fopen(errFileName,"a");
        $strobe("nhvra         VDS     error limit ( %d ) reached at %7.4r  %M", maxEv, $abstime );
        $fwrite(outfile,"nhvra         VDS     error limit ( %d ) reached at %7.4r  %M\n", maxEv, $abstime );
        VDS_cnt=VDS_cnt-1;
        $fclose(outfile);
      end
   end

//      VDB
   VDB = V_D_B;
   if((VDB_cnt>0) || ( maxEv_flg==0 ))   begin
      if( (VDB < -1.5) && (VDB_retc!=-1))
      begin
        outfile=$fopen(errFileName,"a");
        $strobe("nhvra         VDB     leaving   OCA (  .. -1.500 V ) at %7.4r  %M", $abstime );
        $fwrite(outfile,"nhvra         VDB     leaving   OCA (  .. -1.500 V ) at %7.4r  %M\n", $abstime );
        VDB_retc=-1;
        VDB_cnt=VDB_cnt-1;
        $fclose(outfile);
      end
      if((VDB >= -1.5) &&  (VDB <= 40) && (VDB_retc!=0))
      begin
        outfile=$fopen(errFileName,"a");
        $strobe("nhvra         VDB     entering SOCA ( -1.500 V .. 40.000 V ) at %7.4r  %M", $abstime );
        $fwrite(outfile,"nhvra         VDB     entering SOCA ( -1.500 V .. 40.000 V ) at %7.4r  %M\n", $abstime );
        VDB_retc=0;
        VDB_cnt=VDB_cnt-1;
        $fclose(outfile);
      end
      if((VDB > 40) &&  (VDB_retc!=1))
      begin
        outfile=$fopen(errFileName,"a");
        $strobe("nhvra         VDB     leaving   OCA ( 40.000 V ..  ) at %7.4r  %M", $abstime );
        $fwrite(outfile,"nhvra         VDB     leaving   OCA ( 40.000 V ..  ) at %7.4r  %M\n", $abstime );
        VDB_retc=1;
        VDB_cnt=VDB_cnt-1;
        $fclose(outfile);
      end
   end
   else
   begin
      if(VDB_cnt==0)
      begin
        outfile=$fopen(errFileName,"a");
        $strobe("nhvra         VDB     error limit ( %d ) reached at %7.4r  %M", maxEv, $abstime );
        $fwrite(outfile,"nhvra         VDB     error limit ( %d ) reached at %7.4r  %M\n", maxEv, $abstime );
        VDB_cnt=VDB_cnt-1;
        $fclose(outfile);
      end
   end

//      VDHW
   VDHW = V_D_HW;
   if((VDHW_cnt>0) || ( maxEv_flg==0 ))   begin
      if( (VDHW < -25) && (VDHW_retc!=-1))
      begin
        outfile=$fopen(errFileName,"a");
        $strobe("nhvra         VDHW    leaving   OCA (  .. -25.000 V ) at %7.4r  %M", $abstime );
        $fwrite(outfile,"nhvra         VDHW    leaving   OCA (  .. -25.000 V ) at %7.4r  %M\n", $abstime );
        VDHW_retc=-1;
        VDHW_cnt=VDHW_cnt-1;
        $fclose(outfile);
      end
      if((VDHW >= -25) &&  (VDHW <= 125) && (VDHW_retc!=0))
      begin
        outfile=$fopen(errFileName,"a");
        $strobe("nhvra         VDHW    entering SOCA ( -25.000 V .. 125.000 V ) at %7.4r  %M", $abstime );
        $fwrite(outfile,"nhvra         VDHW    entering SOCA ( -25.000 V .. 125.000 V ) at %7.4r  %M\n", $abstime );
        VDHW_retc=0;
        VDHW_cnt=VDHW_cnt-1;
        $fclose(outfile);
      end
      if((VDHW > 125) &&  (VDHW_retc!=1))
      begin
        outfile=$fopen(errFileName,"a");
        $strobe("nhvra         VDHW    leaving   OCA ( 125.000 V ..  ) at %7.4r  %M", $abstime );
        $fwrite(outfile,"nhvra         VDHW    leaving   OCA ( 125.000 V ..  ) at %7.4r  %M\n", $abstime );
        VDHW_retc=1;
        VDHW_cnt=VDHW_cnt-1;
        $fclose(outfile);
      end
   end
   else
   begin
      if(VDHW_cnt==0)
      begin
        outfile=$fopen(errFileName,"a");
        $strobe("nhvra         VDHW    error limit ( %d ) reached at %7.4r  %M", maxEv, $abstime );
        $fwrite(outfile,"nhvra         VDHW    error limit ( %d ) reached at %7.4r  %M\n", maxEv, $abstime );
        VDHW_cnt=VDHW_cnt-1;
        $fclose(outfile);
      end
   end

end // analog
endmodule // nhvra

// Verilog-A OC Watch for device nhvrb Parameters  VGS VGD VDS VDB VDHW
module nhvrb_ahdl(D,G,S,B,HW);
parameter tstep_occ=100n;
parameter errFileName="./occ.err";
parameter maxEv = 25;
parameter maxEv_flg = 0;
inout D,G,S,B,HW;
electrical D,G,S,B,HW;

integer outfile;
real V_D_HW;
real V_D_B;
real V_D_S;
real V_G_D;
real V_G_S;
real VGS;
integer VGS_retc;
integer VGS_cnt;
real VGD;
integer VGD_retc;
integer VGD_cnt;
real VDS;
integer VDS_retc;
integer VDS_cnt;
real VDB;
integer VDB_retc;
integer VDB_cnt;
real VDHW;
integer VDHW_retc;
integer VDHW_cnt;

analog begin
   $bound_step( tstep_occ );
   @(initial_step) begin
      VGS_retc=0;
      VGS_cnt = maxEv;
      VGD_retc=0;
      VGD_cnt = maxEv;
      VDS_retc=0;
      VDS_cnt = maxEv;
      VDB_retc=0;
      VDB_cnt = maxEv;
      VDHW_retc=0;
      VDHW_cnt = maxEv;
   end
   V_D_HW = V(D,HW);
   V_D_B = V(D,B);
   V_D_S = V(D,S);
   V_G_D = V(G,D);
   V_G_S = V(G,S);

//      VGS
   VGS = V_G_S;
   if((VGS_cnt>0) || ( maxEv_flg==0 ))   begin
      if( (VGS < -5.5) && (VGS_retc!=-1))
      begin
        outfile=$fopen(errFileName,"a");
        $strobe("nhvrb         VGS     leaving   OCA (  .. -5.500 V ) at %7.4r  %M", $abstime );
        $fwrite(outfile,"nhvrb         VGS     leaving   OCA (  .. -5.500 V ) at %7.4r  %M\n", $abstime );
        VGS_retc=-1;
        VGS_cnt=VGS_cnt-1;
        $fclose(outfile);
      end
      if((VGS >= -5.5) &&  (VGS <= 5.5) && (VGS_retc!=0))
      begin
        outfile=$fopen(errFileName,"a");
        $strobe("nhvrb         VGS     entering SOCA ( -5.500 V .. 5.500 V ) at %7.4r  %M", $abstime );
        $fwrite(outfile,"nhvrb         VGS     entering SOCA ( -5.500 V .. 5.500 V ) at %7.4r  %M\n", $abstime );
        VGS_retc=0;
        VGS_cnt=VGS_cnt-1;
        $fclose(outfile);
      end
      if((VGS > 5.5) &&  (VGS_retc!=1))
      begin
        outfile=$fopen(errFileName,"a");
        $strobe("nhvrb         VGS     leaving   OCA ( 5.500 V ..  ) at %7.4r  %M", $abstime );
        $fwrite(outfile,"nhvrb         VGS     leaving   OCA ( 5.500 V ..  ) at %7.4r  %M\n", $abstime );
        VGS_retc=1;
        VGS_cnt=VGS_cnt-1;
        $fclose(outfile);
      end
   end
   else
   begin
      if(VGS_cnt==0)
      begin
        outfile=$fopen(errFileName,"a");
        $strobe("nhvrb         VGS     error limit ( %d ) reached at %7.4r  %M", maxEv, $abstime );
        $fwrite(outfile,"nhvrb         VGS     error limit ( %d ) reached at %7.4r  %M\n", maxEv, $abstime );
        VGS_cnt=VGS_cnt-1;
        $fclose(outfile);
      end
   end

//      VGD
   VGD = V_G_D;
   if((VGD_cnt>0) || ( maxEv_flg==0 ))   begin
      if( (VGD < -60) && (VGD_retc!=-1))
      begin
        outfile=$fopen(errFileName,"a");
        $strobe("nhvrb         VGD     leaving   OCA (  .. -60.000 V ) at %7.4r  %M", $abstime );
        $fwrite(outfile,"nhvrb         VGD     leaving   OCA (  .. -60.000 V ) at %7.4r  %M\n", $abstime );
        VGD_retc=-1;
        VGD_cnt=VGD_cnt-1;
        $fclose(outfile);
      end
      if((VGD >= -60) &&  (VGD <= 5.5) && (VGD_retc!=0))
      begin
        outfile=$fopen(errFileName,"a");
        $strobe("nhvrb         VGD     entering SOCA ( -60.000 V .. 5.500 V ) at %7.4r  %M", $abstime );
        $fwrite(outfile,"nhvrb         VGD     entering SOCA ( -60.000 V .. 5.500 V ) at %7.4r  %M\n", $abstime );
        VGD_retc=0;
        VGD_cnt=VGD_cnt-1;
        $fclose(outfile);
      end
      if((VGD > 5.5) &&  (VGD_retc!=1))
      begin
        outfile=$fopen(errFileName,"a");
        $strobe("nhvrb         VGD     leaving   OCA ( 5.500 V ..  ) at %7.4r  %M", $abstime );
        $fwrite(outfile,"nhvrb         VGD     leaving   OCA ( 5.500 V ..  ) at %7.4r  %M\n", $abstime );
        VGD_retc=1;
        VGD_cnt=VGD_cnt-1;
        $fclose(outfile);
      end
   end
   else
   begin
      if(VGD_cnt==0)
      begin
        outfile=$fopen(errFileName,"a");
        $strobe("nhvrb         VGD     error limit ( %d ) reached at %7.4r  %M", maxEv, $abstime );
        $fwrite(outfile,"nhvrb         VGD     error limit ( %d ) reached at %7.4r  %M\n", maxEv, $abstime );
        VGD_cnt=VGD_cnt-1;
        $fclose(outfile);
      end
   end

//      VDS
   VDS = V_D_S;
   if((VDS_cnt>0) || ( maxEv_flg==0 ))   begin
      if( (VDS < -1.5) && (VDS_retc!=-1))
      begin
        outfile=$fopen(errFileName,"a");
        $strobe("nhvrb         VDS     leaving   OCA (  .. -1.500 V ) at %7.4r  %M", $abstime );
        $fwrite(outfile,"nhvrb         VDS     leaving   OCA (  .. -1.500 V ) at %7.4r  %M\n", $abstime );
        VDS_retc=-1;
        VDS_cnt=VDS_cnt-1;
        $fclose(outfile);
      end
      if((VDS >= -1.5) &&  (VDS <= 60) && (VDS_retc!=0))
      begin
        outfile=$fopen(errFileName,"a");
        $strobe("nhvrb         VDS     entering SOCA ( -1.500 V .. 60.000 V ) at %7.4r  %M", $abstime );
        $fwrite(outfile,"nhvrb         VDS     entering SOCA ( -1.500 V .. 60.000 V ) at %7.4r  %M\n", $abstime );
        VDS_retc=0;
        VDS_cnt=VDS_cnt-1;
        $fclose(outfile);
      end
      if((VDS > 60) &&  (VDS_retc!=1))
      begin
        outfile=$fopen(errFileName,"a");
        $strobe("nhvrb         VDS     leaving   OCA ( 60.000 V ..  ) at %7.4r  %M", $abstime );
        $fwrite(outfile,"nhvrb         VDS     leaving   OCA ( 60.000 V ..  ) at %7.4r  %M\n", $abstime );
        VDS_retc=1;
        VDS_cnt=VDS_cnt-1;
        $fclose(outfile);
      end
   end
   else
   begin
      if(VDS_cnt==0)
      begin
        outfile=$fopen(errFileName,"a");
        $strobe("nhvrb         VDS     error limit ( %d ) reached at %7.4r  %M", maxEv, $abstime );
        $fwrite(outfile,"nhvrb         VDS     error limit ( %d ) reached at %7.4r  %M\n", maxEv, $abstime );
        VDS_cnt=VDS_cnt-1;
        $fclose(outfile);
      end
   end

//      VDB
   VDB = V_D_B;
   if((VDB_cnt>0) || ( maxEv_flg==0 ))   begin
      if( (VDB < -1.5) && (VDB_retc!=-1))
      begin
        outfile=$fopen(errFileName,"a");
        $strobe("nhvrb         VDB     leaving   OCA (  .. -1.500 V ) at %7.4r  %M", $abstime );
        $fwrite(outfile,"nhvrb         VDB     leaving   OCA (  .. -1.500 V ) at %7.4r  %M\n", $abstime );
        VDB_retc=-1;
        VDB_cnt=VDB_cnt-1;
        $fclose(outfile);
      end
      if((VDB >= -1.5) &&  (VDB <= 60) && (VDB_retc!=0))
      begin
        outfile=$fopen(errFileName,"a");
        $strobe("nhvrb         VDB     entering SOCA ( -1.500 V .. 60.000 V ) at %7.4r  %M", $abstime );
        $fwrite(outfile,"nhvrb         VDB     entering SOCA ( -1.500 V .. 60.000 V ) at %7.4r  %M\n", $abstime );
        VDB_retc=0;
        VDB_cnt=VDB_cnt-1;
        $fclose(outfile);
      end
      if((VDB > 60) &&  (VDB_retc!=1))
      begin
        outfile=$fopen(errFileName,"a");
        $strobe("nhvrb         VDB     leaving   OCA ( 60.000 V ..  ) at %7.4r  %M", $abstime );
        $fwrite(outfile,"nhvrb         VDB     leaving   OCA ( 60.000 V ..  ) at %7.4r  %M\n", $abstime );
        VDB_retc=1;
        VDB_cnt=VDB_cnt-1;
        $fclose(outfile);
      end
   end
   else
   begin
      if(VDB_cnt==0)
      begin
        outfile=$fopen(errFileName,"a");
        $strobe("nhvrb         VDB     error limit ( %d ) reached at %7.4r  %M", maxEv, $abstime );
        $fwrite(outfile,"nhvrb         VDB     error limit ( %d ) reached at %7.4r  %M\n", maxEv, $abstime );
        VDB_cnt=VDB_cnt-1;
        $fclose(outfile);
      end
   end

//      VDHW
   VDHW = V_D_HW;
   if((VDHW_cnt>0) || ( maxEv_flg==0 ))   begin
      if( (VDHW < -25) && (VDHW_retc!=-1))
      begin
        outfile=$fopen(errFileName,"a");
        $strobe("nhvrb         VDHW    leaving   OCA (  .. -25.000 V ) at %7.4r  %M", $abstime );
        $fwrite(outfile,"nhvrb         VDHW    leaving   OCA (  .. -25.000 V ) at %7.4r  %M\n", $abstime );
        VDHW_retc=-1;
        VDHW_cnt=VDHW_cnt-1;
        $fclose(outfile);
      end
      if((VDHW >= -25) &&  (VDHW <= 125) && (VDHW_retc!=0))
      begin
        outfile=$fopen(errFileName,"a");
        $strobe("nhvrb         VDHW    entering SOCA ( -25.000 V .. 125.000 V ) at %7.4r  %M", $abstime );
        $fwrite(outfile,"nhvrb         VDHW    entering SOCA ( -25.000 V .. 125.000 V ) at %7.4r  %M\n", $abstime );
        VDHW_retc=0;
        VDHW_cnt=VDHW_cnt-1;
        $fclose(outfile);
      end
      if((VDHW > 125) &&  (VDHW_retc!=1))
      begin
        outfile=$fopen(errFileName,"a");
        $strobe("nhvrb         VDHW    leaving   OCA ( 125.000 V ..  ) at %7.4r  %M", $abstime );
        $fwrite(outfile,"nhvrb         VDHW    leaving   OCA ( 125.000 V ..  ) at %7.4r  %M\n", $abstime );
        VDHW_retc=1;
        VDHW_cnt=VDHW_cnt-1;
        $fclose(outfile);
      end
   end
   else
   begin
      if(VDHW_cnt==0)
      begin
        outfile=$fopen(errFileName,"a");
        $strobe("nhvrb         VDHW    error limit ( %d ) reached at %7.4r  %M", maxEv, $abstime );
        $fwrite(outfile,"nhvrb         VDHW    error limit ( %d ) reached at %7.4r  %M\n", maxEv, $abstime );
        VDHW_cnt=VDHW_cnt-1;
        $fclose(outfile);
      end
   end

end // analog
endmodule // nhvrb

// Verilog-A OC Watch for device nhvrc Parameters  VGS VGD VDS VDB VDHW
module nhvrc_ahdl(D,G,S,B,HW);
parameter tstep_occ=100n;
parameter errFileName="./occ.err";
parameter maxEv = 25;
parameter maxEv_flg = 0;
inout D,G,S,B,HW;
electrical D,G,S,B,HW;

integer outfile;
real V_D_HW;
real V_D_B;
real V_D_S;
real V_G_D;
real V_G_S;
real VGS;
integer VGS_retc;
integer VGS_cnt;
real VGD;
integer VGD_retc;
integer VGD_cnt;
real VDS;
integer VDS_retc;
integer VDS_cnt;
real VDB;
integer VDB_retc;
integer VDB_cnt;
real VDHW;
integer VDHW_retc;
integer VDHW_cnt;

analog begin
   $bound_step( tstep_occ );
   @(initial_step) begin
      VGS_retc=0;
      VGS_cnt = maxEv;
      VGD_retc=0;
      VGD_cnt = maxEv;
      VDS_retc=0;
      VDS_cnt = maxEv;
      VDB_retc=0;
      VDB_cnt = maxEv;
      VDHW_retc=0;
      VDHW_cnt = maxEv;
   end
   V_D_HW = V(D,HW);
   V_D_B = V(D,B);
   V_D_S = V(D,S);
   V_G_D = V(G,D);
   V_G_S = V(G,S);

//      VGS
   VGS = V_G_S;
   if((VGS_cnt>0) || ( maxEv_flg==0 ))   begin
      if( (VGS < -5.5) && (VGS_retc!=-1))
      begin
        outfile=$fopen(errFileName,"a");
        $strobe("nhvrc         VGS     leaving   OCA (  .. -5.500 V ) at %7.4r  %M", $abstime );
        $fwrite(outfile,"nhvrc         VGS     leaving   OCA (  .. -5.500 V ) at %7.4r  %M\n", $abstime );
        VGS_retc=-1;
        VGS_cnt=VGS_cnt-1;
        $fclose(outfile);
      end
      if((VGS >= -5.5) &&  (VGS <= 5.5) && (VGS_retc!=0))
      begin
        outfile=$fopen(errFileName,"a");
        $strobe("nhvrc         VGS     entering SOCA ( -5.500 V .. 5.500 V ) at %7.4r  %M", $abstime );
        $fwrite(outfile,"nhvrc         VGS     entering SOCA ( -5.500 V .. 5.500 V ) at %7.4r  %M\n", $abstime );
        VGS_retc=0;
        VGS_cnt=VGS_cnt-1;
        $fclose(outfile);
      end
      if((VGS > 5.5) &&  (VGS_retc!=1))
      begin
        outfile=$fopen(errFileName,"a");
        $strobe("nhvrc         VGS     leaving   OCA ( 5.500 V ..  ) at %7.4r  %M", $abstime );
        $fwrite(outfile,"nhvrc         VGS     leaving   OCA ( 5.500 V ..  ) at %7.4r  %M\n", $abstime );
        VGS_retc=1;
        VGS_cnt=VGS_cnt-1;
        $fclose(outfile);
      end
   end
   else
   begin
      if(VGS_cnt==0)
      begin
        outfile=$fopen(errFileName,"a");
        $strobe("nhvrc         VGS     error limit ( %d ) reached at %7.4r  %M", maxEv, $abstime );
        $fwrite(outfile,"nhvrc         VGS     error limit ( %d ) reached at %7.4r  %M\n", maxEv, $abstime );
        VGS_cnt=VGS_cnt-1;
        $fclose(outfile);
      end
   end

//      VGD
   VGD = V_G_D;
   if((VGD_cnt>0) || ( maxEv_flg==0 ))   begin
      if( (VGD < -70) && (VGD_retc!=-1))
      begin
        outfile=$fopen(errFileName,"a");
        $strobe("nhvrc         VGD     leaving   OCA (  .. -70.000 V ) at %7.4r  %M", $abstime );
        $fwrite(outfile,"nhvrc         VGD     leaving   OCA (  .. -70.000 V ) at %7.4r  %M\n", $abstime );
        VGD_retc=-1;
        VGD_cnt=VGD_cnt-1;
        $fclose(outfile);
      end
      if((VGD >= -70) &&  (VGD <= 5.5) && (VGD_retc!=0))
      begin
        outfile=$fopen(errFileName,"a");
        $strobe("nhvrc         VGD     entering SOCA ( -70.000 V .. 5.500 V ) at %7.4r  %M", $abstime );
        $fwrite(outfile,"nhvrc         VGD     entering SOCA ( -70.000 V .. 5.500 V ) at %7.4r  %M\n", $abstime );
        VGD_retc=0;
        VGD_cnt=VGD_cnt-1;
        $fclose(outfile);
      end
      if((VGD > 5.5) &&  (VGD_retc!=1))
      begin
        outfile=$fopen(errFileName,"a");
        $strobe("nhvrc         VGD     leaving   OCA ( 5.500 V ..  ) at %7.4r  %M", $abstime );
        $fwrite(outfile,"nhvrc         VGD     leaving   OCA ( 5.500 V ..  ) at %7.4r  %M\n", $abstime );
        VGD_retc=1;
        VGD_cnt=VGD_cnt-1;
        $fclose(outfile);
      end
   end
   else
   begin
      if(VGD_cnt==0)
      begin
        outfile=$fopen(errFileName,"a");
        $strobe("nhvrc         VGD     error limit ( %d ) reached at %7.4r  %M", maxEv, $abstime );
        $fwrite(outfile,"nhvrc         VGD     error limit ( %d ) reached at %7.4r  %M\n", maxEv, $abstime );
        VGD_cnt=VGD_cnt-1;
        $fclose(outfile);
      end
   end

//      VDS
   VDS = V_D_S;
   if((VDS_cnt>0) || ( maxEv_flg==0 ))   begin
      if( (VDS < -1.5) && (VDS_retc!=-1))
      begin
        outfile=$fopen(errFileName,"a");
        $strobe("nhvrc         VDS     leaving   OCA (  .. -1.500 V ) at %7.4r  %M", $abstime );
        $fwrite(outfile,"nhvrc         VDS     leaving   OCA (  .. -1.500 V ) at %7.4r  %M\n", $abstime );
        VDS_retc=-1;
        VDS_cnt=VDS_cnt-1;
        $fclose(outfile);
      end
      if((VDS >= -1.5) &&  (VDS <= 70) && (VDS_retc!=0))
      begin
        outfile=$fopen(errFileName,"a");
        $strobe("nhvrc         VDS     entering SOCA ( -1.500 V .. 70.000 V ) at %7.4r  %M", $abstime );
        $fwrite(outfile,"nhvrc         VDS     entering SOCA ( -1.500 V .. 70.000 V ) at %7.4r  %M\n", $abstime );
        VDS_retc=0;
        VDS_cnt=VDS_cnt-1;
        $fclose(outfile);
      end
      if((VDS > 70) &&  (VDS_retc!=1))
      begin
        outfile=$fopen(errFileName,"a");
        $strobe("nhvrc         VDS     leaving   OCA ( 70.000 V ..  ) at %7.4r  %M", $abstime );
        $fwrite(outfile,"nhvrc         VDS     leaving   OCA ( 70.000 V ..  ) at %7.4r  %M\n", $abstime );
        VDS_retc=1;
        VDS_cnt=VDS_cnt-1;
        $fclose(outfile);
      end
   end
   else
   begin
      if(VDS_cnt==0)
      begin
        outfile=$fopen(errFileName,"a");
        $strobe("nhvrc         VDS     error limit ( %d ) reached at %7.4r  %M", maxEv, $abstime );
        $fwrite(outfile,"nhvrc         VDS     error limit ( %d ) reached at %7.4r  %M\n", maxEv, $abstime );
        VDS_cnt=VDS_cnt-1;
        $fclose(outfile);
      end
   end

//      VDB
   VDB = V_D_B;
   if((VDB_cnt>0) || ( maxEv_flg==0 ))   begin
      if( (VDB < -1.5) && (VDB_retc!=-1))
      begin
        outfile=$fopen(errFileName,"a");
        $strobe("nhvrc         VDB     leaving   OCA (  .. -1.500 V ) at %7.4r  %M", $abstime );
        $fwrite(outfile,"nhvrc         VDB     leaving   OCA (  .. -1.500 V ) at %7.4r  %M\n", $abstime );
        VDB_retc=-1;
        VDB_cnt=VDB_cnt-1;
        $fclose(outfile);
      end
      if((VDB >= -1.5) &&  (VDB <= 70) && (VDB_retc!=0))
      begin
        outfile=$fopen(errFileName,"a");
        $strobe("nhvrc         VDB     entering SOCA ( -1.500 V .. 70.000 V ) at %7.4r  %M", $abstime );
        $fwrite(outfile,"nhvrc         VDB     entering SOCA ( -1.500 V .. 70.000 V ) at %7.4r  %M\n", $abstime );
        VDB_retc=0;
        VDB_cnt=VDB_cnt-1;
        $fclose(outfile);
      end
      if((VDB > 70) &&  (VDB_retc!=1))
      begin
        outfile=$fopen(errFileName,"a");
        $strobe("nhvrc         VDB     leaving   OCA ( 70.000 V ..  ) at %7.4r  %M", $abstime );
        $fwrite(outfile,"nhvrc         VDB     leaving   OCA ( 70.000 V ..  ) at %7.4r  %M\n", $abstime );
        VDB_retc=1;
        VDB_cnt=VDB_cnt-1;
        $fclose(outfile);
      end
   end
   else
   begin
      if(VDB_cnt==0)
      begin
        outfile=$fopen(errFileName,"a");
        $strobe("nhvrc         VDB     error limit ( %d ) reached at %7.4r  %M", maxEv, $abstime );
        $fwrite(outfile,"nhvrc         VDB     error limit ( %d ) reached at %7.4r  %M\n", maxEv, $abstime );
        VDB_cnt=VDB_cnt-1;
        $fclose(outfile);
      end
   end

//      VDHW
   VDHW = V_D_HW;
   if((VDHW_cnt>0) || ( maxEv_flg==0 ))   begin
      if( (VDHW < -25) && (VDHW_retc!=-1))
      begin
        outfile=$fopen(errFileName,"a");
        $strobe("nhvrc         VDHW    leaving   OCA (  .. -25.000 V ) at %7.4r  %M", $abstime );
        $fwrite(outfile,"nhvrc         VDHW    leaving   OCA (  .. -25.000 V ) at %7.4r  %M\n", $abstime );
        VDHW_retc=-1;
        VDHW_cnt=VDHW_cnt-1;
        $fclose(outfile);
      end
      if((VDHW >= -25) &&  (VDHW <= 125) && (VDHW_retc!=0))
      begin
        outfile=$fopen(errFileName,"a");
        $strobe("nhvrc         VDHW    entering SOCA ( -25.000 V .. 125.000 V ) at %7.4r  %M", $abstime );
        $fwrite(outfile,"nhvrc         VDHW    entering SOCA ( -25.000 V .. 125.000 V ) at %7.4r  %M\n", $abstime );
        VDHW_retc=0;
        VDHW_cnt=VDHW_cnt-1;
        $fclose(outfile);
      end
      if((VDHW > 125) &&  (VDHW_retc!=1))
      begin
        outfile=$fopen(errFileName,"a");
        $strobe("nhvrc         VDHW    leaving   OCA ( 125.000 V ..  ) at %7.4r  %M", $abstime );
        $fwrite(outfile,"nhvrc         VDHW    leaving   OCA ( 125.000 V ..  ) at %7.4r  %M\n", $abstime );
        VDHW_retc=1;
        VDHW_cnt=VDHW_cnt-1;
        $fclose(outfile);
      end
   end
   else
   begin
      if(VDHW_cnt==0)
      begin
        outfile=$fopen(errFileName,"a");
        $strobe("nhvrc         VDHW    error limit ( %d ) reached at %7.4r  %M", maxEv, $abstime );
        $fwrite(outfile,"nhvrc         VDHW    error limit ( %d ) reached at %7.4r  %M\n", maxEv, $abstime );
        VDHW_cnt=VDHW_cnt-1;
        $fclose(outfile);
      end
   end

end // analog
endmodule // nhvrc

// Verilog-A OC Watch for device nhvrd Parameters  VGS VGD VDS VDB VDHW
module nhvrd_ahdl(D,G,S,B,HW);
parameter tstep_occ=100n;
parameter errFileName="./occ.err";
parameter maxEv = 25;
parameter maxEv_flg = 0;
inout D,G,S,B,HW;
electrical D,G,S,B,HW;

integer outfile;
real V_D_HW;
real V_D_B;
real V_D_S;
real V_G_D;
real V_G_S;
real VGS;
integer VGS_retc;
integer VGS_cnt;
real VGD;
integer VGD_retc;
integer VGD_cnt;
real VDS;
integer VDS_retc;
integer VDS_cnt;
real VDB;
integer VDB_retc;
integer VDB_cnt;
real VDHW;
integer VDHW_retc;
integer VDHW_cnt;

analog begin
   $bound_step( tstep_occ );
   @(initial_step) begin
      VGS_retc=0;
      VGS_cnt = maxEv;
      VGD_retc=0;
      VGD_cnt = maxEv;
      VDS_retc=0;
      VDS_cnt = maxEv;
      VDB_retc=0;
      VDB_cnt = maxEv;
      VDHW_retc=0;
      VDHW_cnt = maxEv;
   end
   V_D_HW = V(D,HW);
   V_D_B = V(D,B);
   V_D_S = V(D,S);
   V_G_D = V(G,D);
   V_G_S = V(G,S);

//      VGS
   VGS = V_G_S;
   if((VGS_cnt>0) || ( maxEv_flg==0 ))   begin
      if( (VGS < -5.5) && (VGS_retc!=-1))
      begin
        outfile=$fopen(errFileName,"a");
        $strobe("nhvrd         VGS     leaving   OCA (  .. -5.500 V ) at %7.4r  %M", $abstime );
        $fwrite(outfile,"nhvrd         VGS     leaving   OCA (  .. -5.500 V ) at %7.4r  %M\n", $abstime );
        VGS_retc=-1;
        VGS_cnt=VGS_cnt-1;
        $fclose(outfile);
      end
      if((VGS >= -5.5) &&  (VGS <= 5.5) && (VGS_retc!=0))
      begin
        outfile=$fopen(errFileName,"a");
        $strobe("nhvrd         VGS     entering SOCA ( -5.500 V .. 5.500 V ) at %7.4r  %M", $abstime );
        $fwrite(outfile,"nhvrd         VGS     entering SOCA ( -5.500 V .. 5.500 V ) at %7.4r  %M\n", $abstime );
        VGS_retc=0;
        VGS_cnt=VGS_cnt-1;
        $fclose(outfile);
      end
      if((VGS > 5.5) &&  (VGS_retc!=1))
      begin
        outfile=$fopen(errFileName,"a");
        $strobe("nhvrd         VGS     leaving   OCA ( 5.500 V ..  ) at %7.4r  %M", $abstime );
        $fwrite(outfile,"nhvrd         VGS     leaving   OCA ( 5.500 V ..  ) at %7.4r  %M\n", $abstime );
        VGS_retc=1;
        VGS_cnt=VGS_cnt-1;
        $fclose(outfile);
      end
   end
   else
   begin
      if(VGS_cnt==0)
      begin
        outfile=$fopen(errFileName,"a");
        $strobe("nhvrd         VGS     error limit ( %d ) reached at %7.4r  %M", maxEv, $abstime );
        $fwrite(outfile,"nhvrd         VGS     error limit ( %d ) reached at %7.4r  %M\n", maxEv, $abstime );
        VGS_cnt=VGS_cnt-1;
        $fclose(outfile);
      end
   end

//      VGD
   VGD = V_G_D;
   if((VGD_cnt>0) || ( maxEv_flg==0 ))   begin
      if( (VGD < -85) && (VGD_retc!=-1))
      begin
        outfile=$fopen(errFileName,"a");
        $strobe("nhvrd         VGD     leaving   OCA (  .. -85.000 V ) at %7.4r  %M", $abstime );
        $fwrite(outfile,"nhvrd         VGD     leaving   OCA (  .. -85.000 V ) at %7.4r  %M\n", $abstime );
        VGD_retc=-1;
        VGD_cnt=VGD_cnt-1;
        $fclose(outfile);
      end
      if((VGD >= -85) &&  (VGD <= 5.5) && (VGD_retc!=0))
      begin
        outfile=$fopen(errFileName,"a");
        $strobe("nhvrd         VGD     entering SOCA ( -85.000 V .. 5.500 V ) at %7.4r  %M", $abstime );
        $fwrite(outfile,"nhvrd         VGD     entering SOCA ( -85.000 V .. 5.500 V ) at %7.4r  %M\n", $abstime );
        VGD_retc=0;
        VGD_cnt=VGD_cnt-1;
        $fclose(outfile);
      end
      if((VGD > 5.5) &&  (VGD_retc!=1))
      begin
        outfile=$fopen(errFileName,"a");
        $strobe("nhvrd         VGD     leaving   OCA ( 5.500 V ..  ) at %7.4r  %M", $abstime );
        $fwrite(outfile,"nhvrd         VGD     leaving   OCA ( 5.500 V ..  ) at %7.4r  %M\n", $abstime );
        VGD_retc=1;
        VGD_cnt=VGD_cnt-1;
        $fclose(outfile);
      end
   end
   else
   begin
      if(VGD_cnt==0)
      begin
        outfile=$fopen(errFileName,"a");
        $strobe("nhvrd         VGD     error limit ( %d ) reached at %7.4r  %M", maxEv, $abstime );
        $fwrite(outfile,"nhvrd         VGD     error limit ( %d ) reached at %7.4r  %M\n", maxEv, $abstime );
        VGD_cnt=VGD_cnt-1;
        $fclose(outfile);
      end
   end

//      VDS
   VDS = V_D_S;
   if((VDS_cnt>0) || ( maxEv_flg==0 ))   begin
      if( (VDS < -1.5) && (VDS_retc!=-1))
      begin
        outfile=$fopen(errFileName,"a");
        $strobe("nhvrd         VDS     leaving   OCA (  .. -1.500 V ) at %7.4r  %M", $abstime );
        $fwrite(outfile,"nhvrd         VDS     leaving   OCA (  .. -1.500 V ) at %7.4r  %M\n", $abstime );
        VDS_retc=-1;
        VDS_cnt=VDS_cnt-1;
        $fclose(outfile);
      end
      if((VDS >= -1.5) &&  (VDS <= 85) && (VDS_retc!=0))
      begin
        outfile=$fopen(errFileName,"a");
        $strobe("nhvrd         VDS     entering SOCA ( -1.500 V .. 85.000 V ) at %7.4r  %M", $abstime );
        $fwrite(outfile,"nhvrd         VDS     entering SOCA ( -1.500 V .. 85.000 V ) at %7.4r  %M\n", $abstime );
        VDS_retc=0;
        VDS_cnt=VDS_cnt-1;
        $fclose(outfile);
      end
      if((VDS > 85) &&  (VDS_retc!=1))
      begin
        outfile=$fopen(errFileName,"a");
        $strobe("nhvrd         VDS     leaving   OCA ( 85.000 V ..  ) at %7.4r  %M", $abstime );
        $fwrite(outfile,"nhvrd         VDS     leaving   OCA ( 85.000 V ..  ) at %7.4r  %M\n", $abstime );
        VDS_retc=1;
        VDS_cnt=VDS_cnt-1;
        $fclose(outfile);
      end
   end
   else
   begin
      if(VDS_cnt==0)
      begin
        outfile=$fopen(errFileName,"a");
        $strobe("nhvrd         VDS     error limit ( %d ) reached at %7.4r  %M", maxEv, $abstime );
        $fwrite(outfile,"nhvrd         VDS     error limit ( %d ) reached at %7.4r  %M\n", maxEv, $abstime );
        VDS_cnt=VDS_cnt-1;
        $fclose(outfile);
      end
   end

//      VDB
   VDB = V_D_B;
   if((VDB_cnt>0) || ( maxEv_flg==0 ))   begin
      if( (VDB < -1.5) && (VDB_retc!=-1))
      begin
        outfile=$fopen(errFileName,"a");
        $strobe("nhvrd         VDB     leaving   OCA (  .. -1.500 V ) at %7.4r  %M", $abstime );
        $fwrite(outfile,"nhvrd         VDB     leaving   OCA (  .. -1.500 V ) at %7.4r  %M\n", $abstime );
        VDB_retc=-1;
        VDB_cnt=VDB_cnt-1;
        $fclose(outfile);
      end
      if((VDB >= -1.5) &&  (VDB <= 85) && (VDB_retc!=0))
      begin
        outfile=$fopen(errFileName,"a");
        $strobe("nhvrd         VDB     entering SOCA ( -1.500 V .. 85.000 V ) at %7.4r  %M", $abstime );
        $fwrite(outfile,"nhvrd         VDB     entering SOCA ( -1.500 V .. 85.000 V ) at %7.4r  %M\n", $abstime );
        VDB_retc=0;
        VDB_cnt=VDB_cnt-1;
        $fclose(outfile);
      end
      if((VDB > 85) &&  (VDB_retc!=1))
      begin
        outfile=$fopen(errFileName,"a");
        $strobe("nhvrd         VDB     leaving   OCA ( 85.000 V ..  ) at %7.4r  %M", $abstime );
        $fwrite(outfile,"nhvrd         VDB     leaving   OCA ( 85.000 V ..  ) at %7.4r  %M\n", $abstime );
        VDB_retc=1;
        VDB_cnt=VDB_cnt-1;
        $fclose(outfile);
      end
   end
   else
   begin
      if(VDB_cnt==0)
      begin
        outfile=$fopen(errFileName,"a");
        $strobe("nhvrd         VDB     error limit ( %d ) reached at %7.4r  %M", maxEv, $abstime );
        $fwrite(outfile,"nhvrd         VDB     error limit ( %d ) reached at %7.4r  %M\n", maxEv, $abstime );
        VDB_cnt=VDB_cnt-1;
        $fclose(outfile);
      end
   end

//      VDHW
   VDHW = V_D_HW;
   if((VDHW_cnt>0) || ( maxEv_flg==0 ))   begin
      if( (VDHW < -25) && (VDHW_retc!=-1))
      begin
        outfile=$fopen(errFileName,"a");
        $strobe("nhvrd         VDHW    leaving   OCA (  .. -25.000 V ) at %7.4r  %M", $abstime );
        $fwrite(outfile,"nhvrd         VDHW    leaving   OCA (  .. -25.000 V ) at %7.4r  %M\n", $abstime );
        VDHW_retc=-1;
        VDHW_cnt=VDHW_cnt-1;
        $fclose(outfile);
      end
      if((VDHW >= -25) &&  (VDHW <= 125) && (VDHW_retc!=0))
      begin
        outfile=$fopen(errFileName,"a");
        $strobe("nhvrd         VDHW    entering SOCA ( -25.000 V .. 125.000 V ) at %7.4r  %M", $abstime );
        $fwrite(outfile,"nhvrd         VDHW    entering SOCA ( -25.000 V .. 125.000 V ) at %7.4r  %M\n", $abstime );
        VDHW_retc=0;
        VDHW_cnt=VDHW_cnt-1;
        $fclose(outfile);
      end
      if((VDHW > 125) &&  (VDHW_retc!=1))
      begin
        outfile=$fopen(errFileName,"a");
        $strobe("nhvrd         VDHW    leaving   OCA ( 125.000 V ..  ) at %7.4r  %M", $abstime );
        $fwrite(outfile,"nhvrd         VDHW    leaving   OCA ( 125.000 V ..  ) at %7.4r  %M\n", $abstime );
        VDHW_retc=1;
        VDHW_cnt=VDHW_cnt-1;
        $fclose(outfile);
      end
   end
   else
   begin
      if(VDHW_cnt==0)
      begin
        outfile=$fopen(errFileName,"a");
        $strobe("nhvrd         VDHW    error limit ( %d ) reached at %7.4r  %M", maxEv, $abstime );
        $fwrite(outfile,"nhvrd         VDHW    error limit ( %d ) reached at %7.4r  %M\n", maxEv, $abstime );
        VDHW_cnt=VDHW_cnt-1;
        $fclose(outfile);
      end
   end

end // analog
endmodule // nhvrd

// Verilog-A OC Watch for device nhvre Parameters  VGS VGD VDS VDB VDHW
module nhvre_ahdl(D,G,S,B,HW);
parameter tstep_occ=100n;
parameter errFileName="./occ.err";
parameter maxEv = 25;
parameter maxEv_flg = 0;
inout D,G,S,B,HW;
electrical D,G,S,B,HW;

integer outfile;
real V_D_HW;
real V_D_B;
real V_D_S;
real V_G_D;
real V_G_S;
real VGS;
integer VGS_retc;
integer VGS_cnt;
real VGD;
integer VGD_retc;
integer VGD_cnt;
real VDS;
integer VDS_retc;
integer VDS_cnt;
real VDB;
integer VDB_retc;
integer VDB_cnt;
real VDHW;
integer VDHW_retc;
integer VDHW_cnt;

analog begin
   $bound_step( tstep_occ );
   @(initial_step) begin
      VGS_retc=0;
      VGS_cnt = maxEv;
      VGD_retc=0;
      VGD_cnt = maxEv;
      VDS_retc=0;
      VDS_cnt = maxEv;
      VDB_retc=0;
      VDB_cnt = maxEv;
      VDHW_retc=0;
      VDHW_cnt = maxEv;
   end
   V_D_HW = V(D,HW);
   V_D_B = V(D,B);
   V_D_S = V(D,S);
   V_G_D = V(G,D);
   V_G_S = V(G,S);

//      VGS
   VGS = V_G_S;
   if((VGS_cnt>0) || ( maxEv_flg==0 ))   begin
      if( (VGS < -5.5) && (VGS_retc!=-1))
      begin
        outfile=$fopen(errFileName,"a");
        $strobe("nhvre         VGS     leaving   OCA (  .. -5.500 V ) at %7.4r  %M", $abstime );
        $fwrite(outfile,"nhvre         VGS     leaving   OCA (  .. -5.500 V ) at %7.4r  %M\n", $abstime );
        VGS_retc=-1;
        VGS_cnt=VGS_cnt-1;
        $fclose(outfile);
      end
      if((VGS >= -5.5) &&  (VGS <= 5.5) && (VGS_retc!=0))
      begin
        outfile=$fopen(errFileName,"a");
        $strobe("nhvre         VGS     entering SOCA ( -5.500 V .. 5.500 V ) at %7.4r  %M", $abstime );
        $fwrite(outfile,"nhvre         VGS     entering SOCA ( -5.500 V .. 5.500 V ) at %7.4r  %M\n", $abstime );
        VGS_retc=0;
        VGS_cnt=VGS_cnt-1;
        $fclose(outfile);
      end
      if((VGS > 5.5) &&  (VGS_retc!=1))
      begin
        outfile=$fopen(errFileName,"a");
        $strobe("nhvre         VGS     leaving   OCA ( 5.500 V ..  ) at %7.4r  %M", $abstime );
        $fwrite(outfile,"nhvre         VGS     leaving   OCA ( 5.500 V ..  ) at %7.4r  %M\n", $abstime );
        VGS_retc=1;
        VGS_cnt=VGS_cnt-1;
        $fclose(outfile);
      end
   end
   else
   begin
      if(VGS_cnt==0)
      begin
        outfile=$fopen(errFileName,"a");
        $strobe("nhvre         VGS     error limit ( %d ) reached at %7.4r  %M", maxEv, $abstime );
        $fwrite(outfile,"nhvre         VGS     error limit ( %d ) reached at %7.4r  %M\n", maxEv, $abstime );
        VGS_cnt=VGS_cnt-1;
        $fclose(outfile);
      end
   end

//      VGD
   VGD = V_G_D;
   if((VGD_cnt>0) || ( maxEv_flg==0 ))   begin
      if( (VGD < -100) && (VGD_retc!=-1))
      begin
        outfile=$fopen(errFileName,"a");
        $strobe("nhvre         VGD     leaving   OCA (  .. -100.000 V ) at %7.4r  %M", $abstime );
        $fwrite(outfile,"nhvre         VGD     leaving   OCA (  .. -100.000 V ) at %7.4r  %M\n", $abstime );
        VGD_retc=-1;
        VGD_cnt=VGD_cnt-1;
        $fclose(outfile);
      end
      if((VGD >= -100) &&  (VGD <= 5.5) && (VGD_retc!=0))
      begin
        outfile=$fopen(errFileName,"a");
        $strobe("nhvre         VGD     entering SOCA ( -100.000 V .. 5.500 V ) at %7.4r  %M", $abstime );
        $fwrite(outfile,"nhvre         VGD     entering SOCA ( -100.000 V .. 5.500 V ) at %7.4r  %M\n", $abstime );
        VGD_retc=0;
        VGD_cnt=VGD_cnt-1;
        $fclose(outfile);
      end
      if((VGD > 5.5) &&  (VGD_retc!=1))
      begin
        outfile=$fopen(errFileName,"a");
        $strobe("nhvre         VGD     leaving   OCA ( 5.500 V ..  ) at %7.4r  %M", $abstime );
        $fwrite(outfile,"nhvre         VGD     leaving   OCA ( 5.500 V ..  ) at %7.4r  %M\n", $abstime );
        VGD_retc=1;
        VGD_cnt=VGD_cnt-1;
        $fclose(outfile);
      end
   end
   else
   begin
      if(VGD_cnt==0)
      begin
        outfile=$fopen(errFileName,"a");
        $strobe("nhvre         VGD     error limit ( %d ) reached at %7.4r  %M", maxEv, $abstime );
        $fwrite(outfile,"nhvre         VGD     error limit ( %d ) reached at %7.4r  %M\n", maxEv, $abstime );
        VGD_cnt=VGD_cnt-1;
        $fclose(outfile);
      end
   end

//      VDS
   VDS = V_D_S;
   if((VDS_cnt>0) || ( maxEv_flg==0 ))   begin
      if( (VDS < -1.5) && (VDS_retc!=-1))
      begin
        outfile=$fopen(errFileName,"a");
        $strobe("nhvre         VDS     leaving   OCA (  .. -1.500 V ) at %7.4r  %M", $abstime );
        $fwrite(outfile,"nhvre         VDS     leaving   OCA (  .. -1.500 V ) at %7.4r  %M\n", $abstime );
        VDS_retc=-1;
        VDS_cnt=VDS_cnt-1;
        $fclose(outfile);
      end
      if((VDS >= -1.5) &&  (VDS <= 100) && (VDS_retc!=0))
      begin
        outfile=$fopen(errFileName,"a");
        $strobe("nhvre         VDS     entering SOCA ( -1.500 V .. 100.000 V ) at %7.4r  %M", $abstime );
        $fwrite(outfile,"nhvre         VDS     entering SOCA ( -1.500 V .. 100.000 V ) at %7.4r  %M\n", $abstime );
        VDS_retc=0;
        VDS_cnt=VDS_cnt-1;
        $fclose(outfile);
      end
      if((VDS > 100) &&  (VDS_retc!=1))
      begin
        outfile=$fopen(errFileName,"a");
        $strobe("nhvre         VDS     leaving   OCA ( 100.000 V ..  ) at %7.4r  %M", $abstime );
        $fwrite(outfile,"nhvre         VDS     leaving   OCA ( 100.000 V ..  ) at %7.4r  %M\n", $abstime );
        VDS_retc=1;
        VDS_cnt=VDS_cnt-1;
        $fclose(outfile);
      end
   end
   else
   begin
      if(VDS_cnt==0)
      begin
        outfile=$fopen(errFileName,"a");
        $strobe("nhvre         VDS     error limit ( %d ) reached at %7.4r  %M", maxEv, $abstime );
        $fwrite(outfile,"nhvre         VDS     error limit ( %d ) reached at %7.4r  %M\n", maxEv, $abstime );
        VDS_cnt=VDS_cnt-1;
        $fclose(outfile);
      end
   end

//      VDB
   VDB = V_D_B;
   if((VDB_cnt>0) || ( maxEv_flg==0 ))   begin
      if( (VDB < -1.5) && (VDB_retc!=-1))
      begin
        outfile=$fopen(errFileName,"a");
        $strobe("nhvre         VDB     leaving   OCA (  .. -1.500 V ) at %7.4r  %M", $abstime );
        $fwrite(outfile,"nhvre         VDB     leaving   OCA (  .. -1.500 V ) at %7.4r  %M\n", $abstime );
        VDB_retc=-1;
        VDB_cnt=VDB_cnt-1;
        $fclose(outfile);
      end
      if((VDB >= -1.5) &&  (VDB <= 100) && (VDB_retc!=0))
      begin
        outfile=$fopen(errFileName,"a");
        $strobe("nhvre         VDB     entering SOCA ( -1.500 V .. 100.000 V ) at %7.4r  %M", $abstime );
        $fwrite(outfile,"nhvre         VDB     entering SOCA ( -1.500 V .. 100.000 V ) at %7.4r  %M\n", $abstime );
        VDB_retc=0;
        VDB_cnt=VDB_cnt-1;
        $fclose(outfile);
      end
      if((VDB > 100) &&  (VDB_retc!=1))
      begin
        outfile=$fopen(errFileName,"a");
        $strobe("nhvre         VDB     leaving   OCA ( 100.000 V ..  ) at %7.4r  %M", $abstime );
        $fwrite(outfile,"nhvre         VDB     leaving   OCA ( 100.000 V ..  ) at %7.4r  %M\n", $abstime );
        VDB_retc=1;
        VDB_cnt=VDB_cnt-1;
        $fclose(outfile);
      end
   end
   else
   begin
      if(VDB_cnt==0)
      begin
        outfile=$fopen(errFileName,"a");
        $strobe("nhvre         VDB     error limit ( %d ) reached at %7.4r  %M", maxEv, $abstime );
        $fwrite(outfile,"nhvre         VDB     error limit ( %d ) reached at %7.4r  %M\n", maxEv, $abstime );
        VDB_cnt=VDB_cnt-1;
        $fclose(outfile);
      end
   end

//      VDHW
   VDHW = V_D_HW;
   if((VDHW_cnt>0) || ( maxEv_flg==0 ))   begin
      if( (VDHW < -25) && (VDHW_retc!=-1))
      begin
        outfile=$fopen(errFileName,"a");
        $strobe("nhvre         VDHW    leaving   OCA (  .. -25.000 V ) at %7.4r  %M", $abstime );
        $fwrite(outfile,"nhvre         VDHW    leaving   OCA (  .. -25.000 V ) at %7.4r  %M\n", $abstime );
        VDHW_retc=-1;
        VDHW_cnt=VDHW_cnt-1;
        $fclose(outfile);
      end
      if((VDHW >= -25) &&  (VDHW <= 125) && (VDHW_retc!=0))
      begin
        outfile=$fopen(errFileName,"a");
        $strobe("nhvre         VDHW    entering SOCA ( -25.000 V .. 125.000 V ) at %7.4r  %M", $abstime );
        $fwrite(outfile,"nhvre         VDHW    entering SOCA ( -25.000 V .. 125.000 V ) at %7.4r  %M\n", $abstime );
        VDHW_retc=0;
        VDHW_cnt=VDHW_cnt-1;
        $fclose(outfile);
      end
      if((VDHW > 125) &&  (VDHW_retc!=1))
      begin
        outfile=$fopen(errFileName,"a");
        $strobe("nhvre         VDHW    leaving   OCA ( 125.000 V ..  ) at %7.4r  %M", $abstime );
        $fwrite(outfile,"nhvre         VDHW    leaving   OCA ( 125.000 V ..  ) at %7.4r  %M\n", $abstime );
        VDHW_retc=1;
        VDHW_cnt=VDHW_cnt-1;
        $fclose(outfile);
      end
   end
   else
   begin
      if(VDHW_cnt==0)
      begin
        outfile=$fopen(errFileName,"a");
        $strobe("nhvre         VDHW    error limit ( %d ) reached at %7.4r  %M", maxEv, $abstime );
        $fwrite(outfile,"nhvre         VDHW    error limit ( %d ) reached at %7.4r  %M\n", maxEv, $abstime );
        VDHW_cnt=VDHW_cnt-1;
        $fclose(outfile);
      end
   end

end // analog
endmodule // nhvre

// Verilog-A OC Watch for device nhvrf Parameters  VGS VGD VDS VDB VDHW
module nhvrf_ahdl(D,G,S,B,HW);
parameter tstep_occ=100n;
parameter errFileName="./occ.err";
parameter maxEv = 25;
parameter maxEv_flg = 0;
inout D,G,S,B,HW;
electrical D,G,S,B,HW;

integer outfile;
real V_D_HW;
real V_D_B;
real V_D_S;
real V_G_D;
real V_G_S;
real VGS;
integer VGS_retc;
integer VGS_cnt;
real VGD;
integer VGD_retc;
integer VGD_cnt;
real VDS;
integer VDS_retc;
integer VDS_cnt;
real VDB;
integer VDB_retc;
integer VDB_cnt;
real VDHW;
integer VDHW_retc;
integer VDHW_cnt;

analog begin
   $bound_step( tstep_occ );
   @(initial_step) begin
      VGS_retc=0;
      VGS_cnt = maxEv;
      VGD_retc=0;
      VGD_cnt = maxEv;
      VDS_retc=0;
      VDS_cnt = maxEv;
      VDB_retc=0;
      VDB_cnt = maxEv;
      VDHW_retc=0;
      VDHW_cnt = maxEv;
   end
   V_D_HW = V(D,HW);
   V_D_B = V(D,B);
   V_D_S = V(D,S);
   V_G_D = V(G,D);
   V_G_S = V(G,S);

//      VGS
   VGS = V_G_S;
   if((VGS_cnt>0) || ( maxEv_flg==0 ))   begin
      if( (VGS < -5.5) && (VGS_retc!=-1))
      begin
        outfile=$fopen(errFileName,"a");
        $strobe("nhvrf         VGS     leaving   OCA (  .. -5.500 V ) at %7.4r  %M", $abstime );
        $fwrite(outfile,"nhvrf         VGS     leaving   OCA (  .. -5.500 V ) at %7.4r  %M\n", $abstime );
        VGS_retc=-1;
        VGS_cnt=VGS_cnt-1;
        $fclose(outfile);
      end
      if((VGS >= -5.5) &&  (VGS <= 5.5) && (VGS_retc!=0))
      begin
        outfile=$fopen(errFileName,"a");
        $strobe("nhvrf         VGS     entering SOCA ( -5.500 V .. 5.500 V ) at %7.4r  %M", $abstime );
        $fwrite(outfile,"nhvrf         VGS     entering SOCA ( -5.500 V .. 5.500 V ) at %7.4r  %M\n", $abstime );
        VGS_retc=0;
        VGS_cnt=VGS_cnt-1;
        $fclose(outfile);
      end
      if((VGS > 5.5) &&  (VGS_retc!=1))
      begin
        outfile=$fopen(errFileName,"a");
        $strobe("nhvrf         VGS     leaving   OCA ( 5.500 V ..  ) at %7.4r  %M", $abstime );
        $fwrite(outfile,"nhvrf         VGS     leaving   OCA ( 5.500 V ..  ) at %7.4r  %M\n", $abstime );
        VGS_retc=1;
        VGS_cnt=VGS_cnt-1;
        $fclose(outfile);
      end
   end
   else
   begin
      if(VGS_cnt==0)
      begin
        outfile=$fopen(errFileName,"a");
        $strobe("nhvrf         VGS     error limit ( %d ) reached at %7.4r  %M", maxEv, $abstime );
        $fwrite(outfile,"nhvrf         VGS     error limit ( %d ) reached at %7.4r  %M\n", maxEv, $abstime );
        VGS_cnt=VGS_cnt-1;
        $fclose(outfile);
      end
   end

//      VGD
   VGD = V_G_D;
   if((VGD_cnt>0) || ( maxEv_flg==0 ))   begin
      if( (VGD < -125) && (VGD_retc!=-1))
      begin
        outfile=$fopen(errFileName,"a");
        $strobe("nhvrf         VGD     leaving   OCA (  .. -125.000 V ) at %7.4r  %M", $abstime );
        $fwrite(outfile,"nhvrf         VGD     leaving   OCA (  .. -125.000 V ) at %7.4r  %M\n", $abstime );
        VGD_retc=-1;
        VGD_cnt=VGD_cnt-1;
        $fclose(outfile);
      end
      if((VGD >= -125) &&  (VGD <= 5.5) && (VGD_retc!=0))
      begin
        outfile=$fopen(errFileName,"a");
        $strobe("nhvrf         VGD     entering SOCA ( -125.000 V .. 5.500 V ) at %7.4r  %M", $abstime );
        $fwrite(outfile,"nhvrf         VGD     entering SOCA ( -125.000 V .. 5.500 V ) at %7.4r  %M\n", $abstime );
        VGD_retc=0;
        VGD_cnt=VGD_cnt-1;
        $fclose(outfile);
      end
      if((VGD > 5.5) &&  (VGD_retc!=1))
      begin
        outfile=$fopen(errFileName,"a");
        $strobe("nhvrf         VGD     leaving   OCA ( 5.500 V ..  ) at %7.4r  %M", $abstime );
        $fwrite(outfile,"nhvrf         VGD     leaving   OCA ( 5.500 V ..  ) at %7.4r  %M\n", $abstime );
        VGD_retc=1;
        VGD_cnt=VGD_cnt-1;
        $fclose(outfile);
      end
   end
   else
   begin
      if(VGD_cnt==0)
      begin
        outfile=$fopen(errFileName,"a");
        $strobe("nhvrf         VGD     error limit ( %d ) reached at %7.4r  %M", maxEv, $abstime );
        $fwrite(outfile,"nhvrf         VGD     error limit ( %d ) reached at %7.4r  %M\n", maxEv, $abstime );
        VGD_cnt=VGD_cnt-1;
        $fclose(outfile);
      end
   end

//      VDS
   VDS = V_D_S;
   if((VDS_cnt>0) || ( maxEv_flg==0 ))   begin
      if( (VDS < -1.5) && (VDS_retc!=-1))
      begin
        outfile=$fopen(errFileName,"a");
        $strobe("nhvrf         VDS     leaving   OCA (  .. -1.500 V ) at %7.4r  %M", $abstime );
        $fwrite(outfile,"nhvrf         VDS     leaving   OCA (  .. -1.500 V ) at %7.4r  %M\n", $abstime );
        VDS_retc=-1;
        VDS_cnt=VDS_cnt-1;
        $fclose(outfile);
      end
      if((VDS >= -1.5) &&  (VDS <= 125) && (VDS_retc!=0))
      begin
        outfile=$fopen(errFileName,"a");
        $strobe("nhvrf         VDS     entering SOCA ( -1.500 V .. 125.000 V ) at %7.4r  %M", $abstime );
        $fwrite(outfile,"nhvrf         VDS     entering SOCA ( -1.500 V .. 125.000 V ) at %7.4r  %M\n", $abstime );
        VDS_retc=0;
        VDS_cnt=VDS_cnt-1;
        $fclose(outfile);
      end
      if((VDS > 125) &&  (VDS_retc!=1))
      begin
        outfile=$fopen(errFileName,"a");
        $strobe("nhvrf         VDS     leaving   OCA ( 125.000 V ..  ) at %7.4r  %M", $abstime );
        $fwrite(outfile,"nhvrf         VDS     leaving   OCA ( 125.000 V ..  ) at %7.4r  %M\n", $abstime );
        VDS_retc=1;
        VDS_cnt=VDS_cnt-1;
        $fclose(outfile);
      end
   end
   else
   begin
      if(VDS_cnt==0)
      begin
        outfile=$fopen(errFileName,"a");
        $strobe("nhvrf         VDS     error limit ( %d ) reached at %7.4r  %M", maxEv, $abstime );
        $fwrite(outfile,"nhvrf         VDS     error limit ( %d ) reached at %7.4r  %M\n", maxEv, $abstime );
        VDS_cnt=VDS_cnt-1;
        $fclose(outfile);
      end
   end

//      VDB
   VDB = V_D_B;
   if((VDB_cnt>0) || ( maxEv_flg==0 ))   begin
      if( (VDB < -1.5) && (VDB_retc!=-1))
      begin
        outfile=$fopen(errFileName,"a");
        $strobe("nhvrf         VDB     leaving   OCA (  .. -1.500 V ) at %7.4r  %M", $abstime );
        $fwrite(outfile,"nhvrf         VDB     leaving   OCA (  .. -1.500 V ) at %7.4r  %M\n", $abstime );
        VDB_retc=-1;
        VDB_cnt=VDB_cnt-1;
        $fclose(outfile);
      end
      if((VDB >= -1.5) &&  (VDB <= 125) && (VDB_retc!=0))
      begin
        outfile=$fopen(errFileName,"a");
        $strobe("nhvrf         VDB     entering SOCA ( -1.500 V .. 125.000 V ) at %7.4r  %M", $abstime );
        $fwrite(outfile,"nhvrf         VDB     entering SOCA ( -1.500 V .. 125.000 V ) at %7.4r  %M\n", $abstime );
        VDB_retc=0;
        VDB_cnt=VDB_cnt-1;
        $fclose(outfile);
      end
      if((VDB > 125) &&  (VDB_retc!=1))
      begin
        outfile=$fopen(errFileName,"a");
        $strobe("nhvrf         VDB     leaving   OCA ( 125.000 V ..  ) at %7.4r  %M", $abstime );
        $fwrite(outfile,"nhvrf         VDB     leaving   OCA ( 125.000 V ..  ) at %7.4r  %M\n", $abstime );
        VDB_retc=1;
        VDB_cnt=VDB_cnt-1;
        $fclose(outfile);
      end
   end
   else
   begin
      if(VDB_cnt==0)
      begin
        outfile=$fopen(errFileName,"a");
        $strobe("nhvrf         VDB     error limit ( %d ) reached at %7.4r  %M", maxEv, $abstime );
        $fwrite(outfile,"nhvrf         VDB     error limit ( %d ) reached at %7.4r  %M\n", maxEv, $abstime );
        VDB_cnt=VDB_cnt-1;
        $fclose(outfile);
      end
   end

//      VDHW
   VDHW = V_D_HW;
   if((VDHW_cnt>0) || ( maxEv_flg==0 ))   begin
      if( (VDHW < -25) && (VDHW_retc!=-1))
      begin
        outfile=$fopen(errFileName,"a");
        $strobe("nhvrf         VDHW    leaving   OCA (  .. -25.000 V ) at %7.4r  %M", $abstime );
        $fwrite(outfile,"nhvrf         VDHW    leaving   OCA (  .. -25.000 V ) at %7.4r  %M\n", $abstime );
        VDHW_retc=-1;
        VDHW_cnt=VDHW_cnt-1;
        $fclose(outfile);
      end
      if((VDHW >= -25) &&  (VDHW <= 125) && (VDHW_retc!=0))
      begin
        outfile=$fopen(errFileName,"a");
        $strobe("nhvrf         VDHW    entering SOCA ( -25.000 V .. 125.000 V ) at %7.4r  %M", $abstime );
        $fwrite(outfile,"nhvrf         VDHW    entering SOCA ( -25.000 V .. 125.000 V ) at %7.4r  %M\n", $abstime );
        VDHW_retc=0;
        VDHW_cnt=VDHW_cnt-1;
        $fclose(outfile);
      end
      if((VDHW > 125) &&  (VDHW_retc!=1))
      begin
        outfile=$fopen(errFileName,"a");
        $strobe("nhvrf         VDHW    leaving   OCA ( 125.000 V ..  ) at %7.4r  %M", $abstime );
        $fwrite(outfile,"nhvrf         VDHW    leaving   OCA ( 125.000 V ..  ) at %7.4r  %M\n", $abstime );
        VDHW_retc=1;
        VDHW_cnt=VDHW_cnt-1;
        $fclose(outfile);
      end
   end
   else
   begin
      if(VDHW_cnt==0)
      begin
        outfile=$fopen(errFileName,"a");
        $strobe("nhvrf         VDHW    error limit ( %d ) reached at %7.4r  %M", maxEv, $abstime );
        $fwrite(outfile,"nhvrf         VDHW    error limit ( %d ) reached at %7.4r  %M\n", maxEv, $abstime );
        VDHW_cnt=VDHW_cnt-1;
        $fclose(outfile);
      end
   end

end // analog
endmodule // nhvrf

// Verilog-A OC Watch for device ndhvrd Parameters  VGS VGD VDS VDB VDHW
module ndhvrd_ahdl(D,G,S,B,HW);
parameter tstep_occ=100n;
parameter errFileName="./occ.err";
parameter maxEv = 25;
parameter maxEv_flg = 0;
inout D,G,S,B,HW;
electrical D,G,S,B,HW;

integer outfile;
real V_D_HW;
real V_D_B;
real V_D_S;
real V_G_D;
real V_G_S;
real VGS;
integer VGS_retc;
integer VGS_cnt;
real VGD;
integer VGD_retc;
integer VGD_cnt;
real VDS;
integer VDS_retc;
integer VDS_cnt;
real VDB;
integer VDB_retc;
integer VDB_cnt;
real VDHW;
integer VDHW_retc;
integer VDHW_cnt;

analog begin
   $bound_step( tstep_occ );
   @(initial_step) begin
      VGS_retc=0;
      VGS_cnt = maxEv;
      VGD_retc=0;
      VGD_cnt = maxEv;
      VDS_retc=0;
      VDS_cnt = maxEv;
      VDB_retc=0;
      VDB_cnt = maxEv;
      VDHW_retc=0;
      VDHW_cnt = maxEv;
   end
   V_D_HW = V(D,HW);
   V_D_B = V(D,B);
   V_D_S = V(D,S);
   V_G_D = V(G,D);
   V_G_S = V(G,S);

//      VGS
   VGS = V_G_S;
   if((VGS_cnt>0) || ( maxEv_flg==0 ))   begin
      if( (VGS < -5.5) && (VGS_retc!=-1))
      begin
        outfile=$fopen(errFileName,"a");
        $strobe("ndhvrd        VGS     leaving   OCA (  .. -5.500 V ) at %7.4r  %M", $abstime );
        $fwrite(outfile,"ndhvrd        VGS     leaving   OCA (  .. -5.500 V ) at %7.4r  %M\n", $abstime );
        VGS_retc=-1;
        VGS_cnt=VGS_cnt-1;
        $fclose(outfile);
      end
      if((VGS >= -5.5) &&  (VGS <= 5.5) && (VGS_retc!=0))
      begin
        outfile=$fopen(errFileName,"a");
        $strobe("ndhvrd        VGS     entering SOCA ( -5.500 V .. 5.500 V ) at %7.4r  %M", $abstime );
        $fwrite(outfile,"ndhvrd        VGS     entering SOCA ( -5.500 V .. 5.500 V ) at %7.4r  %M\n", $abstime );
        VGS_retc=0;
        VGS_cnt=VGS_cnt-1;
        $fclose(outfile);
      end
      if((VGS > 5.5) &&  (VGS_retc!=1))
      begin
        outfile=$fopen(errFileName,"a");
        $strobe("ndhvrd        VGS     leaving   OCA ( 5.500 V ..  ) at %7.4r  %M", $abstime );
        $fwrite(outfile,"ndhvrd        VGS     leaving   OCA ( 5.500 V ..  ) at %7.4r  %M\n", $abstime );
        VGS_retc=1;
        VGS_cnt=VGS_cnt-1;
        $fclose(outfile);
      end
   end
   else
   begin
      if(VGS_cnt==0)
      begin
        outfile=$fopen(errFileName,"a");
        $strobe("ndhvrd        VGS     error limit ( %d ) reached at %7.4r  %M", maxEv, $abstime );
        $fwrite(outfile,"ndhvrd        VGS     error limit ( %d ) reached at %7.4r  %M\n", maxEv, $abstime );
        VGS_cnt=VGS_cnt-1;
        $fclose(outfile);
      end
   end

//      VGD
   VGD = V_G_D;
   if((VGD_cnt>0) || ( maxEv_flg==0 ))   begin
      if( (VGD < -85) && (VGD_retc!=-1))
      begin
        outfile=$fopen(errFileName,"a");
        $strobe("ndhvrd        VGD     leaving   OCA (  .. -85.000 V ) at %7.4r  %M", $abstime );
        $fwrite(outfile,"ndhvrd        VGD     leaving   OCA (  .. -85.000 V ) at %7.4r  %M\n", $abstime );
        VGD_retc=-1;
        VGD_cnt=VGD_cnt-1;
        $fclose(outfile);
      end
      if((VGD >= -85) &&  (VGD <= 5.5) && (VGD_retc!=0))
      begin
        outfile=$fopen(errFileName,"a");
        $strobe("ndhvrd        VGD     entering SOCA ( -85.000 V .. 5.500 V ) at %7.4r  %M", $abstime );
        $fwrite(outfile,"ndhvrd        VGD     entering SOCA ( -85.000 V .. 5.500 V ) at %7.4r  %M\n", $abstime );
        VGD_retc=0;
        VGD_cnt=VGD_cnt-1;
        $fclose(outfile);
      end
      if((VGD > 5.5) &&  (VGD_retc!=1))
      begin
        outfile=$fopen(errFileName,"a");
        $strobe("ndhvrd        VGD     leaving   OCA ( 5.500 V ..  ) at %7.4r  %M", $abstime );
        $fwrite(outfile,"ndhvrd        VGD     leaving   OCA ( 5.500 V ..  ) at %7.4r  %M\n", $abstime );
        VGD_retc=1;
        VGD_cnt=VGD_cnt-1;
        $fclose(outfile);
      end
   end
   else
   begin
      if(VGD_cnt==0)
      begin
        outfile=$fopen(errFileName,"a");
        $strobe("ndhvrd        VGD     error limit ( %d ) reached at %7.4r  %M", maxEv, $abstime );
        $fwrite(outfile,"ndhvrd        VGD     error limit ( %d ) reached at %7.4r  %M\n", maxEv, $abstime );
        VGD_cnt=VGD_cnt-1;
        $fclose(outfile);
      end
   end

//      VDS
   VDS = V_D_S;
   if((VDS_cnt>0) || ( maxEv_flg==0 ))   begin
      if( (VDS < -0.1) && (VDS_retc!=-1))
      begin
        outfile=$fopen(errFileName,"a");
        $strobe("ndhvrd        VDS     leaving   OCA (  .. -0.100 V ) at %7.4r  %M", $abstime );
        $fwrite(outfile,"ndhvrd        VDS     leaving   OCA (  .. -0.100 V ) at %7.4r  %M\n", $abstime );
        VDS_retc=-1;
        VDS_cnt=VDS_cnt-1;
        $fclose(outfile);
      end
      if((VDS >= -0.1) &&  (VDS <= 85) && (VDS_retc!=0))
      begin
        outfile=$fopen(errFileName,"a");
        $strobe("ndhvrd        VDS     entering SOCA ( -0.100 V .. 85.000 V ) at %7.4r  %M", $abstime );
        $fwrite(outfile,"ndhvrd        VDS     entering SOCA ( -0.100 V .. 85.000 V ) at %7.4r  %M\n", $abstime );
        VDS_retc=0;
        VDS_cnt=VDS_cnt-1;
        $fclose(outfile);
      end
      if((VDS > 85) &&  (VDS_retc!=1))
      begin
        outfile=$fopen(errFileName,"a");
        $strobe("ndhvrd        VDS     leaving   OCA ( 85.000 V ..  ) at %7.4r  %M", $abstime );
        $fwrite(outfile,"ndhvrd        VDS     leaving   OCA ( 85.000 V ..  ) at %7.4r  %M\n", $abstime );
        VDS_retc=1;
        VDS_cnt=VDS_cnt-1;
        $fclose(outfile);
      end
   end
   else
   begin
      if(VDS_cnt==0)
      begin
        outfile=$fopen(errFileName,"a");
        $strobe("ndhvrd        VDS     error limit ( %d ) reached at %7.4r  %M", maxEv, $abstime );
        $fwrite(outfile,"ndhvrd        VDS     error limit ( %d ) reached at %7.4r  %M\n", maxEv, $abstime );
        VDS_cnt=VDS_cnt-1;
        $fclose(outfile);
      end
   end

//      VDB
   VDB = V_D_B;
   if((VDB_cnt>0) || ( maxEv_flg==0 ))   begin
      if( (VDB < -0.1) && (VDB_retc!=-1))
      begin
        outfile=$fopen(errFileName,"a");
        $strobe("ndhvrd        VDB     leaving   OCA (  .. -0.100 V ) at %7.4r  %M", $abstime );
        $fwrite(outfile,"ndhvrd        VDB     leaving   OCA (  .. -0.100 V ) at %7.4r  %M\n", $abstime );
        VDB_retc=-1;
        VDB_cnt=VDB_cnt-1;
        $fclose(outfile);
      end
      if((VDB >= -0.1) &&  (VDB <= 85) && (VDB_retc!=0))
      begin
        outfile=$fopen(errFileName,"a");
        $strobe("ndhvrd        VDB     entering SOCA ( -0.100 V .. 85.000 V ) at %7.4r  %M", $abstime );
        $fwrite(outfile,"ndhvrd        VDB     entering SOCA ( -0.100 V .. 85.000 V ) at %7.4r  %M\n", $abstime );
        VDB_retc=0;
        VDB_cnt=VDB_cnt-1;
        $fclose(outfile);
      end
      if((VDB > 85) &&  (VDB_retc!=1))
      begin
        outfile=$fopen(errFileName,"a");
        $strobe("ndhvrd        VDB     leaving   OCA ( 85.000 V ..  ) at %7.4r  %M", $abstime );
        $fwrite(outfile,"ndhvrd        VDB     leaving   OCA ( 85.000 V ..  ) at %7.4r  %M\n", $abstime );
        VDB_retc=1;
        VDB_cnt=VDB_cnt-1;
        $fclose(outfile);
      end
   end
   else
   begin
      if(VDB_cnt==0)
      begin
        outfile=$fopen(errFileName,"a");
        $strobe("ndhvrd        VDB     error limit ( %d ) reached at %7.4r  %M", maxEv, $abstime );
        $fwrite(outfile,"ndhvrd        VDB     error limit ( %d ) reached at %7.4r  %M\n", maxEv, $abstime );
        VDB_cnt=VDB_cnt-1;
        $fclose(outfile);
      end
   end

//      VDHW
   VDHW = V_D_HW;
   if((VDHW_cnt>0) || ( maxEv_flg==0 ))   begin
      if( (VDHW < -25) && (VDHW_retc!=-1))
      begin
        outfile=$fopen(errFileName,"a");
        $strobe("ndhvrd        VDHW    leaving   OCA (  .. -25.000 V ) at %7.4r  %M", $abstime );
        $fwrite(outfile,"ndhvrd        VDHW    leaving   OCA (  .. -25.000 V ) at %7.4r  %M\n", $abstime );
        VDHW_retc=-1;
        VDHW_cnt=VDHW_cnt-1;
        $fclose(outfile);
      end
      if((VDHW >= -25) &&  (VDHW <= 125) && (VDHW_retc!=0))
      begin
        outfile=$fopen(errFileName,"a");
        $strobe("ndhvrd        VDHW    entering SOCA ( -25.000 V .. 125.000 V ) at %7.4r  %M", $abstime );
        $fwrite(outfile,"ndhvrd        VDHW    entering SOCA ( -25.000 V .. 125.000 V ) at %7.4r  %M\n", $abstime );
        VDHW_retc=0;
        VDHW_cnt=VDHW_cnt-1;
        $fclose(outfile);
      end
      if((VDHW > 125) &&  (VDHW_retc!=1))
      begin
        outfile=$fopen(errFileName,"a");
        $strobe("ndhvrd        VDHW    leaving   OCA ( 125.000 V ..  ) at %7.4r  %M", $abstime );
        $fwrite(outfile,"ndhvrd        VDHW    leaving   OCA ( 125.000 V ..  ) at %7.4r  %M\n", $abstime );
        VDHW_retc=1;
        VDHW_cnt=VDHW_cnt-1;
        $fclose(outfile);
      end
   end
   else
   begin
      if(VDHW_cnt==0)
      begin
        outfile=$fopen(errFileName,"a");
        $strobe("ndhvrd        VDHW    error limit ( %d ) reached at %7.4r  %M", maxEv, $abstime );
        $fwrite(outfile,"ndhvrd        VDHW    error limit ( %d ) reached at %7.4r  %M\n", maxEv, $abstime );
        VDHW_cnt=VDHW_cnt-1;
        $fclose(outfile);
      end
   end

end // analog
endmodule // ndhvrd

// Verilog-A OC Watch for device ndhvrf Parameters  VGS VGD VDS VDB VDHW
module ndhvrf_ahdl(D,G,S,B,HW);
parameter tstep_occ=100n;
parameter errFileName="./occ.err";
parameter maxEv = 25;
parameter maxEv_flg = 0;
inout D,G,S,B,HW;
electrical D,G,S,B,HW;

integer outfile;
real V_D_HW;
real V_D_B;
real V_D_S;
real V_G_D;
real V_G_S;
real VGS;
integer VGS_retc;
integer VGS_cnt;
real VGD;
integer VGD_retc;
integer VGD_cnt;
real VDS;
integer VDS_retc;
integer VDS_cnt;
real VDB;
integer VDB_retc;
integer VDB_cnt;
real VDHW;
integer VDHW_retc;
integer VDHW_cnt;

analog begin
   $bound_step( tstep_occ );
   @(initial_step) begin
      VGS_retc=0;
      VGS_cnt = maxEv;
      VGD_retc=0;
      VGD_cnt = maxEv;
      VDS_retc=0;
      VDS_cnt = maxEv;
      VDB_retc=0;
      VDB_cnt = maxEv;
      VDHW_retc=0;
      VDHW_cnt = maxEv;
   end
   V_D_HW = V(D,HW);
   V_D_B = V(D,B);
   V_D_S = V(D,S);
   V_G_D = V(G,D);
   V_G_S = V(G,S);

//      VGS
   VGS = V_G_S;
   if((VGS_cnt>0) || ( maxEv_flg==0 ))   begin
      if( (VGS < -5.5) && (VGS_retc!=-1))
      begin
        outfile=$fopen(errFileName,"a");
        $strobe("ndhvrf        VGS     leaving   OCA (  .. -5.500 V ) at %7.4r  %M", $abstime );
        $fwrite(outfile,"ndhvrf        VGS     leaving   OCA (  .. -5.500 V ) at %7.4r  %M\n", $abstime );
        VGS_retc=-1;
        VGS_cnt=VGS_cnt-1;
        $fclose(outfile);
      end
      if((VGS >= -5.5) &&  (VGS <= 5.5) && (VGS_retc!=0))
      begin
        outfile=$fopen(errFileName,"a");
        $strobe("ndhvrf        VGS     entering SOCA ( -5.500 V .. 5.500 V ) at %7.4r  %M", $abstime );
        $fwrite(outfile,"ndhvrf        VGS     entering SOCA ( -5.500 V .. 5.500 V ) at %7.4r  %M\n", $abstime );
        VGS_retc=0;
        VGS_cnt=VGS_cnt-1;
        $fclose(outfile);
      end
      if((VGS > 5.5) &&  (VGS_retc!=1))
      begin
        outfile=$fopen(errFileName,"a");
        $strobe("ndhvrf        VGS     leaving   OCA ( 5.500 V ..  ) at %7.4r  %M", $abstime );
        $fwrite(outfile,"ndhvrf        VGS     leaving   OCA ( 5.500 V ..  ) at %7.4r  %M\n", $abstime );
        VGS_retc=1;
        VGS_cnt=VGS_cnt-1;
        $fclose(outfile);
      end
   end
   else
   begin
      if(VGS_cnt==0)
      begin
        outfile=$fopen(errFileName,"a");
        $strobe("ndhvrf        VGS     error limit ( %d ) reached at %7.4r  %M", maxEv, $abstime );
        $fwrite(outfile,"ndhvrf        VGS     error limit ( %d ) reached at %7.4r  %M\n", maxEv, $abstime );
        VGS_cnt=VGS_cnt-1;
        $fclose(outfile);
      end
   end

//      VGD
   VGD = V_G_D;
   if((VGD_cnt>0) || ( maxEv_flg==0 ))   begin
      if( (VGD < -125) && (VGD_retc!=-1))
      begin
        outfile=$fopen(errFileName,"a");
        $strobe("ndhvrf        VGD     leaving   OCA (  .. -125.000 V ) at %7.4r  %M", $abstime );
        $fwrite(outfile,"ndhvrf        VGD     leaving   OCA (  .. -125.000 V ) at %7.4r  %M\n", $abstime );
        VGD_retc=-1;
        VGD_cnt=VGD_cnt-1;
        $fclose(outfile);
      end
      if((VGD >= -125) &&  (VGD <= 5.5) && (VGD_retc!=0))
      begin
        outfile=$fopen(errFileName,"a");
        $strobe("ndhvrf        VGD     entering SOCA ( -125.000 V .. 5.500 V ) at %7.4r  %M", $abstime );
        $fwrite(outfile,"ndhvrf        VGD     entering SOCA ( -125.000 V .. 5.500 V ) at %7.4r  %M\n", $abstime );
        VGD_retc=0;
        VGD_cnt=VGD_cnt-1;
        $fclose(outfile);
      end
      if((VGD > 5.5) &&  (VGD_retc!=1))
      begin
        outfile=$fopen(errFileName,"a");
        $strobe("ndhvrf        VGD     leaving   OCA ( 5.500 V ..  ) at %7.4r  %M", $abstime );
        $fwrite(outfile,"ndhvrf        VGD     leaving   OCA ( 5.500 V ..  ) at %7.4r  %M\n", $abstime );
        VGD_retc=1;
        VGD_cnt=VGD_cnt-1;
        $fclose(outfile);
      end
   end
   else
   begin
      if(VGD_cnt==0)
      begin
        outfile=$fopen(errFileName,"a");
        $strobe("ndhvrf        VGD     error limit ( %d ) reached at %7.4r  %M", maxEv, $abstime );
        $fwrite(outfile,"ndhvrf        VGD     error limit ( %d ) reached at %7.4r  %M\n", maxEv, $abstime );
        VGD_cnt=VGD_cnt-1;
        $fclose(outfile);
      end
   end

//      VDS
   VDS = V_D_S;
   if((VDS_cnt>0) || ( maxEv_flg==0 ))   begin
      if( (VDS < -0.1) && (VDS_retc!=-1))
      begin
        outfile=$fopen(errFileName,"a");
        $strobe("ndhvrf        VDS     leaving   OCA (  .. -0.100 V ) at %7.4r  %M", $abstime );
        $fwrite(outfile,"ndhvrf        VDS     leaving   OCA (  .. -0.100 V ) at %7.4r  %M\n", $abstime );
        VDS_retc=-1;
        VDS_cnt=VDS_cnt-1;
        $fclose(outfile);
      end
      if((VDS >= -0.1) &&  (VDS <= 125) && (VDS_retc!=0))
      begin
        outfile=$fopen(errFileName,"a");
        $strobe("ndhvrf        VDS     entering SOCA ( -0.100 V .. 125.000 V ) at %7.4r  %M", $abstime );
        $fwrite(outfile,"ndhvrf        VDS     entering SOCA ( -0.100 V .. 125.000 V ) at %7.4r  %M\n", $abstime );
        VDS_retc=0;
        VDS_cnt=VDS_cnt-1;
        $fclose(outfile);
      end
      if((VDS > 125) &&  (VDS_retc!=1))
      begin
        outfile=$fopen(errFileName,"a");
        $strobe("ndhvrf        VDS     leaving   OCA ( 125.000 V ..  ) at %7.4r  %M", $abstime );
        $fwrite(outfile,"ndhvrf        VDS     leaving   OCA ( 125.000 V ..  ) at %7.4r  %M\n", $abstime );
        VDS_retc=1;
        VDS_cnt=VDS_cnt-1;
        $fclose(outfile);
      end
   end
   else
   begin
      if(VDS_cnt==0)
      begin
        outfile=$fopen(errFileName,"a");
        $strobe("ndhvrf        VDS     error limit ( %d ) reached at %7.4r  %M", maxEv, $abstime );
        $fwrite(outfile,"ndhvrf        VDS     error limit ( %d ) reached at %7.4r  %M\n", maxEv, $abstime );
        VDS_cnt=VDS_cnt-1;
        $fclose(outfile);
      end
   end

//      VDB
   VDB = V_D_B;
   if((VDB_cnt>0) || ( maxEv_flg==0 ))   begin
      if( (VDB < -0.1) && (VDB_retc!=-1))
      begin
        outfile=$fopen(errFileName,"a");
        $strobe("ndhvrf        VDB     leaving   OCA (  .. -0.100 V ) at %7.4r  %M", $abstime );
        $fwrite(outfile,"ndhvrf        VDB     leaving   OCA (  .. -0.100 V ) at %7.4r  %M\n", $abstime );
        VDB_retc=-1;
        VDB_cnt=VDB_cnt-1;
        $fclose(outfile);
      end
      if((VDB >= -0.1) &&  (VDB <= 125) && (VDB_retc!=0))
      begin
        outfile=$fopen(errFileName,"a");
        $strobe("ndhvrf        VDB     entering SOCA ( -0.100 V .. 125.000 V ) at %7.4r  %M", $abstime );
        $fwrite(outfile,"ndhvrf        VDB     entering SOCA ( -0.100 V .. 125.000 V ) at %7.4r  %M\n", $abstime );
        VDB_retc=0;
        VDB_cnt=VDB_cnt-1;
        $fclose(outfile);
      end
      if((VDB > 125) &&  (VDB_retc!=1))
      begin
        outfile=$fopen(errFileName,"a");
        $strobe("ndhvrf        VDB     leaving   OCA ( 125.000 V ..  ) at %7.4r  %M", $abstime );
        $fwrite(outfile,"ndhvrf        VDB     leaving   OCA ( 125.000 V ..  ) at %7.4r  %M\n", $abstime );
        VDB_retc=1;
        VDB_cnt=VDB_cnt-1;
        $fclose(outfile);
      end
   end
   else
   begin
      if(VDB_cnt==0)
      begin
        outfile=$fopen(errFileName,"a");
        $strobe("ndhvrf        VDB     error limit ( %d ) reached at %7.4r  %M", maxEv, $abstime );
        $fwrite(outfile,"ndhvrf        VDB     error limit ( %d ) reached at %7.4r  %M\n", maxEv, $abstime );
        VDB_cnt=VDB_cnt-1;
        $fclose(outfile);
      end
   end

//      VDHW
   VDHW = V_D_HW;
   if((VDHW_cnt>0) || ( maxEv_flg==0 ))   begin
      if( (VDHW < -25) && (VDHW_retc!=-1))
      begin
        outfile=$fopen(errFileName,"a");
        $strobe("ndhvrf        VDHW    leaving   OCA (  .. -25.000 V ) at %7.4r  %M", $abstime );
        $fwrite(outfile,"ndhvrf        VDHW    leaving   OCA (  .. -25.000 V ) at %7.4r  %M\n", $abstime );
        VDHW_retc=-1;
        VDHW_cnt=VDHW_cnt-1;
        $fclose(outfile);
      end
      if((VDHW >= -25) &&  (VDHW <= 125) && (VDHW_retc!=0))
      begin
        outfile=$fopen(errFileName,"a");
        $strobe("ndhvrf        VDHW    entering SOCA ( -25.000 V .. 125.000 V ) at %7.4r  %M", $abstime );
        $fwrite(outfile,"ndhvrf        VDHW    entering SOCA ( -25.000 V .. 125.000 V ) at %7.4r  %M\n", $abstime );
        VDHW_retc=0;
        VDHW_cnt=VDHW_cnt-1;
        $fclose(outfile);
      end
      if((VDHW > 125) &&  (VDHW_retc!=1))
      begin
        outfile=$fopen(errFileName,"a");
        $strobe("ndhvrf        VDHW    leaving   OCA ( 125.000 V ..  ) at %7.4r  %M", $abstime );
        $fwrite(outfile,"ndhvrf        VDHW    leaving   OCA ( 125.000 V ..  ) at %7.4r  %M\n", $abstime );
        VDHW_retc=1;
        VDHW_cnt=VDHW_cnt-1;
        $fclose(outfile);
      end
   end
   else
   begin
      if(VDHW_cnt==0)
      begin
        outfile=$fopen(errFileName,"a");
        $strobe("ndhvrf        VDHW    error limit ( %d ) reached at %7.4r  %M", maxEv, $abstime );
        $fwrite(outfile,"ndhvrf        VDHW    error limit ( %d ) reached at %7.4r  %M\n", maxEv, $abstime );
        VDHW_cnt=VDHW_cnt-1;
        $fclose(outfile);
      end
   end

end // analog
endmodule // ndhvrf

// Verilog-A OC Watch for device phvra Parameters  VGS VGD VDS VDB VDHW VBHW
module phvra_ahdl(D,G,S,B,HW);
parameter tstep_occ=100n;
parameter errFileName="./occ.err";
parameter maxEv = 25;
parameter maxEv_flg = 0;
inout D,G,S,B,HW;
electrical D,G,S,B,HW;

integer outfile;
real V_B_HW;
real V_D_HW;
real V_D_B;
real V_D_S;
real V_G_D;
real V_G_S;
real VGS;
integer VGS_retc;
integer VGS_cnt;
real VGD;
integer VGD_retc;
integer VGD_cnt;
real VDS;
integer VDS_retc;
integer VDS_cnt;
real VDB;
integer VDB_retc;
integer VDB_cnt;
real VDHW;
integer VDHW_retc;
integer VDHW_cnt;
real VBHW;
integer VBHW_retc;
integer VBHW_cnt;

analog begin
   $bound_step( tstep_occ );
   @(initial_step) begin
      VGS_retc=0;
      VGS_cnt = maxEv;
      VGD_retc=0;
      VGD_cnt = maxEv;
      VDS_retc=0;
      VDS_cnt = maxEv;
      VDB_retc=0;
      VDB_cnt = maxEv;
      VDHW_retc=0;
      VDHW_cnt = maxEv;
      VBHW_retc=0;
      VBHW_cnt = maxEv;
   end
   V_B_HW = V(B,HW);
   V_D_HW = V(D,HW);
   V_D_B = V(D,B);
   V_D_S = V(D,S);
   V_G_D = V(G,D);
   V_G_S = V(G,S);

//      VGS
   VGS = V_G_S;
   if((VGS_cnt>0) || ( maxEv_flg==0 ))   begin
      if( (VGS < -5.5) && (VGS_retc!=-1))
      begin
        outfile=$fopen(errFileName,"a");
        $strobe("phvra         VGS     leaving   OCA (  .. -5.500 V ) at %7.4r  %M", $abstime );
        $fwrite(outfile,"phvra         VGS     leaving   OCA (  .. -5.500 V ) at %7.4r  %M\n", $abstime );
        VGS_retc=-1;
        VGS_cnt=VGS_cnt-1;
        $fclose(outfile);
      end
      if((VGS >= -5.5) &&  (VGS <= 5.5) && (VGS_retc!=0))
      begin
        outfile=$fopen(errFileName,"a");
        $strobe("phvra         VGS     entering SOCA ( -5.500 V .. 5.500 V ) at %7.4r  %M", $abstime );
        $fwrite(outfile,"phvra         VGS     entering SOCA ( -5.500 V .. 5.500 V ) at %7.4r  %M\n", $abstime );
        VGS_retc=0;
        VGS_cnt=VGS_cnt-1;
        $fclose(outfile);
      end
      if((VGS > 5.5) &&  (VGS_retc!=1))
      begin
        outfile=$fopen(errFileName,"a");
        $strobe("phvra         VGS     leaving   OCA ( 5.500 V ..  ) at %7.4r  %M", $abstime );
        $fwrite(outfile,"phvra         VGS     leaving   OCA ( 5.500 V ..  ) at %7.4r  %M\n", $abstime );
        VGS_retc=1;
        VGS_cnt=VGS_cnt-1;
        $fclose(outfile);
      end
   end
   else
   begin
      if(VGS_cnt==0)
      begin
        outfile=$fopen(errFileName,"a");
        $strobe("phvra         VGS     error limit ( %d ) reached at %7.4r  %M", maxEv, $abstime );
        $fwrite(outfile,"phvra         VGS     error limit ( %d ) reached at %7.4r  %M\n", maxEv, $abstime );
        VGS_cnt=VGS_cnt-1;
        $fclose(outfile);
      end
   end

//      VGD
   VGD = V_G_D;
   if((VGD_cnt>0) || ( maxEv_flg==0 ))   begin
      if( (VGD < -5.5) && (VGD_retc!=-1))
      begin
        outfile=$fopen(errFileName,"a");
        $strobe("phvra         VGD     leaving   OCA (  .. -5.500 V ) at %7.4r  %M", $abstime );
        $fwrite(outfile,"phvra         VGD     leaving   OCA (  .. -5.500 V ) at %7.4r  %M\n", $abstime );
        VGD_retc=-1;
        VGD_cnt=VGD_cnt-1;
        $fclose(outfile);
      end
      if((VGD >= -5.5) &&  (VGD <= 40) && (VGD_retc!=0))
      begin
        outfile=$fopen(errFileName,"a");
        $strobe("phvra         VGD     entering SOCA ( -5.500 V .. 40.000 V ) at %7.4r  %M", $abstime );
        $fwrite(outfile,"phvra         VGD     entering SOCA ( -5.500 V .. 40.000 V ) at %7.4r  %M\n", $abstime );
        VGD_retc=0;
        VGD_cnt=VGD_cnt-1;
        $fclose(outfile);
      end
      if((VGD > 40) &&  (VGD_retc!=1))
      begin
        outfile=$fopen(errFileName,"a");
        $strobe("phvra         VGD     leaving   OCA ( 40.000 V ..  ) at %7.4r  %M", $abstime );
        $fwrite(outfile,"phvra         VGD     leaving   OCA ( 40.000 V ..  ) at %7.4r  %M\n", $abstime );
        VGD_retc=1;
        VGD_cnt=VGD_cnt-1;
        $fclose(outfile);
      end
   end
   else
   begin
      if(VGD_cnt==0)
      begin
        outfile=$fopen(errFileName,"a");
        $strobe("phvra         VGD     error limit ( %d ) reached at %7.4r  %M", maxEv, $abstime );
        $fwrite(outfile,"phvra         VGD     error limit ( %d ) reached at %7.4r  %M\n", maxEv, $abstime );
        VGD_cnt=VGD_cnt-1;
        $fclose(outfile);
      end
   end

//      VDS
   VDS = V_D_S;
   if((VDS_cnt>0) || ( maxEv_flg==0 ))   begin
      if( (VDS < -40) && (VDS_retc!=-1))
      begin
        outfile=$fopen(errFileName,"a");
        $strobe("phvra         VDS     leaving   OCA (  .. -40.000 V ) at %7.4r  %M", $abstime );
        $fwrite(outfile,"phvra         VDS     leaving   OCA (  .. -40.000 V ) at %7.4r  %M\n", $abstime );
        VDS_retc=-1;
        VDS_cnt=VDS_cnt-1;
        $fclose(outfile);
      end
      if((VDS >= -40) &&  (VDS <= 1.5) && (VDS_retc!=0))
      begin
        outfile=$fopen(errFileName,"a");
        $strobe("phvra         VDS     entering SOCA ( -40.000 V .. 1.500 V ) at %7.4r  %M", $abstime );
        $fwrite(outfile,"phvra         VDS     entering SOCA ( -40.000 V .. 1.500 V ) at %7.4r  %M\n", $abstime );
        VDS_retc=0;
        VDS_cnt=VDS_cnt-1;
        $fclose(outfile);
      end
      if((VDS > 1.5) &&  (VDS_retc!=1))
      begin
        outfile=$fopen(errFileName,"a");
        $strobe("phvra         VDS     leaving   OCA ( 1.500 V ..  ) at %7.4r  %M", $abstime );
        $fwrite(outfile,"phvra         VDS     leaving   OCA ( 1.500 V ..  ) at %7.4r  %M\n", $abstime );
        VDS_retc=1;
        VDS_cnt=VDS_cnt-1;
        $fclose(outfile);
      end
   end
   else
   begin
      if(VDS_cnt==0)
      begin
        outfile=$fopen(errFileName,"a");
        $strobe("phvra         VDS     error limit ( %d ) reached at %7.4r  %M", maxEv, $abstime );
        $fwrite(outfile,"phvra         VDS     error limit ( %d ) reached at %7.4r  %M\n", maxEv, $abstime );
        VDS_cnt=VDS_cnt-1;
        $fclose(outfile);
      end
   end

//      VDB
   VDB = V_D_B;
   if((VDB_cnt>0) || ( maxEv_flg==0 ))   begin
      if( (VDB < -40) && (VDB_retc!=-1))
      begin
        outfile=$fopen(errFileName,"a");
        $strobe("phvra         VDB     leaving   OCA (  .. -40.000 V ) at %7.4r  %M", $abstime );
        $fwrite(outfile,"phvra         VDB     leaving   OCA (  .. -40.000 V ) at %7.4r  %M\n", $abstime );
        VDB_retc=-1;
        VDB_cnt=VDB_cnt-1;
        $fclose(outfile);
      end
      if((VDB >= -40) &&  (VDB <= 1.5) && (VDB_retc!=0))
      begin
        outfile=$fopen(errFileName,"a");
        $strobe("phvra         VDB     entering SOCA ( -40.000 V .. 1.500 V ) at %7.4r  %M", $abstime );
        $fwrite(outfile,"phvra         VDB     entering SOCA ( -40.000 V .. 1.500 V ) at %7.4r  %M\n", $abstime );
        VDB_retc=0;
        VDB_cnt=VDB_cnt-1;
        $fclose(outfile);
      end
      if((VDB > 1.5) &&  (VDB_retc!=1))
      begin
        outfile=$fopen(errFileName,"a");
        $strobe("phvra         VDB     leaving   OCA ( 1.500 V ..  ) at %7.4r  %M", $abstime );
        $fwrite(outfile,"phvra         VDB     leaving   OCA ( 1.500 V ..  ) at %7.4r  %M\n", $abstime );
        VDB_retc=1;
        VDB_cnt=VDB_cnt-1;
        $fclose(outfile);
      end
   end
   else
   begin
      if(VDB_cnt==0)
      begin
        outfile=$fopen(errFileName,"a");
        $strobe("phvra         VDB     error limit ( %d ) reached at %7.4r  %M", maxEv, $abstime );
        $fwrite(outfile,"phvra         VDB     error limit ( %d ) reached at %7.4r  %M\n", maxEv, $abstime );
        VDB_cnt=VDB_cnt-1;
        $fclose(outfile);
      end
   end

//      VDHW
   VDHW = V_D_HW;
   if((VDHW_cnt>0) || ( maxEv_flg==0 ))   begin
      if( (VDHW < -25) && (VDHW_retc!=-1))
      begin
        outfile=$fopen(errFileName,"a");
        $strobe("phvra         VDHW    leaving   OCA (  .. -25.000 V ) at %7.4r  %M", $abstime );
        $fwrite(outfile,"phvra         VDHW    leaving   OCA (  .. -25.000 V ) at %7.4r  %M\n", $abstime );
        VDHW_retc=-1;
        VDHW_cnt=VDHW_cnt-1;
        $fclose(outfile);
      end
      if((VDHW >= -25) &&  (VDHW <= 125) && (VDHW_retc!=0))
      begin
        outfile=$fopen(errFileName,"a");
        $strobe("phvra         VDHW    entering SOCA ( -25.000 V .. 125.000 V ) at %7.4r  %M", $abstime );
        $fwrite(outfile,"phvra         VDHW    entering SOCA ( -25.000 V .. 125.000 V ) at %7.4r  %M\n", $abstime );
        VDHW_retc=0;
        VDHW_cnt=VDHW_cnt-1;
        $fclose(outfile);
      end
      if((VDHW > 125) &&  (VDHW_retc!=1))
      begin
        outfile=$fopen(errFileName,"a");
        $strobe("phvra         VDHW    leaving   OCA ( 125.000 V ..  ) at %7.4r  %M", $abstime );
        $fwrite(outfile,"phvra         VDHW    leaving   OCA ( 125.000 V ..  ) at %7.4r  %M\n", $abstime );
        VDHW_retc=1;
        VDHW_cnt=VDHW_cnt-1;
        $fclose(outfile);
      end
   end
   else
   begin
      if(VDHW_cnt==0)
      begin
        outfile=$fopen(errFileName,"a");
        $strobe("phvra         VDHW    error limit ( %d ) reached at %7.4r  %M", maxEv, $abstime );
        $fwrite(outfile,"phvra         VDHW    error limit ( %d ) reached at %7.4r  %M\n", maxEv, $abstime );
        VDHW_cnt=VDHW_cnt-1;
        $fclose(outfile);
      end
   end

//      VBHW
   VBHW = V_B_HW;
   if((VBHW_cnt>0) || ( maxEv_flg==0 ))   begin
      if( (VBHW < -25) && (VBHW_retc!=-1))
      begin
        outfile=$fopen(errFileName,"a");
        $strobe("phvra         VBHW    leaving   OCA (  .. -25.000 V ) at %7.4r  %M", $abstime );
        $fwrite(outfile,"phvra         VBHW    leaving   OCA (  .. -25.000 V ) at %7.4r  %M\n", $abstime );
        VBHW_retc=-1;
        VBHW_cnt=VBHW_cnt-1;
        $fclose(outfile);
      end
      if((VBHW >= -25) &&  (VBHW <= 125) && (VBHW_retc!=0))
      begin
        outfile=$fopen(errFileName,"a");
        $strobe("phvra         VBHW    entering SOCA ( -25.000 V .. 125.000 V ) at %7.4r  %M", $abstime );
        $fwrite(outfile,"phvra         VBHW    entering SOCA ( -25.000 V .. 125.000 V ) at %7.4r  %M\n", $abstime );
        VBHW_retc=0;
        VBHW_cnt=VBHW_cnt-1;
        $fclose(outfile);
      end
      if((VBHW > 125) &&  (VBHW_retc!=1))
      begin
        outfile=$fopen(errFileName,"a");
        $strobe("phvra         VBHW    leaving   OCA ( 125.000 V ..  ) at %7.4r  %M", $abstime );
        $fwrite(outfile,"phvra         VBHW    leaving   OCA ( 125.000 V ..  ) at %7.4r  %M\n", $abstime );
        VBHW_retc=1;
        VBHW_cnt=VBHW_cnt-1;
        $fclose(outfile);
      end
   end
   else
   begin
      if(VBHW_cnt==0)
      begin
        outfile=$fopen(errFileName,"a");
        $strobe("phvra         VBHW    error limit ( %d ) reached at %7.4r  %M", maxEv, $abstime );
        $fwrite(outfile,"phvra         VBHW    error limit ( %d ) reached at %7.4r  %M\n", maxEv, $abstime );
        VBHW_cnt=VBHW_cnt-1;
        $fclose(outfile);
      end
   end

end // analog
endmodule // phvra

// Verilog-A OC Watch for device phvrb Parameters  VGS VGD VDS VDB VDHW VBHW
module phvrb_ahdl(D,G,S,B,HW);
parameter tstep_occ=100n;
parameter errFileName="./occ.err";
parameter maxEv = 25;
parameter maxEv_flg = 0;
inout D,G,S,B,HW;
electrical D,G,S,B,HW;

integer outfile;
real V_B_HW;
real V_D_HW;
real V_D_B;
real V_D_S;
real V_G_D;
real V_G_S;
real VGS;
integer VGS_retc;
integer VGS_cnt;
real VGD;
integer VGD_retc;
integer VGD_cnt;
real VDS;
integer VDS_retc;
integer VDS_cnt;
real VDB;
integer VDB_retc;
integer VDB_cnt;
real VDHW;
integer VDHW_retc;
integer VDHW_cnt;
real VBHW;
integer VBHW_retc;
integer VBHW_cnt;

analog begin
   $bound_step( tstep_occ );
   @(initial_step) begin
      VGS_retc=0;
      VGS_cnt = maxEv;
      VGD_retc=0;
      VGD_cnt = maxEv;
      VDS_retc=0;
      VDS_cnt = maxEv;
      VDB_retc=0;
      VDB_cnt = maxEv;
      VDHW_retc=0;
      VDHW_cnt = maxEv;
      VBHW_retc=0;
      VBHW_cnt = maxEv;
   end
   V_B_HW = V(B,HW);
   V_D_HW = V(D,HW);
   V_D_B = V(D,B);
   V_D_S = V(D,S);
   V_G_D = V(G,D);
   V_G_S = V(G,S);

//      VGS
   VGS = V_G_S;
   if((VGS_cnt>0) || ( maxEv_flg==0 ))   begin
      if( (VGS < -5.5) && (VGS_retc!=-1))
      begin
        outfile=$fopen(errFileName,"a");
        $strobe("phvrb         VGS     leaving   OCA (  .. -5.500 V ) at %7.4r  %M", $abstime );
        $fwrite(outfile,"phvrb         VGS     leaving   OCA (  .. -5.500 V ) at %7.4r  %M\n", $abstime );
        VGS_retc=-1;
        VGS_cnt=VGS_cnt-1;
        $fclose(outfile);
      end
      if((VGS >= -5.5) &&  (VGS <= 5.5) && (VGS_retc!=0))
      begin
        outfile=$fopen(errFileName,"a");
        $strobe("phvrb         VGS     entering SOCA ( -5.500 V .. 5.500 V ) at %7.4r  %M", $abstime );
        $fwrite(outfile,"phvrb         VGS     entering SOCA ( -5.500 V .. 5.500 V ) at %7.4r  %M\n", $abstime );
        VGS_retc=0;
        VGS_cnt=VGS_cnt-1;
        $fclose(outfile);
      end
      if((VGS > 5.5) &&  (VGS_retc!=1))
      begin
        outfile=$fopen(errFileName,"a");
        $strobe("phvrb         VGS     leaving   OCA ( 5.500 V ..  ) at %7.4r  %M", $abstime );
        $fwrite(outfile,"phvrb         VGS     leaving   OCA ( 5.500 V ..  ) at %7.4r  %M\n", $abstime );
        VGS_retc=1;
        VGS_cnt=VGS_cnt-1;
        $fclose(outfile);
      end
   end
   else
   begin
      if(VGS_cnt==0)
      begin
        outfile=$fopen(errFileName,"a");
        $strobe("phvrb         VGS     error limit ( %d ) reached at %7.4r  %M", maxEv, $abstime );
        $fwrite(outfile,"phvrb         VGS     error limit ( %d ) reached at %7.4r  %M\n", maxEv, $abstime );
        VGS_cnt=VGS_cnt-1;
        $fclose(outfile);
      end
   end

//      VGD
   VGD = V_G_D;
   if((VGD_cnt>0) || ( maxEv_flg==0 ))   begin
      if( (VGD < -5.5) && (VGD_retc!=-1))
      begin
        outfile=$fopen(errFileName,"a");
        $strobe("phvrb         VGD     leaving   OCA (  .. -5.500 V ) at %7.4r  %M", $abstime );
        $fwrite(outfile,"phvrb         VGD     leaving   OCA (  .. -5.500 V ) at %7.4r  %M\n", $abstime );
        VGD_retc=-1;
        VGD_cnt=VGD_cnt-1;
        $fclose(outfile);
      end
      if((VGD >= -5.5) &&  (VGD <= 60) && (VGD_retc!=0))
      begin
        outfile=$fopen(errFileName,"a");
        $strobe("phvrb         VGD     entering SOCA ( -5.500 V .. 60.000 V ) at %7.4r  %M", $abstime );
        $fwrite(outfile,"phvrb         VGD     entering SOCA ( -5.500 V .. 60.000 V ) at %7.4r  %M\n", $abstime );
        VGD_retc=0;
        VGD_cnt=VGD_cnt-1;
        $fclose(outfile);
      end
      if((VGD > 60) &&  (VGD_retc!=1))
      begin
        outfile=$fopen(errFileName,"a");
        $strobe("phvrb         VGD     leaving   OCA ( 60.000 V ..  ) at %7.4r  %M", $abstime );
        $fwrite(outfile,"phvrb         VGD     leaving   OCA ( 60.000 V ..  ) at %7.4r  %M\n", $abstime );
        VGD_retc=1;
        VGD_cnt=VGD_cnt-1;
        $fclose(outfile);
      end
   end
   else
   begin
      if(VGD_cnt==0)
      begin
        outfile=$fopen(errFileName,"a");
        $strobe("phvrb         VGD     error limit ( %d ) reached at %7.4r  %M", maxEv, $abstime );
        $fwrite(outfile,"phvrb         VGD     error limit ( %d ) reached at %7.4r  %M\n", maxEv, $abstime );
        VGD_cnt=VGD_cnt-1;
        $fclose(outfile);
      end
   end

//      VDS
   VDS = V_D_S;
   if((VDS_cnt>0) || ( maxEv_flg==0 ))   begin
      if( (VDS < -60) && (VDS_retc!=-1))
      begin
        outfile=$fopen(errFileName,"a");
        $strobe("phvrb         VDS     leaving   OCA (  .. -60.000 V ) at %7.4r  %M", $abstime );
        $fwrite(outfile,"phvrb         VDS     leaving   OCA (  .. -60.000 V ) at %7.4r  %M\n", $abstime );
        VDS_retc=-1;
        VDS_cnt=VDS_cnt-1;
        $fclose(outfile);
      end
      if((VDS >= -60) &&  (VDS <= 1.5) && (VDS_retc!=0))
      begin
        outfile=$fopen(errFileName,"a");
        $strobe("phvrb         VDS     entering SOCA ( -60.000 V .. 1.500 V ) at %7.4r  %M", $abstime );
        $fwrite(outfile,"phvrb         VDS     entering SOCA ( -60.000 V .. 1.500 V ) at %7.4r  %M\n", $abstime );
        VDS_retc=0;
        VDS_cnt=VDS_cnt-1;
        $fclose(outfile);
      end
      if((VDS > 1.5) &&  (VDS_retc!=1))
      begin
        outfile=$fopen(errFileName,"a");
        $strobe("phvrb         VDS     leaving   OCA ( 1.500 V ..  ) at %7.4r  %M", $abstime );
        $fwrite(outfile,"phvrb         VDS     leaving   OCA ( 1.500 V ..  ) at %7.4r  %M\n", $abstime );
        VDS_retc=1;
        VDS_cnt=VDS_cnt-1;
        $fclose(outfile);
      end
   end
   else
   begin
      if(VDS_cnt==0)
      begin
        outfile=$fopen(errFileName,"a");
        $strobe("phvrb         VDS     error limit ( %d ) reached at %7.4r  %M", maxEv, $abstime );
        $fwrite(outfile,"phvrb         VDS     error limit ( %d ) reached at %7.4r  %M\n", maxEv, $abstime );
        VDS_cnt=VDS_cnt-1;
        $fclose(outfile);
      end
   end

//      VDB
   VDB = V_D_B;
   if((VDB_cnt>0) || ( maxEv_flg==0 ))   begin
      if( (VDB < -60) && (VDB_retc!=-1))
      begin
        outfile=$fopen(errFileName,"a");
        $strobe("phvrb         VDB     leaving   OCA (  .. -60.000 V ) at %7.4r  %M", $abstime );
        $fwrite(outfile,"phvrb         VDB     leaving   OCA (  .. -60.000 V ) at %7.4r  %M\n", $abstime );
        VDB_retc=-1;
        VDB_cnt=VDB_cnt-1;
        $fclose(outfile);
      end
      if((VDB >= -60) &&  (VDB <= 1.5) && (VDB_retc!=0))
      begin
        outfile=$fopen(errFileName,"a");
        $strobe("phvrb         VDB     entering SOCA ( -60.000 V .. 1.500 V ) at %7.4r  %M", $abstime );
        $fwrite(outfile,"phvrb         VDB     entering SOCA ( -60.000 V .. 1.500 V ) at %7.4r  %M\n", $abstime );
        VDB_retc=0;
        VDB_cnt=VDB_cnt-1;
        $fclose(outfile);
      end
      if((VDB > 1.5) &&  (VDB_retc!=1))
      begin
        outfile=$fopen(errFileName,"a");
        $strobe("phvrb         VDB     leaving   OCA ( 1.500 V ..  ) at %7.4r  %M", $abstime );
        $fwrite(outfile,"phvrb         VDB     leaving   OCA ( 1.500 V ..  ) at %7.4r  %M\n", $abstime );
        VDB_retc=1;
        VDB_cnt=VDB_cnt-1;
        $fclose(outfile);
      end
   end
   else
   begin
      if(VDB_cnt==0)
      begin
        outfile=$fopen(errFileName,"a");
        $strobe("phvrb         VDB     error limit ( %d ) reached at %7.4r  %M", maxEv, $abstime );
        $fwrite(outfile,"phvrb         VDB     error limit ( %d ) reached at %7.4r  %M\n", maxEv, $abstime );
        VDB_cnt=VDB_cnt-1;
        $fclose(outfile);
      end
   end

//      VDHW
   VDHW = V_D_HW;
   if((VDHW_cnt>0) || ( maxEv_flg==0 ))   begin
      if( (VDHW < -25) && (VDHW_retc!=-1))
      begin
        outfile=$fopen(errFileName,"a");
        $strobe("phvrb         VDHW    leaving   OCA (  .. -25.000 V ) at %7.4r  %M", $abstime );
        $fwrite(outfile,"phvrb         VDHW    leaving   OCA (  .. -25.000 V ) at %7.4r  %M\n", $abstime );
        VDHW_retc=-1;
        VDHW_cnt=VDHW_cnt-1;
        $fclose(outfile);
      end
      if((VDHW >= -25) &&  (VDHW <= 125) && (VDHW_retc!=0))
      begin
        outfile=$fopen(errFileName,"a");
        $strobe("phvrb         VDHW    entering SOCA ( -25.000 V .. 125.000 V ) at %7.4r  %M", $abstime );
        $fwrite(outfile,"phvrb         VDHW    entering SOCA ( -25.000 V .. 125.000 V ) at %7.4r  %M\n", $abstime );
        VDHW_retc=0;
        VDHW_cnt=VDHW_cnt-1;
        $fclose(outfile);
      end
      if((VDHW > 125) &&  (VDHW_retc!=1))
      begin
        outfile=$fopen(errFileName,"a");
        $strobe("phvrb         VDHW    leaving   OCA ( 125.000 V ..  ) at %7.4r  %M", $abstime );
        $fwrite(outfile,"phvrb         VDHW    leaving   OCA ( 125.000 V ..  ) at %7.4r  %M\n", $abstime );
        VDHW_retc=1;
        VDHW_cnt=VDHW_cnt-1;
        $fclose(outfile);
      end
   end
   else
   begin
      if(VDHW_cnt==0)
      begin
        outfile=$fopen(errFileName,"a");
        $strobe("phvrb         VDHW    error limit ( %d ) reached at %7.4r  %M", maxEv, $abstime );
        $fwrite(outfile,"phvrb         VDHW    error limit ( %d ) reached at %7.4r  %M\n", maxEv, $abstime );
        VDHW_cnt=VDHW_cnt-1;
        $fclose(outfile);
      end
   end

//      VBHW
   VBHW = V_B_HW;
   if((VBHW_cnt>0) || ( maxEv_flg==0 ))   begin
      if( (VBHW < -25) && (VBHW_retc!=-1))
      begin
        outfile=$fopen(errFileName,"a");
        $strobe("phvrb         VBHW    leaving   OCA (  .. -25.000 V ) at %7.4r  %M", $abstime );
        $fwrite(outfile,"phvrb         VBHW    leaving   OCA (  .. -25.000 V ) at %7.4r  %M\n", $abstime );
        VBHW_retc=-1;
        VBHW_cnt=VBHW_cnt-1;
        $fclose(outfile);
      end
      if((VBHW >= -25) &&  (VBHW <= 125) && (VBHW_retc!=0))
      begin
        outfile=$fopen(errFileName,"a");
        $strobe("phvrb         VBHW    entering SOCA ( -25.000 V .. 125.000 V ) at %7.4r  %M", $abstime );
        $fwrite(outfile,"phvrb         VBHW    entering SOCA ( -25.000 V .. 125.000 V ) at %7.4r  %M\n", $abstime );
        VBHW_retc=0;
        VBHW_cnt=VBHW_cnt-1;
        $fclose(outfile);
      end
      if((VBHW > 125) &&  (VBHW_retc!=1))
      begin
        outfile=$fopen(errFileName,"a");
        $strobe("phvrb         VBHW    leaving   OCA ( 125.000 V ..  ) at %7.4r  %M", $abstime );
        $fwrite(outfile,"phvrb         VBHW    leaving   OCA ( 125.000 V ..  ) at %7.4r  %M\n", $abstime );
        VBHW_retc=1;
        VBHW_cnt=VBHW_cnt-1;
        $fclose(outfile);
      end
   end
   else
   begin
      if(VBHW_cnt==0)
      begin
        outfile=$fopen(errFileName,"a");
        $strobe("phvrb         VBHW    error limit ( %d ) reached at %7.4r  %M", maxEv, $abstime );
        $fwrite(outfile,"phvrb         VBHW    error limit ( %d ) reached at %7.4r  %M\n", maxEv, $abstime );
        VBHW_cnt=VBHW_cnt-1;
        $fclose(outfile);
      end
   end

end // analog
endmodule // phvrb

// Verilog-A OC Watch for device phvrc Parameters  VGS VGD VDS VDB VDHW VBHW
module phvrc_ahdl(D,G,S,B,HW);
parameter tstep_occ=100n;
parameter errFileName="./occ.err";
parameter maxEv = 25;
parameter maxEv_flg = 0;
inout D,G,S,B,HW;
electrical D,G,S,B,HW;

integer outfile;
real V_B_HW;
real V_D_HW;
real V_D_B;
real V_D_S;
real V_G_D;
real V_G_S;
real VGS;
integer VGS_retc;
integer VGS_cnt;
real VGD;
integer VGD_retc;
integer VGD_cnt;
real VDS;
integer VDS_retc;
integer VDS_cnt;
real VDB;
integer VDB_retc;
integer VDB_cnt;
real VDHW;
integer VDHW_retc;
integer VDHW_cnt;
real VBHW;
integer VBHW_retc;
integer VBHW_cnt;

analog begin
   $bound_step( tstep_occ );
   @(initial_step) begin
      VGS_retc=0;
      VGS_cnt = maxEv;
      VGD_retc=0;
      VGD_cnt = maxEv;
      VDS_retc=0;
      VDS_cnt = maxEv;
      VDB_retc=0;
      VDB_cnt = maxEv;
      VDHW_retc=0;
      VDHW_cnt = maxEv;
      VBHW_retc=0;
      VBHW_cnt = maxEv;
   end
   V_B_HW = V(B,HW);
   V_D_HW = V(D,HW);
   V_D_B = V(D,B);
   V_D_S = V(D,S);
   V_G_D = V(G,D);
   V_G_S = V(G,S);

//      VGS
   VGS = V_G_S;
   if((VGS_cnt>0) || ( maxEv_flg==0 ))   begin
      if( (VGS < -5.5) && (VGS_retc!=-1))
      begin
        outfile=$fopen(errFileName,"a");
        $strobe("phvrc         VGS     leaving   OCA (  .. -5.500 V ) at %7.4r  %M", $abstime );
        $fwrite(outfile,"phvrc         VGS     leaving   OCA (  .. -5.500 V ) at %7.4r  %M\n", $abstime );
        VGS_retc=-1;
        VGS_cnt=VGS_cnt-1;
        $fclose(outfile);
      end
      if((VGS >= -5.5) &&  (VGS <= 5.5) && (VGS_retc!=0))
      begin
        outfile=$fopen(errFileName,"a");
        $strobe("phvrc         VGS     entering SOCA ( -5.500 V .. 5.500 V ) at %7.4r  %M", $abstime );
        $fwrite(outfile,"phvrc         VGS     entering SOCA ( -5.500 V .. 5.500 V ) at %7.4r  %M\n", $abstime );
        VGS_retc=0;
        VGS_cnt=VGS_cnt-1;
        $fclose(outfile);
      end
      if((VGS > 5.5) &&  (VGS_retc!=1))
      begin
        outfile=$fopen(errFileName,"a");
        $strobe("phvrc         VGS     leaving   OCA ( 5.500 V ..  ) at %7.4r  %M", $abstime );
        $fwrite(outfile,"phvrc         VGS     leaving   OCA ( 5.500 V ..  ) at %7.4r  %M\n", $abstime );
        VGS_retc=1;
        VGS_cnt=VGS_cnt-1;
        $fclose(outfile);
      end
   end
   else
   begin
      if(VGS_cnt==0)
      begin
        outfile=$fopen(errFileName,"a");
        $strobe("phvrc         VGS     error limit ( %d ) reached at %7.4r  %M", maxEv, $abstime );
        $fwrite(outfile,"phvrc         VGS     error limit ( %d ) reached at %7.4r  %M\n", maxEv, $abstime );
        VGS_cnt=VGS_cnt-1;
        $fclose(outfile);
      end
   end

//      VGD
   VGD = V_G_D;
   if((VGD_cnt>0) || ( maxEv_flg==0 ))   begin
      if( (VGD < -5.5) && (VGD_retc!=-1))
      begin
        outfile=$fopen(errFileName,"a");
        $strobe("phvrc         VGD     leaving   OCA (  .. -5.500 V ) at %7.4r  %M", $abstime );
        $fwrite(outfile,"phvrc         VGD     leaving   OCA (  .. -5.500 V ) at %7.4r  %M\n", $abstime );
        VGD_retc=-1;
        VGD_cnt=VGD_cnt-1;
        $fclose(outfile);
      end
      if((VGD >= -5.5) &&  (VGD <= 70) && (VGD_retc!=0))
      begin
        outfile=$fopen(errFileName,"a");
        $strobe("phvrc         VGD     entering SOCA ( -5.500 V .. 70.000 V ) at %7.4r  %M", $abstime );
        $fwrite(outfile,"phvrc         VGD     entering SOCA ( -5.500 V .. 70.000 V ) at %7.4r  %M\n", $abstime );
        VGD_retc=0;
        VGD_cnt=VGD_cnt-1;
        $fclose(outfile);
      end
      if((VGD > 70) &&  (VGD_retc!=1))
      begin
        outfile=$fopen(errFileName,"a");
        $strobe("phvrc         VGD     leaving   OCA ( 70.000 V ..  ) at %7.4r  %M", $abstime );
        $fwrite(outfile,"phvrc         VGD     leaving   OCA ( 70.000 V ..  ) at %7.4r  %M\n", $abstime );
        VGD_retc=1;
        VGD_cnt=VGD_cnt-1;
        $fclose(outfile);
      end
   end
   else
   begin
      if(VGD_cnt==0)
      begin
        outfile=$fopen(errFileName,"a");
        $strobe("phvrc         VGD     error limit ( %d ) reached at %7.4r  %M", maxEv, $abstime );
        $fwrite(outfile,"phvrc         VGD     error limit ( %d ) reached at %7.4r  %M\n", maxEv, $abstime );
        VGD_cnt=VGD_cnt-1;
        $fclose(outfile);
      end
   end

//      VDS
   VDS = V_D_S;
   if((VDS_cnt>0) || ( maxEv_flg==0 ))   begin
      if( (VDS < -70) && (VDS_retc!=-1))
      begin
        outfile=$fopen(errFileName,"a");
        $strobe("phvrc         VDS     leaving   OCA (  .. -70.000 V ) at %7.4r  %M", $abstime );
        $fwrite(outfile,"phvrc         VDS     leaving   OCA (  .. -70.000 V ) at %7.4r  %M\n", $abstime );
        VDS_retc=-1;
        VDS_cnt=VDS_cnt-1;
        $fclose(outfile);
      end
      if((VDS >= -70) &&  (VDS <= 1.5) && (VDS_retc!=0))
      begin
        outfile=$fopen(errFileName,"a");
        $strobe("phvrc         VDS     entering SOCA ( -70.000 V .. 1.500 V ) at %7.4r  %M", $abstime );
        $fwrite(outfile,"phvrc         VDS     entering SOCA ( -70.000 V .. 1.500 V ) at %7.4r  %M\n", $abstime );
        VDS_retc=0;
        VDS_cnt=VDS_cnt-1;
        $fclose(outfile);
      end
      if((VDS > 1.5) &&  (VDS_retc!=1))
      begin
        outfile=$fopen(errFileName,"a");
        $strobe("phvrc         VDS     leaving   OCA ( 1.500 V ..  ) at %7.4r  %M", $abstime );
        $fwrite(outfile,"phvrc         VDS     leaving   OCA ( 1.500 V ..  ) at %7.4r  %M\n", $abstime );
        VDS_retc=1;
        VDS_cnt=VDS_cnt-1;
        $fclose(outfile);
      end
   end
   else
   begin
      if(VDS_cnt==0)
      begin
        outfile=$fopen(errFileName,"a");
        $strobe("phvrc         VDS     error limit ( %d ) reached at %7.4r  %M", maxEv, $abstime );
        $fwrite(outfile,"phvrc         VDS     error limit ( %d ) reached at %7.4r  %M\n", maxEv, $abstime );
        VDS_cnt=VDS_cnt-1;
        $fclose(outfile);
      end
   end

//      VDB
   VDB = V_D_B;
   if((VDB_cnt>0) || ( maxEv_flg==0 ))   begin
      if( (VDB < -70) && (VDB_retc!=-1))
      begin
        outfile=$fopen(errFileName,"a");
        $strobe("phvrc         VDB     leaving   OCA (  .. -70.000 V ) at %7.4r  %M", $abstime );
        $fwrite(outfile,"phvrc         VDB     leaving   OCA (  .. -70.000 V ) at %7.4r  %M\n", $abstime );
        VDB_retc=-1;
        VDB_cnt=VDB_cnt-1;
        $fclose(outfile);
      end
      if((VDB >= -70) &&  (VDB <= 1.5) && (VDB_retc!=0))
      begin
        outfile=$fopen(errFileName,"a");
        $strobe("phvrc         VDB     entering SOCA ( -70.000 V .. 1.500 V ) at %7.4r  %M", $abstime );
        $fwrite(outfile,"phvrc         VDB     entering SOCA ( -70.000 V .. 1.500 V ) at %7.4r  %M\n", $abstime );
        VDB_retc=0;
        VDB_cnt=VDB_cnt-1;
        $fclose(outfile);
      end
      if((VDB > 1.5) &&  (VDB_retc!=1))
      begin
        outfile=$fopen(errFileName,"a");
        $strobe("phvrc         VDB     leaving   OCA ( 1.500 V ..  ) at %7.4r  %M", $abstime );
        $fwrite(outfile,"phvrc         VDB     leaving   OCA ( 1.500 V ..  ) at %7.4r  %M\n", $abstime );
        VDB_retc=1;
        VDB_cnt=VDB_cnt-1;
        $fclose(outfile);
      end
   end
   else
   begin
      if(VDB_cnt==0)
      begin
        outfile=$fopen(errFileName,"a");
        $strobe("phvrc         VDB     error limit ( %d ) reached at %7.4r  %M", maxEv, $abstime );
        $fwrite(outfile,"phvrc         VDB     error limit ( %d ) reached at %7.4r  %M\n", maxEv, $abstime );
        VDB_cnt=VDB_cnt-1;
        $fclose(outfile);
      end
   end

//      VDHW
   VDHW = V_D_HW;
   if((VDHW_cnt>0) || ( maxEv_flg==0 ))   begin
      if( (VDHW < -25) && (VDHW_retc!=-1))
      begin
        outfile=$fopen(errFileName,"a");
        $strobe("phvrc         VDHW    leaving   OCA (  .. -25.000 V ) at %7.4r  %M", $abstime );
        $fwrite(outfile,"phvrc         VDHW    leaving   OCA (  .. -25.000 V ) at %7.4r  %M\n", $abstime );
        VDHW_retc=-1;
        VDHW_cnt=VDHW_cnt-1;
        $fclose(outfile);
      end
      if((VDHW >= -25) &&  (VDHW <= 125) && (VDHW_retc!=0))
      begin
        outfile=$fopen(errFileName,"a");
        $strobe("phvrc         VDHW    entering SOCA ( -25.000 V .. 125.000 V ) at %7.4r  %M", $abstime );
        $fwrite(outfile,"phvrc         VDHW    entering SOCA ( -25.000 V .. 125.000 V ) at %7.4r  %M\n", $abstime );
        VDHW_retc=0;
        VDHW_cnt=VDHW_cnt-1;
        $fclose(outfile);
      end
      if((VDHW > 125) &&  (VDHW_retc!=1))
      begin
        outfile=$fopen(errFileName,"a");
        $strobe("phvrc         VDHW    leaving   OCA ( 125.000 V ..  ) at %7.4r  %M", $abstime );
        $fwrite(outfile,"phvrc         VDHW    leaving   OCA ( 125.000 V ..  ) at %7.4r  %M\n", $abstime );
        VDHW_retc=1;
        VDHW_cnt=VDHW_cnt-1;
        $fclose(outfile);
      end
   end
   else
   begin
      if(VDHW_cnt==0)
      begin
        outfile=$fopen(errFileName,"a");
        $strobe("phvrc         VDHW    error limit ( %d ) reached at %7.4r  %M", maxEv, $abstime );
        $fwrite(outfile,"phvrc         VDHW    error limit ( %d ) reached at %7.4r  %M\n", maxEv, $abstime );
        VDHW_cnt=VDHW_cnt-1;
        $fclose(outfile);
      end
   end

//      VBHW
   VBHW = V_B_HW;
   if((VBHW_cnt>0) || ( maxEv_flg==0 ))   begin
      if( (VBHW < -25) && (VBHW_retc!=-1))
      begin
        outfile=$fopen(errFileName,"a");
        $strobe("phvrc         VBHW    leaving   OCA (  .. -25.000 V ) at %7.4r  %M", $abstime );
        $fwrite(outfile,"phvrc         VBHW    leaving   OCA (  .. -25.000 V ) at %7.4r  %M\n", $abstime );
        VBHW_retc=-1;
        VBHW_cnt=VBHW_cnt-1;
        $fclose(outfile);
      end
      if((VBHW >= -25) &&  (VBHW <= 125) && (VBHW_retc!=0))
      begin
        outfile=$fopen(errFileName,"a");
        $strobe("phvrc         VBHW    entering SOCA ( -25.000 V .. 125.000 V ) at %7.4r  %M", $abstime );
        $fwrite(outfile,"phvrc         VBHW    entering SOCA ( -25.000 V .. 125.000 V ) at %7.4r  %M\n", $abstime );
        VBHW_retc=0;
        VBHW_cnt=VBHW_cnt-1;
        $fclose(outfile);
      end
      if((VBHW > 125) &&  (VBHW_retc!=1))
      begin
        outfile=$fopen(errFileName,"a");
        $strobe("phvrc         VBHW    leaving   OCA ( 125.000 V ..  ) at %7.4r  %M", $abstime );
        $fwrite(outfile,"phvrc         VBHW    leaving   OCA ( 125.000 V ..  ) at %7.4r  %M\n", $abstime );
        VBHW_retc=1;
        VBHW_cnt=VBHW_cnt-1;
        $fclose(outfile);
      end
   end
   else
   begin
      if(VBHW_cnt==0)
      begin
        outfile=$fopen(errFileName,"a");
        $strobe("phvrc         VBHW    error limit ( %d ) reached at %7.4r  %M", maxEv, $abstime );
        $fwrite(outfile,"phvrc         VBHW    error limit ( %d ) reached at %7.4r  %M\n", maxEv, $abstime );
        VBHW_cnt=VBHW_cnt-1;
        $fclose(outfile);
      end
   end

end // analog
endmodule // phvrc

// Verilog-A OC Watch for device phvrd Parameters  VGS VGD VDS VDB VDHW VBHW
module phvrd_ahdl(D,G,S,B,HW);
parameter tstep_occ=100n;
parameter errFileName="./occ.err";
parameter maxEv = 25;
parameter maxEv_flg = 0;
inout D,G,S,B,HW;
electrical D,G,S,B,HW;

integer outfile;
real V_B_HW;
real V_D_HW;
real V_D_B;
real V_D_S;
real V_G_D;
real V_G_S;
real VGS;
integer VGS_retc;
integer VGS_cnt;
real VGD;
integer VGD_retc;
integer VGD_cnt;
real VDS;
integer VDS_retc;
integer VDS_cnt;
real VDB;
integer VDB_retc;
integer VDB_cnt;
real VDHW;
integer VDHW_retc;
integer VDHW_cnt;
real VBHW;
integer VBHW_retc;
integer VBHW_cnt;

analog begin
   $bound_step( tstep_occ );
   @(initial_step) begin
      VGS_retc=0;
      VGS_cnt = maxEv;
      VGD_retc=0;
      VGD_cnt = maxEv;
      VDS_retc=0;
      VDS_cnt = maxEv;
      VDB_retc=0;
      VDB_cnt = maxEv;
      VDHW_retc=0;
      VDHW_cnt = maxEv;
      VBHW_retc=0;
      VBHW_cnt = maxEv;
   end
   V_B_HW = V(B,HW);
   V_D_HW = V(D,HW);
   V_D_B = V(D,B);
   V_D_S = V(D,S);
   V_G_D = V(G,D);
   V_G_S = V(G,S);

//      VGS
   VGS = V_G_S;
   if((VGS_cnt>0) || ( maxEv_flg==0 ))   begin
      if( (VGS < -5.5) && (VGS_retc!=-1))
      begin
        outfile=$fopen(errFileName,"a");
        $strobe("phvrd         VGS     leaving   OCA (  .. -5.500 V ) at %7.4r  %M", $abstime );
        $fwrite(outfile,"phvrd         VGS     leaving   OCA (  .. -5.500 V ) at %7.4r  %M\n", $abstime );
        VGS_retc=-1;
        VGS_cnt=VGS_cnt-1;
        $fclose(outfile);
      end
      if((VGS >= -5.5) &&  (VGS <= 5.5) && (VGS_retc!=0))
      begin
        outfile=$fopen(errFileName,"a");
        $strobe("phvrd         VGS     entering SOCA ( -5.500 V .. 5.500 V ) at %7.4r  %M", $abstime );
        $fwrite(outfile,"phvrd         VGS     entering SOCA ( -5.500 V .. 5.500 V ) at %7.4r  %M\n", $abstime );
        VGS_retc=0;
        VGS_cnt=VGS_cnt-1;
        $fclose(outfile);
      end
      if((VGS > 5.5) &&  (VGS_retc!=1))
      begin
        outfile=$fopen(errFileName,"a");
        $strobe("phvrd         VGS     leaving   OCA ( 5.500 V ..  ) at %7.4r  %M", $abstime );
        $fwrite(outfile,"phvrd         VGS     leaving   OCA ( 5.500 V ..  ) at %7.4r  %M\n", $abstime );
        VGS_retc=1;
        VGS_cnt=VGS_cnt-1;
        $fclose(outfile);
      end
   end
   else
   begin
      if(VGS_cnt==0)
      begin
        outfile=$fopen(errFileName,"a");
        $strobe("phvrd         VGS     error limit ( %d ) reached at %7.4r  %M", maxEv, $abstime );
        $fwrite(outfile,"phvrd         VGS     error limit ( %d ) reached at %7.4r  %M\n", maxEv, $abstime );
        VGS_cnt=VGS_cnt-1;
        $fclose(outfile);
      end
   end

//      VGD
   VGD = V_G_D;
   if((VGD_cnt>0) || ( maxEv_flg==0 ))   begin
      if( (VGD < -5.5) && (VGD_retc!=-1))
      begin
        outfile=$fopen(errFileName,"a");
        $strobe("phvrd         VGD     leaving   OCA (  .. -5.500 V ) at %7.4r  %M", $abstime );
        $fwrite(outfile,"phvrd         VGD     leaving   OCA (  .. -5.500 V ) at %7.4r  %M\n", $abstime );
        VGD_retc=-1;
        VGD_cnt=VGD_cnt-1;
        $fclose(outfile);
      end
      if((VGD >= -5.5) &&  (VGD <= 85) && (VGD_retc!=0))
      begin
        outfile=$fopen(errFileName,"a");
        $strobe("phvrd         VGD     entering SOCA ( -5.500 V .. 85.000 V ) at %7.4r  %M", $abstime );
        $fwrite(outfile,"phvrd         VGD     entering SOCA ( -5.500 V .. 85.000 V ) at %7.4r  %M\n", $abstime );
        VGD_retc=0;
        VGD_cnt=VGD_cnt-1;
        $fclose(outfile);
      end
      if((VGD > 85) &&  (VGD_retc!=1))
      begin
        outfile=$fopen(errFileName,"a");
        $strobe("phvrd         VGD     leaving   OCA ( 85.000 V ..  ) at %7.4r  %M", $abstime );
        $fwrite(outfile,"phvrd         VGD     leaving   OCA ( 85.000 V ..  ) at %7.4r  %M\n", $abstime );
        VGD_retc=1;
        VGD_cnt=VGD_cnt-1;
        $fclose(outfile);
      end
   end
   else
   begin
      if(VGD_cnt==0)
      begin
        outfile=$fopen(errFileName,"a");
        $strobe("phvrd         VGD     error limit ( %d ) reached at %7.4r  %M", maxEv, $abstime );
        $fwrite(outfile,"phvrd         VGD     error limit ( %d ) reached at %7.4r  %M\n", maxEv, $abstime );
        VGD_cnt=VGD_cnt-1;
        $fclose(outfile);
      end
   end

//      VDS
   VDS = V_D_S;
   if((VDS_cnt>0) || ( maxEv_flg==0 ))   begin
      if( (VDS < -85) && (VDS_retc!=-1))
      begin
        outfile=$fopen(errFileName,"a");
        $strobe("phvrd         VDS     leaving   OCA (  .. -85.000 V ) at %7.4r  %M", $abstime );
        $fwrite(outfile,"phvrd         VDS     leaving   OCA (  .. -85.000 V ) at %7.4r  %M\n", $abstime );
        VDS_retc=-1;
        VDS_cnt=VDS_cnt-1;
        $fclose(outfile);
      end
      if((VDS >= -85) &&  (VDS <= 1.5) && (VDS_retc!=0))
      begin
        outfile=$fopen(errFileName,"a");
        $strobe("phvrd         VDS     entering SOCA ( -85.000 V .. 1.500 V ) at %7.4r  %M", $abstime );
        $fwrite(outfile,"phvrd         VDS     entering SOCA ( -85.000 V .. 1.500 V ) at %7.4r  %M\n", $abstime );
        VDS_retc=0;
        VDS_cnt=VDS_cnt-1;
        $fclose(outfile);
      end
      if((VDS > 1.5) &&  (VDS_retc!=1))
      begin
        outfile=$fopen(errFileName,"a");
        $strobe("phvrd         VDS     leaving   OCA ( 1.500 V ..  ) at %7.4r  %M", $abstime );
        $fwrite(outfile,"phvrd         VDS     leaving   OCA ( 1.500 V ..  ) at %7.4r  %M\n", $abstime );
        VDS_retc=1;
        VDS_cnt=VDS_cnt-1;
        $fclose(outfile);
      end
   end
   else
   begin
      if(VDS_cnt==0)
      begin
        outfile=$fopen(errFileName,"a");
        $strobe("phvrd         VDS     error limit ( %d ) reached at %7.4r  %M", maxEv, $abstime );
        $fwrite(outfile,"phvrd         VDS     error limit ( %d ) reached at %7.4r  %M\n", maxEv, $abstime );
        VDS_cnt=VDS_cnt-1;
        $fclose(outfile);
      end
   end

//      VDB
   VDB = V_D_B;
   if((VDB_cnt>0) || ( maxEv_flg==0 ))   begin
      if( (VDB < -85) && (VDB_retc!=-1))
      begin
        outfile=$fopen(errFileName,"a");
        $strobe("phvrd         VDB     leaving   OCA (  .. -85.000 V ) at %7.4r  %M", $abstime );
        $fwrite(outfile,"phvrd         VDB     leaving   OCA (  .. -85.000 V ) at %7.4r  %M\n", $abstime );
        VDB_retc=-1;
        VDB_cnt=VDB_cnt-1;
        $fclose(outfile);
      end
      if((VDB >= -85) &&  (VDB <= 1.5) && (VDB_retc!=0))
      begin
        outfile=$fopen(errFileName,"a");
        $strobe("phvrd         VDB     entering SOCA ( -85.000 V .. 1.500 V ) at %7.4r  %M", $abstime );
        $fwrite(outfile,"phvrd         VDB     entering SOCA ( -85.000 V .. 1.500 V ) at %7.4r  %M\n", $abstime );
        VDB_retc=0;
        VDB_cnt=VDB_cnt-1;
        $fclose(outfile);
      end
      if((VDB > 1.5) &&  (VDB_retc!=1))
      begin
        outfile=$fopen(errFileName,"a");
        $strobe("phvrd         VDB     leaving   OCA ( 1.500 V ..  ) at %7.4r  %M", $abstime );
        $fwrite(outfile,"phvrd         VDB     leaving   OCA ( 1.500 V ..  ) at %7.4r  %M\n", $abstime );
        VDB_retc=1;
        VDB_cnt=VDB_cnt-1;
        $fclose(outfile);
      end
   end
   else
   begin
      if(VDB_cnt==0)
      begin
        outfile=$fopen(errFileName,"a");
        $strobe("phvrd         VDB     error limit ( %d ) reached at %7.4r  %M", maxEv, $abstime );
        $fwrite(outfile,"phvrd         VDB     error limit ( %d ) reached at %7.4r  %M\n", maxEv, $abstime );
        VDB_cnt=VDB_cnt-1;
        $fclose(outfile);
      end
   end

//      VDHW
   VDHW = V_D_HW;
   if((VDHW_cnt>0) || ( maxEv_flg==0 ))   begin
      if( (VDHW < -25) && (VDHW_retc!=-1))
      begin
        outfile=$fopen(errFileName,"a");
        $strobe("phvrd         VDHW    leaving   OCA (  .. -25.000 V ) at %7.4r  %M", $abstime );
        $fwrite(outfile,"phvrd         VDHW    leaving   OCA (  .. -25.000 V ) at %7.4r  %M\n", $abstime );
        VDHW_retc=-1;
        VDHW_cnt=VDHW_cnt-1;
        $fclose(outfile);
      end
      if((VDHW >= -25) &&  (VDHW <= 125) && (VDHW_retc!=0))
      begin
        outfile=$fopen(errFileName,"a");
        $strobe("phvrd         VDHW    entering SOCA ( -25.000 V .. 125.000 V ) at %7.4r  %M", $abstime );
        $fwrite(outfile,"phvrd         VDHW    entering SOCA ( -25.000 V .. 125.000 V ) at %7.4r  %M\n", $abstime );
        VDHW_retc=0;
        VDHW_cnt=VDHW_cnt-1;
        $fclose(outfile);
      end
      if((VDHW > 125) &&  (VDHW_retc!=1))
      begin
        outfile=$fopen(errFileName,"a");
        $strobe("phvrd         VDHW    leaving   OCA ( 125.000 V ..  ) at %7.4r  %M", $abstime );
        $fwrite(outfile,"phvrd         VDHW    leaving   OCA ( 125.000 V ..  ) at %7.4r  %M\n", $abstime );
        VDHW_retc=1;
        VDHW_cnt=VDHW_cnt-1;
        $fclose(outfile);
      end
   end
   else
   begin
      if(VDHW_cnt==0)
      begin
        outfile=$fopen(errFileName,"a");
        $strobe("phvrd         VDHW    error limit ( %d ) reached at %7.4r  %M", maxEv, $abstime );
        $fwrite(outfile,"phvrd         VDHW    error limit ( %d ) reached at %7.4r  %M\n", maxEv, $abstime );
        VDHW_cnt=VDHW_cnt-1;
        $fclose(outfile);
      end
   end

//      VBHW
   VBHW = V_B_HW;
   if((VBHW_cnt>0) || ( maxEv_flg==0 ))   begin
      if( (VBHW < -25) && (VBHW_retc!=-1))
      begin
        outfile=$fopen(errFileName,"a");
        $strobe("phvrd         VBHW    leaving   OCA (  .. -25.000 V ) at %7.4r  %M", $abstime );
        $fwrite(outfile,"phvrd         VBHW    leaving   OCA (  .. -25.000 V ) at %7.4r  %M\n", $abstime );
        VBHW_retc=-1;
        VBHW_cnt=VBHW_cnt-1;
        $fclose(outfile);
      end
      if((VBHW >= -25) &&  (VBHW <= 125) && (VBHW_retc!=0))
      begin
        outfile=$fopen(errFileName,"a");
        $strobe("phvrd         VBHW    entering SOCA ( -25.000 V .. 125.000 V ) at %7.4r  %M", $abstime );
        $fwrite(outfile,"phvrd         VBHW    entering SOCA ( -25.000 V .. 125.000 V ) at %7.4r  %M\n", $abstime );
        VBHW_retc=0;
        VBHW_cnt=VBHW_cnt-1;
        $fclose(outfile);
      end
      if((VBHW > 125) &&  (VBHW_retc!=1))
      begin
        outfile=$fopen(errFileName,"a");
        $strobe("phvrd         VBHW    leaving   OCA ( 125.000 V ..  ) at %7.4r  %M", $abstime );
        $fwrite(outfile,"phvrd         VBHW    leaving   OCA ( 125.000 V ..  ) at %7.4r  %M\n", $abstime );
        VBHW_retc=1;
        VBHW_cnt=VBHW_cnt-1;
        $fclose(outfile);
      end
   end
   else
   begin
      if(VBHW_cnt==0)
      begin
        outfile=$fopen(errFileName,"a");
        $strobe("phvrd         VBHW    error limit ( %d ) reached at %7.4r  %M", maxEv, $abstime );
        $fwrite(outfile,"phvrd         VBHW    error limit ( %d ) reached at %7.4r  %M\n", maxEv, $abstime );
        VBHW_cnt=VBHW_cnt-1;
        $fclose(outfile);
      end
   end

end // analog
endmodule // phvrd

// Verilog-A OC Watch for device phvre Parameters  VGS VGD VDS VDB VDHW VBHW
module phvre_ahdl(D,G,S,B,HW);
parameter tstep_occ=100n;
parameter errFileName="./occ.err";
parameter maxEv = 25;
parameter maxEv_flg = 0;
inout D,G,S,B,HW;
electrical D,G,S,B,HW;

integer outfile;
real V_B_HW;
real V_D_HW;
real V_D_B;
real V_D_S;
real V_G_D;
real V_G_S;
real VGS;
integer VGS_retc;
integer VGS_cnt;
real VGD;
integer VGD_retc;
integer VGD_cnt;
real VDS;
integer VDS_retc;
integer VDS_cnt;
real VDB;
integer VDB_retc;
integer VDB_cnt;
real VDHW;
integer VDHW_retc;
integer VDHW_cnt;
real VBHW;
integer VBHW_retc;
integer VBHW_cnt;

analog begin
   $bound_step( tstep_occ );
   @(initial_step) begin
      VGS_retc=0;
      VGS_cnt = maxEv;
      VGD_retc=0;
      VGD_cnt = maxEv;
      VDS_retc=0;
      VDS_cnt = maxEv;
      VDB_retc=0;
      VDB_cnt = maxEv;
      VDHW_retc=0;
      VDHW_cnt = maxEv;
      VBHW_retc=0;
      VBHW_cnt = maxEv;
   end
   V_B_HW = V(B,HW);
   V_D_HW = V(D,HW);
   V_D_B = V(D,B);
   V_D_S = V(D,S);
   V_G_D = V(G,D);
   V_G_S = V(G,S);

//      VGS
   VGS = V_G_S;
   if((VGS_cnt>0) || ( maxEv_flg==0 ))   begin
      if( (VGS < -5.5) && (VGS_retc!=-1))
      begin
        outfile=$fopen(errFileName,"a");
        $strobe("phvre         VGS     leaving   OCA (  .. -5.500 V ) at %7.4r  %M", $abstime );
        $fwrite(outfile,"phvre         VGS     leaving   OCA (  .. -5.500 V ) at %7.4r  %M\n", $abstime );
        VGS_retc=-1;
        VGS_cnt=VGS_cnt-1;
        $fclose(outfile);
      end
      if((VGS >= -5.5) &&  (VGS <= 5.5) && (VGS_retc!=0))
      begin
        outfile=$fopen(errFileName,"a");
        $strobe("phvre         VGS     entering SOCA ( -5.500 V .. 5.500 V ) at %7.4r  %M", $abstime );
        $fwrite(outfile,"phvre         VGS     entering SOCA ( -5.500 V .. 5.500 V ) at %7.4r  %M\n", $abstime );
        VGS_retc=0;
        VGS_cnt=VGS_cnt-1;
        $fclose(outfile);
      end
      if((VGS > 5.5) &&  (VGS_retc!=1))
      begin
        outfile=$fopen(errFileName,"a");
        $strobe("phvre         VGS     leaving   OCA ( 5.500 V ..  ) at %7.4r  %M", $abstime );
        $fwrite(outfile,"phvre         VGS     leaving   OCA ( 5.500 V ..  ) at %7.4r  %M\n", $abstime );
        VGS_retc=1;
        VGS_cnt=VGS_cnt-1;
        $fclose(outfile);
      end
   end
   else
   begin
      if(VGS_cnt==0)
      begin
        outfile=$fopen(errFileName,"a");
        $strobe("phvre         VGS     error limit ( %d ) reached at %7.4r  %M", maxEv, $abstime );
        $fwrite(outfile,"phvre         VGS     error limit ( %d ) reached at %7.4r  %M\n", maxEv, $abstime );
        VGS_cnt=VGS_cnt-1;
        $fclose(outfile);
      end
   end

//      VGD
   VGD = V_G_D;
   if((VGD_cnt>0) || ( maxEv_flg==0 ))   begin
      if( (VGD < -5.5) && (VGD_retc!=-1))
      begin
        outfile=$fopen(errFileName,"a");
        $strobe("phvre         VGD     leaving   OCA (  .. -5.500 V ) at %7.4r  %M", $abstime );
        $fwrite(outfile,"phvre         VGD     leaving   OCA (  .. -5.500 V ) at %7.4r  %M\n", $abstime );
        VGD_retc=-1;
        VGD_cnt=VGD_cnt-1;
        $fclose(outfile);
      end
      if((VGD >= -5.5) &&  (VGD <= 100) && (VGD_retc!=0))
      begin
        outfile=$fopen(errFileName,"a");
        $strobe("phvre         VGD     entering SOCA ( -5.500 V .. 100.000 V ) at %7.4r  %M", $abstime );
        $fwrite(outfile,"phvre         VGD     entering SOCA ( -5.500 V .. 100.000 V ) at %7.4r  %M\n", $abstime );
        VGD_retc=0;
        VGD_cnt=VGD_cnt-1;
        $fclose(outfile);
      end
      if((VGD > 100) &&  (VGD_retc!=1))
      begin
        outfile=$fopen(errFileName,"a");
        $strobe("phvre         VGD     leaving   OCA ( 100.000 V ..  ) at %7.4r  %M", $abstime );
        $fwrite(outfile,"phvre         VGD     leaving   OCA ( 100.000 V ..  ) at %7.4r  %M\n", $abstime );
        VGD_retc=1;
        VGD_cnt=VGD_cnt-1;
        $fclose(outfile);
      end
   end
   else
   begin
      if(VGD_cnt==0)
      begin
        outfile=$fopen(errFileName,"a");
        $strobe("phvre         VGD     error limit ( %d ) reached at %7.4r  %M", maxEv, $abstime );
        $fwrite(outfile,"phvre         VGD     error limit ( %d ) reached at %7.4r  %M\n", maxEv, $abstime );
        VGD_cnt=VGD_cnt-1;
        $fclose(outfile);
      end
   end

//      VDS
   VDS = V_D_S;
   if((VDS_cnt>0) || ( maxEv_flg==0 ))   begin
      if( (VDS < -100) && (VDS_retc!=-1))
      begin
        outfile=$fopen(errFileName,"a");
        $strobe("phvre         VDS     leaving   OCA (  .. -100.000 V ) at %7.4r  %M", $abstime );
        $fwrite(outfile,"phvre         VDS     leaving   OCA (  .. -100.000 V ) at %7.4r  %M\n", $abstime );
        VDS_retc=-1;
        VDS_cnt=VDS_cnt-1;
        $fclose(outfile);
      end
      if((VDS >= -100) &&  (VDS <= 1.5) && (VDS_retc!=0))
      begin
        outfile=$fopen(errFileName,"a");
        $strobe("phvre         VDS     entering SOCA ( -100.000 V .. 1.500 V ) at %7.4r  %M", $abstime );
        $fwrite(outfile,"phvre         VDS     entering SOCA ( -100.000 V .. 1.500 V ) at %7.4r  %M\n", $abstime );
        VDS_retc=0;
        VDS_cnt=VDS_cnt-1;
        $fclose(outfile);
      end
      if((VDS > 1.5) &&  (VDS_retc!=1))
      begin
        outfile=$fopen(errFileName,"a");
        $strobe("phvre         VDS     leaving   OCA ( 1.500 V ..  ) at %7.4r  %M", $abstime );
        $fwrite(outfile,"phvre         VDS     leaving   OCA ( 1.500 V ..  ) at %7.4r  %M\n", $abstime );
        VDS_retc=1;
        VDS_cnt=VDS_cnt-1;
        $fclose(outfile);
      end
   end
   else
   begin
      if(VDS_cnt==0)
      begin
        outfile=$fopen(errFileName,"a");
        $strobe("phvre         VDS     error limit ( %d ) reached at %7.4r  %M", maxEv, $abstime );
        $fwrite(outfile,"phvre         VDS     error limit ( %d ) reached at %7.4r  %M\n", maxEv, $abstime );
        VDS_cnt=VDS_cnt-1;
        $fclose(outfile);
      end
   end

//      VDB
   VDB = V_D_B;
   if((VDB_cnt>0) || ( maxEv_flg==0 ))   begin
      if( (VDB < -100) && (VDB_retc!=-1))
      begin
        outfile=$fopen(errFileName,"a");
        $strobe("phvre         VDB     leaving   OCA (  .. -100.000 V ) at %7.4r  %M", $abstime );
        $fwrite(outfile,"phvre         VDB     leaving   OCA (  .. -100.000 V ) at %7.4r  %M\n", $abstime );
        VDB_retc=-1;
        VDB_cnt=VDB_cnt-1;
        $fclose(outfile);
      end
      if((VDB >= -100) &&  (VDB <= 1.5) && (VDB_retc!=0))
      begin
        outfile=$fopen(errFileName,"a");
        $strobe("phvre         VDB     entering SOCA ( -100.000 V .. 1.500 V ) at %7.4r  %M", $abstime );
        $fwrite(outfile,"phvre         VDB     entering SOCA ( -100.000 V .. 1.500 V ) at %7.4r  %M\n", $abstime );
        VDB_retc=0;
        VDB_cnt=VDB_cnt-1;
        $fclose(outfile);
      end
      if((VDB > 1.5) &&  (VDB_retc!=1))
      begin
        outfile=$fopen(errFileName,"a");
        $strobe("phvre         VDB     leaving   OCA ( 1.500 V ..  ) at %7.4r  %M", $abstime );
        $fwrite(outfile,"phvre         VDB     leaving   OCA ( 1.500 V ..  ) at %7.4r  %M\n", $abstime );
        VDB_retc=1;
        VDB_cnt=VDB_cnt-1;
        $fclose(outfile);
      end
   end
   else
   begin
      if(VDB_cnt==0)
      begin
        outfile=$fopen(errFileName,"a");
        $strobe("phvre         VDB     error limit ( %d ) reached at %7.4r  %M", maxEv, $abstime );
        $fwrite(outfile,"phvre         VDB     error limit ( %d ) reached at %7.4r  %M\n", maxEv, $abstime );
        VDB_cnt=VDB_cnt-1;
        $fclose(outfile);
      end
   end

//      VDHW
   VDHW = V_D_HW;
   if((VDHW_cnt>0) || ( maxEv_flg==0 ))   begin
      if( (VDHW < -25) && (VDHW_retc!=-1))
      begin
        outfile=$fopen(errFileName,"a");
        $strobe("phvre         VDHW    leaving   OCA (  .. -25.000 V ) at %7.4r  %M", $abstime );
        $fwrite(outfile,"phvre         VDHW    leaving   OCA (  .. -25.000 V ) at %7.4r  %M\n", $abstime );
        VDHW_retc=-1;
        VDHW_cnt=VDHW_cnt-1;
        $fclose(outfile);
      end
      if((VDHW >= -25) &&  (VDHW <= 125) && (VDHW_retc!=0))
      begin
        outfile=$fopen(errFileName,"a");
        $strobe("phvre         VDHW    entering SOCA ( -25.000 V .. 125.000 V ) at %7.4r  %M", $abstime );
        $fwrite(outfile,"phvre         VDHW    entering SOCA ( -25.000 V .. 125.000 V ) at %7.4r  %M\n", $abstime );
        VDHW_retc=0;
        VDHW_cnt=VDHW_cnt-1;
        $fclose(outfile);
      end
      if((VDHW > 125) &&  (VDHW_retc!=1))
      begin
        outfile=$fopen(errFileName,"a");
        $strobe("phvre         VDHW    leaving   OCA ( 125.000 V ..  ) at %7.4r  %M", $abstime );
        $fwrite(outfile,"phvre         VDHW    leaving   OCA ( 125.000 V ..  ) at %7.4r  %M\n", $abstime );
        VDHW_retc=1;
        VDHW_cnt=VDHW_cnt-1;
        $fclose(outfile);
      end
   end
   else
   begin
      if(VDHW_cnt==0)
      begin
        outfile=$fopen(errFileName,"a");
        $strobe("phvre         VDHW    error limit ( %d ) reached at %7.4r  %M", maxEv, $abstime );
        $fwrite(outfile,"phvre         VDHW    error limit ( %d ) reached at %7.4r  %M\n", maxEv, $abstime );
        VDHW_cnt=VDHW_cnt-1;
        $fclose(outfile);
      end
   end

//      VBHW
   VBHW = V_B_HW;
   if((VBHW_cnt>0) || ( maxEv_flg==0 ))   begin
      if( (VBHW < -25) && (VBHW_retc!=-1))
      begin
        outfile=$fopen(errFileName,"a");
        $strobe("phvre         VBHW    leaving   OCA (  .. -25.000 V ) at %7.4r  %M", $abstime );
        $fwrite(outfile,"phvre         VBHW    leaving   OCA (  .. -25.000 V ) at %7.4r  %M\n", $abstime );
        VBHW_retc=-1;
        VBHW_cnt=VBHW_cnt-1;
        $fclose(outfile);
      end
      if((VBHW >= -25) &&  (VBHW <= 125) && (VBHW_retc!=0))
      begin
        outfile=$fopen(errFileName,"a");
        $strobe("phvre         VBHW    entering SOCA ( -25.000 V .. 125.000 V ) at %7.4r  %M", $abstime );
        $fwrite(outfile,"phvre         VBHW    entering SOCA ( -25.000 V .. 125.000 V ) at %7.4r  %M\n", $abstime );
        VBHW_retc=0;
        VBHW_cnt=VBHW_cnt-1;
        $fclose(outfile);
      end
      if((VBHW > 125) &&  (VBHW_retc!=1))
      begin
        outfile=$fopen(errFileName,"a");
        $strobe("phvre         VBHW    leaving   OCA ( 125.000 V ..  ) at %7.4r  %M", $abstime );
        $fwrite(outfile,"phvre         VBHW    leaving   OCA ( 125.000 V ..  ) at %7.4r  %M\n", $abstime );
        VBHW_retc=1;
        VBHW_cnt=VBHW_cnt-1;
        $fclose(outfile);
      end
   end
   else
   begin
      if(VBHW_cnt==0)
      begin
        outfile=$fopen(errFileName,"a");
        $strobe("phvre         VBHW    error limit ( %d ) reached at %7.4r  %M", maxEv, $abstime );
        $fwrite(outfile,"phvre         VBHW    error limit ( %d ) reached at %7.4r  %M\n", maxEv, $abstime );
        VBHW_cnt=VBHW_cnt-1;
        $fclose(outfile);
      end
   end

end // analog
endmodule // phvre

// Verilog-A OC Watch for device phvrf Parameters  VGS VGD VDS VDB VDHW VBHW
module phvrf_ahdl(D,G,S,B,HW);
parameter tstep_occ=100n;
parameter errFileName="./occ.err";
parameter maxEv = 25;
parameter maxEv_flg = 0;
inout D,G,S,B,HW;
electrical D,G,S,B,HW;

integer outfile;
real V_B_HW;
real V_D_HW;
real V_D_B;
real V_D_S;
real V_G_D;
real V_G_S;
real VGS;
integer VGS_retc;
integer VGS_cnt;
real VGD;
integer VGD_retc;
integer VGD_cnt;
real VDS;
integer VDS_retc;
integer VDS_cnt;
real VDB;
integer VDB_retc;
integer VDB_cnt;
real VDHW;
integer VDHW_retc;
integer VDHW_cnt;
real VBHW;
integer VBHW_retc;
integer VBHW_cnt;

analog begin
   $bound_step( tstep_occ );
   @(initial_step) begin
      VGS_retc=0;
      VGS_cnt = maxEv;
      VGD_retc=0;
      VGD_cnt = maxEv;
      VDS_retc=0;
      VDS_cnt = maxEv;
      VDB_retc=0;
      VDB_cnt = maxEv;
      VDHW_retc=0;
      VDHW_cnt = maxEv;
      VBHW_retc=0;
      VBHW_cnt = maxEv;
   end
   V_B_HW = V(B,HW);
   V_D_HW = V(D,HW);
   V_D_B = V(D,B);
   V_D_S = V(D,S);
   V_G_D = V(G,D);
   V_G_S = V(G,S);

//      VGS
   VGS = V_G_S;
   if((VGS_cnt>0) || ( maxEv_flg==0 ))   begin
      if( (VGS < -5.5) && (VGS_retc!=-1))
      begin
        outfile=$fopen(errFileName,"a");
        $strobe("phvrf         VGS     leaving   OCA (  .. -5.500 V ) at %7.4r  %M", $abstime );
        $fwrite(outfile,"phvrf         VGS     leaving   OCA (  .. -5.500 V ) at %7.4r  %M\n", $abstime );
        VGS_retc=-1;
        VGS_cnt=VGS_cnt-1;
        $fclose(outfile);
      end
      if((VGS >= -5.5) &&  (VGS <= 5.5) && (VGS_retc!=0))
      begin
        outfile=$fopen(errFileName,"a");
        $strobe("phvrf         VGS     entering SOCA ( -5.500 V .. 5.500 V ) at %7.4r  %M", $abstime );
        $fwrite(outfile,"phvrf         VGS     entering SOCA ( -5.500 V .. 5.500 V ) at %7.4r  %M\n", $abstime );
        VGS_retc=0;
        VGS_cnt=VGS_cnt-1;
        $fclose(outfile);
      end
      if((VGS > 5.5) &&  (VGS_retc!=1))
      begin
        outfile=$fopen(errFileName,"a");
        $strobe("phvrf         VGS     leaving   OCA ( 5.500 V ..  ) at %7.4r  %M", $abstime );
        $fwrite(outfile,"phvrf         VGS     leaving   OCA ( 5.500 V ..  ) at %7.4r  %M\n", $abstime );
        VGS_retc=1;
        VGS_cnt=VGS_cnt-1;
        $fclose(outfile);
      end
   end
   else
   begin
      if(VGS_cnt==0)
      begin
        outfile=$fopen(errFileName,"a");
        $strobe("phvrf         VGS     error limit ( %d ) reached at %7.4r  %M", maxEv, $abstime );
        $fwrite(outfile,"phvrf         VGS     error limit ( %d ) reached at %7.4r  %M\n", maxEv, $abstime );
        VGS_cnt=VGS_cnt-1;
        $fclose(outfile);
      end
   end

//      VGD
   VGD = V_G_D;
   if((VGD_cnt>0) || ( maxEv_flg==0 ))   begin
      if( (VGD < -5.5) && (VGD_retc!=-1))
      begin
        outfile=$fopen(errFileName,"a");
        $strobe("phvrf         VGD     leaving   OCA (  .. -5.500 V ) at %7.4r  %M", $abstime );
        $fwrite(outfile,"phvrf         VGD     leaving   OCA (  .. -5.500 V ) at %7.4r  %M\n", $abstime );
        VGD_retc=-1;
        VGD_cnt=VGD_cnt-1;
        $fclose(outfile);
      end
      if((VGD >= -5.5) &&  (VGD <= 125) && (VGD_retc!=0))
      begin
        outfile=$fopen(errFileName,"a");
        $strobe("phvrf         VGD     entering SOCA ( -5.500 V .. 125.000 V ) at %7.4r  %M", $abstime );
        $fwrite(outfile,"phvrf         VGD     entering SOCA ( -5.500 V .. 125.000 V ) at %7.4r  %M\n", $abstime );
        VGD_retc=0;
        VGD_cnt=VGD_cnt-1;
        $fclose(outfile);
      end
      if((VGD > 125) &&  (VGD_retc!=1))
      begin
        outfile=$fopen(errFileName,"a");
        $strobe("phvrf         VGD     leaving   OCA ( 125.000 V ..  ) at %7.4r  %M", $abstime );
        $fwrite(outfile,"phvrf         VGD     leaving   OCA ( 125.000 V ..  ) at %7.4r  %M\n", $abstime );
        VGD_retc=1;
        VGD_cnt=VGD_cnt-1;
        $fclose(outfile);
      end
   end
   else
   begin
      if(VGD_cnt==0)
      begin
        outfile=$fopen(errFileName,"a");
        $strobe("phvrf         VGD     error limit ( %d ) reached at %7.4r  %M", maxEv, $abstime );
        $fwrite(outfile,"phvrf         VGD     error limit ( %d ) reached at %7.4r  %M\n", maxEv, $abstime );
        VGD_cnt=VGD_cnt-1;
        $fclose(outfile);
      end
   end

//      VDS
   VDS = V_D_S;
   if((VDS_cnt>0) || ( maxEv_flg==0 ))   begin
      if( (VDS < -125) && (VDS_retc!=-1))
      begin
        outfile=$fopen(errFileName,"a");
        $strobe("phvrf         VDS     leaving   OCA (  .. -125.000 V ) at %7.4r  %M", $abstime );
        $fwrite(outfile,"phvrf         VDS     leaving   OCA (  .. -125.000 V ) at %7.4r  %M\n", $abstime );
        VDS_retc=-1;
        VDS_cnt=VDS_cnt-1;
        $fclose(outfile);
      end
      if((VDS >= -125) &&  (VDS <= 1.5) && (VDS_retc!=0))
      begin
        outfile=$fopen(errFileName,"a");
        $strobe("phvrf         VDS     entering SOCA ( -125.000 V .. 1.500 V ) at %7.4r  %M", $abstime );
        $fwrite(outfile,"phvrf         VDS     entering SOCA ( -125.000 V .. 1.500 V ) at %7.4r  %M\n", $abstime );
        VDS_retc=0;
        VDS_cnt=VDS_cnt-1;
        $fclose(outfile);
      end
      if((VDS > 1.5) &&  (VDS_retc!=1))
      begin
        outfile=$fopen(errFileName,"a");
        $strobe("phvrf         VDS     leaving   OCA ( 1.500 V ..  ) at %7.4r  %M", $abstime );
        $fwrite(outfile,"phvrf         VDS     leaving   OCA ( 1.500 V ..  ) at %7.4r  %M\n", $abstime );
        VDS_retc=1;
        VDS_cnt=VDS_cnt-1;
        $fclose(outfile);
      end
   end
   else
   begin
      if(VDS_cnt==0)
      begin
        outfile=$fopen(errFileName,"a");
        $strobe("phvrf         VDS     error limit ( %d ) reached at %7.4r  %M", maxEv, $abstime );
        $fwrite(outfile,"phvrf         VDS     error limit ( %d ) reached at %7.4r  %M\n", maxEv, $abstime );
        VDS_cnt=VDS_cnt-1;
        $fclose(outfile);
      end
   end

//      VDB
   VDB = V_D_B;
   if((VDB_cnt>0) || ( maxEv_flg==0 ))   begin
      if( (VDB < -125) && (VDB_retc!=-1))
      begin
        outfile=$fopen(errFileName,"a");
        $strobe("phvrf         VDB     leaving   OCA (  .. -125.000 V ) at %7.4r  %M", $abstime );
        $fwrite(outfile,"phvrf         VDB     leaving   OCA (  .. -125.000 V ) at %7.4r  %M\n", $abstime );
        VDB_retc=-1;
        VDB_cnt=VDB_cnt-1;
        $fclose(outfile);
      end
      if((VDB >= -125) &&  (VDB <= 1.5) && (VDB_retc!=0))
      begin
        outfile=$fopen(errFileName,"a");
        $strobe("phvrf         VDB     entering SOCA ( -125.000 V .. 1.500 V ) at %7.4r  %M", $abstime );
        $fwrite(outfile,"phvrf         VDB     entering SOCA ( -125.000 V .. 1.500 V ) at %7.4r  %M\n", $abstime );
        VDB_retc=0;
        VDB_cnt=VDB_cnt-1;
        $fclose(outfile);
      end
      if((VDB > 1.5) &&  (VDB_retc!=1))
      begin
        outfile=$fopen(errFileName,"a");
        $strobe("phvrf         VDB     leaving   OCA ( 1.500 V ..  ) at %7.4r  %M", $abstime );
        $fwrite(outfile,"phvrf         VDB     leaving   OCA ( 1.500 V ..  ) at %7.4r  %M\n", $abstime );
        VDB_retc=1;
        VDB_cnt=VDB_cnt-1;
        $fclose(outfile);
      end
   end
   else
   begin
      if(VDB_cnt==0)
      begin
        outfile=$fopen(errFileName,"a");
        $strobe("phvrf         VDB     error limit ( %d ) reached at %7.4r  %M", maxEv, $abstime );
        $fwrite(outfile,"phvrf         VDB     error limit ( %d ) reached at %7.4r  %M\n", maxEv, $abstime );
        VDB_cnt=VDB_cnt-1;
        $fclose(outfile);
      end
   end

//      VDHW
   VDHW = V_D_HW;
   if((VDHW_cnt>0) || ( maxEv_flg==0 ))   begin
      if( (VDHW < -25) && (VDHW_retc!=-1))
      begin
        outfile=$fopen(errFileName,"a");
        $strobe("phvrf         VDHW    leaving   OCA (  .. -25.000 V ) at %7.4r  %M", $abstime );
        $fwrite(outfile,"phvrf         VDHW    leaving   OCA (  .. -25.000 V ) at %7.4r  %M\n", $abstime );
        VDHW_retc=-1;
        VDHW_cnt=VDHW_cnt-1;
        $fclose(outfile);
      end
      if((VDHW >= -25) &&  (VDHW <= 125) && (VDHW_retc!=0))
      begin
        outfile=$fopen(errFileName,"a");
        $strobe("phvrf         VDHW    entering SOCA ( -25.000 V .. 125.000 V ) at %7.4r  %M", $abstime );
        $fwrite(outfile,"phvrf         VDHW    entering SOCA ( -25.000 V .. 125.000 V ) at %7.4r  %M\n", $abstime );
        VDHW_retc=0;
        VDHW_cnt=VDHW_cnt-1;
        $fclose(outfile);
      end
      if((VDHW > 125) &&  (VDHW_retc!=1))
      begin
        outfile=$fopen(errFileName,"a");
        $strobe("phvrf         VDHW    leaving   OCA ( 125.000 V ..  ) at %7.4r  %M", $abstime );
        $fwrite(outfile,"phvrf         VDHW    leaving   OCA ( 125.000 V ..  ) at %7.4r  %M\n", $abstime );
        VDHW_retc=1;
        VDHW_cnt=VDHW_cnt-1;
        $fclose(outfile);
      end
   end
   else
   begin
      if(VDHW_cnt==0)
      begin
        outfile=$fopen(errFileName,"a");
        $strobe("phvrf         VDHW    error limit ( %d ) reached at %7.4r  %M", maxEv, $abstime );
        $fwrite(outfile,"phvrf         VDHW    error limit ( %d ) reached at %7.4r  %M\n", maxEv, $abstime );
        VDHW_cnt=VDHW_cnt-1;
        $fclose(outfile);
      end
   end

//      VBHW
   VBHW = V_B_HW;
   if((VBHW_cnt>0) || ( maxEv_flg==0 ))   begin
      if( (VBHW < -25) && (VBHW_retc!=-1))
      begin
        outfile=$fopen(errFileName,"a");
        $strobe("phvrf         VBHW    leaving   OCA (  .. -25.000 V ) at %7.4r  %M", $abstime );
        $fwrite(outfile,"phvrf         VBHW    leaving   OCA (  .. -25.000 V ) at %7.4r  %M\n", $abstime );
        VBHW_retc=-1;
        VBHW_cnt=VBHW_cnt-1;
        $fclose(outfile);
      end
      if((VBHW >= -25) &&  (VBHW <= 125) && (VBHW_retc!=0))
      begin
        outfile=$fopen(errFileName,"a");
        $strobe("phvrf         VBHW    entering SOCA ( -25.000 V .. 125.000 V ) at %7.4r  %M", $abstime );
        $fwrite(outfile,"phvrf         VBHW    entering SOCA ( -25.000 V .. 125.000 V ) at %7.4r  %M\n", $abstime );
        VBHW_retc=0;
        VBHW_cnt=VBHW_cnt-1;
        $fclose(outfile);
      end
      if((VBHW > 125) &&  (VBHW_retc!=1))
      begin
        outfile=$fopen(errFileName,"a");
        $strobe("phvrf         VBHW    leaving   OCA ( 125.000 V ..  ) at %7.4r  %M", $abstime );
        $fwrite(outfile,"phvrf         VBHW    leaving   OCA ( 125.000 V ..  ) at %7.4r  %M\n", $abstime );
        VBHW_retc=1;
        VBHW_cnt=VBHW_cnt-1;
        $fclose(outfile);
      end
   end
   else
   begin
      if(VBHW_cnt==0)
      begin
        outfile=$fopen(errFileName,"a");
        $strobe("phvrf         VBHW    error limit ( %d ) reached at %7.4r  %M", maxEv, $abstime );
        $fwrite(outfile,"phvrf         VBHW    error limit ( %d ) reached at %7.4r  %M\n", maxEv, $abstime );
        VBHW_cnt=VBHW_cnt-1;
        $fclose(outfile);
      end
   end

end // analog
endmodule // phvrf

// Verilog-A OC Watch for device nhsj1_7 Parameters  VGS VGD VDS VDB VSB VDHW
module nhsj1_7_ahdl(D,G,S,B,HW);
parameter tstep_occ=100n;
parameter errFileName="./occ.err";
parameter maxEv = 25;
parameter maxEv_flg = 0;
inout D,G,S,B,HW;
electrical D,G,S,B,HW;

integer outfile;
real V_D_HW;
real V_S_B;
real V_D_B;
real V_D_S;
real V_G_D;
real V_G_S;
real VGS;
integer VGS_retc;
integer VGS_cnt;
real VGD;
integer VGD_retc;
integer VGD_cnt;
real VDS;
integer VDS_retc;
integer VDS_cnt;
real VDB;
integer VDB_retc;
integer VDB_cnt;
real VSB;
integer VSB_retc;
integer VSB_cnt;
real VDHW;
integer VDHW_retc;
integer VDHW_cnt;

analog begin
   $bound_step( tstep_occ );
   @(initial_step) begin
      VGS_retc=0;
      VGS_cnt = maxEv;
      VGD_retc=0;
      VGD_cnt = maxEv;
      VDS_retc=0;
      VDS_cnt = maxEv;
      VDB_retc=0;
      VDB_cnt = maxEv;
      VSB_retc=0;
      VSB_cnt = maxEv;
      VDHW_retc=0;
      VDHW_cnt = maxEv;
   end
   V_D_HW = V(D,HW);
   V_S_B = V(S,B);
   V_D_B = V(D,B);
   V_D_S = V(D,S);
   V_G_D = V(G,D);
   V_G_S = V(G,S);

//      VGS
   VGS = V_G_S;
   if((VGS_cnt>0) || ( maxEv_flg==0 ))   begin
      if( (VGS < -5.5) && (VGS_retc!=-1))
      begin
        outfile=$fopen(errFileName,"a");
        $strobe("nhsj1_7       VGS     leaving   OCA (  .. -5.500 V ) at %7.4r  %M", $abstime );
        $fwrite(outfile,"nhsj1_7       VGS     leaving   OCA (  .. -5.500 V ) at %7.4r  %M\n", $abstime );
        VGS_retc=-1;
        VGS_cnt=VGS_cnt-1;
        $fclose(outfile);
      end
      if((VGS >= -5.5) &&  (VGS <= 5.5) && (VGS_retc!=0))
      begin
        outfile=$fopen(errFileName,"a");
        $strobe("nhsj1_7       VGS     entering SOCA ( -5.500 V .. 5.500 V ) at %7.4r  %M", $abstime );
        $fwrite(outfile,"nhsj1_7       VGS     entering SOCA ( -5.500 V .. 5.500 V ) at %7.4r  %M\n", $abstime );
        VGS_retc=0;
        VGS_cnt=VGS_cnt-1;
        $fclose(outfile);
      end
      if((VGS > 5.5) &&  (VGS_retc!=1))
      begin
        outfile=$fopen(errFileName,"a");
        $strobe("nhsj1_7       VGS     leaving   OCA ( 5.500 V ..  ) at %7.4r  %M", $abstime );
        $fwrite(outfile,"nhsj1_7       VGS     leaving   OCA ( 5.500 V ..  ) at %7.4r  %M\n", $abstime );
        VGS_retc=1;
        VGS_cnt=VGS_cnt-1;
        $fclose(outfile);
      end
   end
   else
   begin
      if(VGS_cnt==0)
      begin
        outfile=$fopen(errFileName,"a");
        $strobe("nhsj1_7       VGS     error limit ( %d ) reached at %7.4r  %M", maxEv, $abstime );
        $fwrite(outfile,"nhsj1_7       VGS     error limit ( %d ) reached at %7.4r  %M\n", maxEv, $abstime );
        VGS_cnt=VGS_cnt-1;
        $fclose(outfile);
      end
   end

//      VGD
   VGD = V_G_D;
   if((VGD_cnt>0) || ( maxEv_flg==0 ))   begin
      if( (VGD < -100) && (VGD_retc!=-1))
      begin
        outfile=$fopen(errFileName,"a");
        $strobe("nhsj1_7       VGD     leaving   OCA (  .. -100.000 V ) at %7.4r  %M", $abstime );
        $fwrite(outfile,"nhsj1_7       VGD     leaving   OCA (  .. -100.000 V ) at %7.4r  %M\n", $abstime );
        VGD_retc=-1;
        VGD_cnt=VGD_cnt-1;
        $fclose(outfile);
      end
      if((VGD >= -100) &&  (VGD <= 5.5) && (VGD_retc!=0))
      begin
        outfile=$fopen(errFileName,"a");
        $strobe("nhsj1_7       VGD     entering SOCA ( -100.000 V .. 5.500 V ) at %7.4r  %M", $abstime );
        $fwrite(outfile,"nhsj1_7       VGD     entering SOCA ( -100.000 V .. 5.500 V ) at %7.4r  %M\n", $abstime );
        VGD_retc=0;
        VGD_cnt=VGD_cnt-1;
        $fclose(outfile);
      end
      if((VGD > 5.5) &&  (VGD_retc!=1))
      begin
        outfile=$fopen(errFileName,"a");
        $strobe("nhsj1_7       VGD     leaving   OCA ( 5.500 V ..  ) at %7.4r  %M", $abstime );
        $fwrite(outfile,"nhsj1_7       VGD     leaving   OCA ( 5.500 V ..  ) at %7.4r  %M\n", $abstime );
        VGD_retc=1;
        VGD_cnt=VGD_cnt-1;
        $fclose(outfile);
      end
   end
   else
   begin
      if(VGD_cnt==0)
      begin
        outfile=$fopen(errFileName,"a");
        $strobe("nhsj1_7       VGD     error limit ( %d ) reached at %7.4r  %M", maxEv, $abstime );
        $fwrite(outfile,"nhsj1_7       VGD     error limit ( %d ) reached at %7.4r  %M\n", maxEv, $abstime );
        VGD_cnt=VGD_cnt-1;
        $fclose(outfile);
      end
   end

//      VDS
   VDS = V_D_S;
   if((VDS_cnt>0) || ( maxEv_flg==0 ))   begin
      if( (VDS < -1.5) && (VDS_retc!=-1))
      begin
        outfile=$fopen(errFileName,"a");
        $strobe("nhsj1_7       VDS     leaving   OCA (  .. -1.500 V ) at %7.4r  %M", $abstime );
        $fwrite(outfile,"nhsj1_7       VDS     leaving   OCA (  .. -1.500 V ) at %7.4r  %M\n", $abstime );
        VDS_retc=-1;
        VDS_cnt=VDS_cnt-1;
        $fclose(outfile);
      end
      if((VDS >= -1.5) &&  (VDS <= 100) && (VDS_retc!=0))
      begin
        outfile=$fopen(errFileName,"a");
        $strobe("nhsj1_7       VDS     entering SOCA ( -1.500 V .. 100.000 V ) at %7.4r  %M", $abstime );
        $fwrite(outfile,"nhsj1_7       VDS     entering SOCA ( -1.500 V .. 100.000 V ) at %7.4r  %M\n", $abstime );
        VDS_retc=0;
        VDS_cnt=VDS_cnt-1;
        $fclose(outfile);
      end
      if((VDS > 100) &&  (VDS_retc!=1))
      begin
        outfile=$fopen(errFileName,"a");
        $strobe("nhsj1_7       VDS     leaving   OCA ( 100.000 V ..  ) at %7.4r  %M", $abstime );
        $fwrite(outfile,"nhsj1_7       VDS     leaving   OCA ( 100.000 V ..  ) at %7.4r  %M\n", $abstime );
        VDS_retc=1;
        VDS_cnt=VDS_cnt-1;
        $fclose(outfile);
      end
   end
   else
   begin
      if(VDS_cnt==0)
      begin
        outfile=$fopen(errFileName,"a");
        $strobe("nhsj1_7       VDS     error limit ( %d ) reached at %7.4r  %M", maxEv, $abstime );
        $fwrite(outfile,"nhsj1_7       VDS     error limit ( %d ) reached at %7.4r  %M\n", maxEv, $abstime );
        VDS_cnt=VDS_cnt-1;
        $fclose(outfile);
      end
   end

//      VDB
   VDB = V_D_B;
   if((VDB_cnt>0) || ( maxEv_flg==0 ))   begin
      if( (VDB < -1.5) && (VDB_retc!=-1))
      begin
        outfile=$fopen(errFileName,"a");
        $strobe("nhsj1_7       VDB     leaving   OCA (  .. -1.500 V ) at %7.4r  %M", $abstime );
        $fwrite(outfile,"nhsj1_7       VDB     leaving   OCA (  .. -1.500 V ) at %7.4r  %M\n", $abstime );
        VDB_retc=-1;
        VDB_cnt=VDB_cnt-1;
        $fclose(outfile);
      end
      if((VDB >= -1.5) &&  (VDB <= 100) && (VDB_retc!=0))
      begin
        outfile=$fopen(errFileName,"a");
        $strobe("nhsj1_7       VDB     entering SOCA ( -1.500 V .. 100.000 V ) at %7.4r  %M", $abstime );
        $fwrite(outfile,"nhsj1_7       VDB     entering SOCA ( -1.500 V .. 100.000 V ) at %7.4r  %M\n", $abstime );
        VDB_retc=0;
        VDB_cnt=VDB_cnt-1;
        $fclose(outfile);
      end
      if((VDB > 100) &&  (VDB_retc!=1))
      begin
        outfile=$fopen(errFileName,"a");
        $strobe("nhsj1_7       VDB     leaving   OCA ( 100.000 V ..  ) at %7.4r  %M", $abstime );
        $fwrite(outfile,"nhsj1_7       VDB     leaving   OCA ( 100.000 V ..  ) at %7.4r  %M\n", $abstime );
        VDB_retc=1;
        VDB_cnt=VDB_cnt-1;
        $fclose(outfile);
      end
   end
   else
   begin
      if(VDB_cnt==0)
      begin
        outfile=$fopen(errFileName,"a");
        $strobe("nhsj1_7       VDB     error limit ( %d ) reached at %7.4r  %M", maxEv, $abstime );
        $fwrite(outfile,"nhsj1_7       VDB     error limit ( %d ) reached at %7.4r  %M\n", maxEv, $abstime );
        VDB_cnt=VDB_cnt-1;
        $fclose(outfile);
      end
   end

//      VSB
   VSB = V_S_B;
   if((VSB_cnt>0) || ( maxEv_flg==0 ))   begin
      if( (VSB < -0.1) && (VSB_retc!=-1))
      begin
        outfile=$fopen(errFileName,"a");
        $strobe("nhsj1_7       VSB     leaving   OCA (  .. -0.100 V ) at %7.4r  %M", $abstime );
        $fwrite(outfile,"nhsj1_7       VSB     leaving   OCA (  .. -0.100 V ) at %7.4r  %M\n", $abstime );
        VSB_retc=-1;
        VSB_cnt=VSB_cnt-1;
        $fclose(outfile);
      end
      if((VSB >= -0.1) &&  (VSB <= 5.5) && (VSB_retc!=0))
      begin
        outfile=$fopen(errFileName,"a");
        $strobe("nhsj1_7       VSB     entering SOCA ( -0.100 V .. 5.500 V ) at %7.4r  %M", $abstime );
        $fwrite(outfile,"nhsj1_7       VSB     entering SOCA ( -0.100 V .. 5.500 V ) at %7.4r  %M\n", $abstime );
        VSB_retc=0;
        VSB_cnt=VSB_cnt-1;
        $fclose(outfile);
      end
      if((VSB > 5.5) &&  (VSB_retc!=1))
      begin
        outfile=$fopen(errFileName,"a");
        $strobe("nhsj1_7       VSB     leaving   OCA ( 5.500 V ..  ) at %7.4r  %M", $abstime );
        $fwrite(outfile,"nhsj1_7       VSB     leaving   OCA ( 5.500 V ..  ) at %7.4r  %M\n", $abstime );
        VSB_retc=1;
        VSB_cnt=VSB_cnt-1;
        $fclose(outfile);
      end
   end
   else
   begin
      if(VSB_cnt==0)
      begin
        outfile=$fopen(errFileName,"a");
        $strobe("nhsj1_7       VSB     error limit ( %d ) reached at %7.4r  %M", maxEv, $abstime );
        $fwrite(outfile,"nhsj1_7       VSB     error limit ( %d ) reached at %7.4r  %M\n", maxEv, $abstime );
        VSB_cnt=VSB_cnt-1;
        $fclose(outfile);
      end
   end

//      VDHW
   VDHW = V_D_HW;
   if((VDHW_cnt>0) || ( maxEv_flg==0 ))   begin
      if( (VDHW < -1.5) && (VDHW_retc!=-1))
      begin
        outfile=$fopen(errFileName,"a");
        $strobe("nhsj1_7       VDHW    leaving   OCA (  .. -1.500 V ) at %7.4r  %M", $abstime );
        $fwrite(outfile,"nhsj1_7       VDHW    leaving   OCA (  .. -1.500 V ) at %7.4r  %M\n", $abstime );
        VDHW_retc=-1;
        VDHW_cnt=VDHW_cnt-1;
        $fclose(outfile);
      end
      if((VDHW >= -1.5) &&  (VDHW <= 200) && (VDHW_retc!=0))
      begin
        outfile=$fopen(errFileName,"a");
        $strobe("nhsj1_7       VDHW    entering SOCA ( -1.500 V .. 200.000 V ) at %7.4r  %M", $abstime );
        $fwrite(outfile,"nhsj1_7       VDHW    entering SOCA ( -1.500 V .. 200.000 V ) at %7.4r  %M\n", $abstime );
        VDHW_retc=0;
        VDHW_cnt=VDHW_cnt-1;
        $fclose(outfile);
      end
      if((VDHW > 200) &&  (VDHW_retc!=1))
      begin
        outfile=$fopen(errFileName,"a");
        $strobe("nhsj1_7       VDHW    leaving   OCA ( 200.000 V ..  ) at %7.4r  %M", $abstime );
        $fwrite(outfile,"nhsj1_7       VDHW    leaving   OCA ( 200.000 V ..  ) at %7.4r  %M\n", $abstime );
        VDHW_retc=1;
        VDHW_cnt=VDHW_cnt-1;
        $fclose(outfile);
      end
   end
   else
   begin
      if(VDHW_cnt==0)
      begin
        outfile=$fopen(errFileName,"a");
        $strobe("nhsj1_7       VDHW    error limit ( %d ) reached at %7.4r  %M", maxEv, $abstime );
        $fwrite(outfile,"nhsj1_7       VDHW    error limit ( %d ) reached at %7.4r  %M\n", maxEv, $abstime );
        VDHW_cnt=VDHW_cnt-1;
        $fclose(outfile);
      end
   end

end // analog
endmodule // nhsj1_7

// Verilog-A OC Watch for device nhsj1_10 Parameters  VGS VGD VDS VDB VSB VDHW
module nhsj1_10_ahdl(D,G,S,B,HW);
parameter tstep_occ=100n;
parameter errFileName="./occ.err";
parameter maxEv = 25;
parameter maxEv_flg = 0;
inout D,G,S,B,HW;
electrical D,G,S,B,HW;

integer outfile;
real V_D_HW;
real V_S_B;
real V_D_B;
real V_D_S;
real V_G_D;
real V_G_S;
real VGS;
integer VGS_retc;
integer VGS_cnt;
real VGD;
integer VGD_retc;
integer VGD_cnt;
real VDS;
integer VDS_retc;
integer VDS_cnt;
real VDB;
integer VDB_retc;
integer VDB_cnt;
real VSB;
integer VSB_retc;
integer VSB_cnt;
real VDHW;
integer VDHW_retc;
integer VDHW_cnt;

analog begin
   $bound_step( tstep_occ );
   @(initial_step) begin
      VGS_retc=0;
      VGS_cnt = maxEv;
      VGD_retc=0;
      VGD_cnt = maxEv;
      VDS_retc=0;
      VDS_cnt = maxEv;
      VDB_retc=0;
      VDB_cnt = maxEv;
      VSB_retc=0;
      VSB_cnt = maxEv;
      VDHW_retc=0;
      VDHW_cnt = maxEv;
   end
   V_D_HW = V(D,HW);
   V_S_B = V(S,B);
   V_D_B = V(D,B);
   V_D_S = V(D,S);
   V_G_D = V(G,D);
   V_G_S = V(G,S);

//      VGS
   VGS = V_G_S;
   if((VGS_cnt>0) || ( maxEv_flg==0 ))   begin
      if( (VGS < -5.5) && (VGS_retc!=-1))
      begin
        outfile=$fopen(errFileName,"a");
        $strobe("nhsj1_10      VGS     leaving   OCA (  .. -5.500 V ) at %7.4r  %M", $abstime );
        $fwrite(outfile,"nhsj1_10      VGS     leaving   OCA (  .. -5.500 V ) at %7.4r  %M\n", $abstime );
        VGS_retc=-1;
        VGS_cnt=VGS_cnt-1;
        $fclose(outfile);
      end
      if((VGS >= -5.5) &&  (VGS <= 5.5) && (VGS_retc!=0))
      begin
        outfile=$fopen(errFileName,"a");
        $strobe("nhsj1_10      VGS     entering SOCA ( -5.500 V .. 5.500 V ) at %7.4r  %M", $abstime );
        $fwrite(outfile,"nhsj1_10      VGS     entering SOCA ( -5.500 V .. 5.500 V ) at %7.4r  %M\n", $abstime );
        VGS_retc=0;
        VGS_cnt=VGS_cnt-1;
        $fclose(outfile);
      end
      if((VGS > 5.5) &&  (VGS_retc!=1))
      begin
        outfile=$fopen(errFileName,"a");
        $strobe("nhsj1_10      VGS     leaving   OCA ( 5.500 V ..  ) at %7.4r  %M", $abstime );
        $fwrite(outfile,"nhsj1_10      VGS     leaving   OCA ( 5.500 V ..  ) at %7.4r  %M\n", $abstime );
        VGS_retc=1;
        VGS_cnt=VGS_cnt-1;
        $fclose(outfile);
      end
   end
   else
   begin
      if(VGS_cnt==0)
      begin
        outfile=$fopen(errFileName,"a");
        $strobe("nhsj1_10      VGS     error limit ( %d ) reached at %7.4r  %M", maxEv, $abstime );
        $fwrite(outfile,"nhsj1_10      VGS     error limit ( %d ) reached at %7.4r  %M\n", maxEv, $abstime );
        VGS_cnt=VGS_cnt-1;
        $fclose(outfile);
      end
   end

//      VGD
   VGD = V_G_D;
   if((VGD_cnt>0) || ( maxEv_flg==0 ))   begin
      if( (VGD < -140) && (VGD_retc!=-1))
      begin
        outfile=$fopen(errFileName,"a");
        $strobe("nhsj1_10      VGD     leaving   OCA (  .. -140.000 V ) at %7.4r  %M", $abstime );
        $fwrite(outfile,"nhsj1_10      VGD     leaving   OCA (  .. -140.000 V ) at %7.4r  %M\n", $abstime );
        VGD_retc=-1;
        VGD_cnt=VGD_cnt-1;
        $fclose(outfile);
      end
      if((VGD >= -140) &&  (VGD <= 5.5) && (VGD_retc!=0))
      begin
        outfile=$fopen(errFileName,"a");
        $strobe("nhsj1_10      VGD     entering SOCA ( -140.000 V .. 5.500 V ) at %7.4r  %M", $abstime );
        $fwrite(outfile,"nhsj1_10      VGD     entering SOCA ( -140.000 V .. 5.500 V ) at %7.4r  %M\n", $abstime );
        VGD_retc=0;
        VGD_cnt=VGD_cnt-1;
        $fclose(outfile);
      end
      if((VGD > 5.5) &&  (VGD_retc!=1))
      begin
        outfile=$fopen(errFileName,"a");
        $strobe("nhsj1_10      VGD     leaving   OCA ( 5.500 V ..  ) at %7.4r  %M", $abstime );
        $fwrite(outfile,"nhsj1_10      VGD     leaving   OCA ( 5.500 V ..  ) at %7.4r  %M\n", $abstime );
        VGD_retc=1;
        VGD_cnt=VGD_cnt-1;
        $fclose(outfile);
      end
   end
   else
   begin
      if(VGD_cnt==0)
      begin
        outfile=$fopen(errFileName,"a");
        $strobe("nhsj1_10      VGD     error limit ( %d ) reached at %7.4r  %M", maxEv, $abstime );
        $fwrite(outfile,"nhsj1_10      VGD     error limit ( %d ) reached at %7.4r  %M\n", maxEv, $abstime );
        VGD_cnt=VGD_cnt-1;
        $fclose(outfile);
      end
   end

//      VDS
   VDS = V_D_S;
   if((VDS_cnt>0) || ( maxEv_flg==0 ))   begin
      if( (VDS < -1.5) && (VDS_retc!=-1))
      begin
        outfile=$fopen(errFileName,"a");
        $strobe("nhsj1_10      VDS     leaving   OCA (  .. -1.500 V ) at %7.4r  %M", $abstime );
        $fwrite(outfile,"nhsj1_10      VDS     leaving   OCA (  .. -1.500 V ) at %7.4r  %M\n", $abstime );
        VDS_retc=-1;
        VDS_cnt=VDS_cnt-1;
        $fclose(outfile);
      end
      if((VDS >= -1.5) &&  (VDS <= 140) && (VDS_retc!=0))
      begin
        outfile=$fopen(errFileName,"a");
        $strobe("nhsj1_10      VDS     entering SOCA ( -1.500 V .. 140.000 V ) at %7.4r  %M", $abstime );
        $fwrite(outfile,"nhsj1_10      VDS     entering SOCA ( -1.500 V .. 140.000 V ) at %7.4r  %M\n", $abstime );
        VDS_retc=0;
        VDS_cnt=VDS_cnt-1;
        $fclose(outfile);
      end
      if((VDS > 140) &&  (VDS_retc!=1))
      begin
        outfile=$fopen(errFileName,"a");
        $strobe("nhsj1_10      VDS     leaving   OCA ( 140.000 V ..  ) at %7.4r  %M", $abstime );
        $fwrite(outfile,"nhsj1_10      VDS     leaving   OCA ( 140.000 V ..  ) at %7.4r  %M\n", $abstime );
        VDS_retc=1;
        VDS_cnt=VDS_cnt-1;
        $fclose(outfile);
      end
   end
   else
   begin
      if(VDS_cnt==0)
      begin
        outfile=$fopen(errFileName,"a");
        $strobe("nhsj1_10      VDS     error limit ( %d ) reached at %7.4r  %M", maxEv, $abstime );
        $fwrite(outfile,"nhsj1_10      VDS     error limit ( %d ) reached at %7.4r  %M\n", maxEv, $abstime );
        VDS_cnt=VDS_cnt-1;
        $fclose(outfile);
      end
   end

//      VDB
   VDB = V_D_B;
   if((VDB_cnt>0) || ( maxEv_flg==0 ))   begin
      if( (VDB < -1.5) && (VDB_retc!=-1))
      begin
        outfile=$fopen(errFileName,"a");
        $strobe("nhsj1_10      VDB     leaving   OCA (  .. -1.500 V ) at %7.4r  %M", $abstime );
        $fwrite(outfile,"nhsj1_10      VDB     leaving   OCA (  .. -1.500 V ) at %7.4r  %M\n", $abstime );
        VDB_retc=-1;
        VDB_cnt=VDB_cnt-1;
        $fclose(outfile);
      end
      if((VDB >= -1.5) &&  (VDB <= 140) && (VDB_retc!=0))
      begin
        outfile=$fopen(errFileName,"a");
        $strobe("nhsj1_10      VDB     entering SOCA ( -1.500 V .. 140.000 V ) at %7.4r  %M", $abstime );
        $fwrite(outfile,"nhsj1_10      VDB     entering SOCA ( -1.500 V .. 140.000 V ) at %7.4r  %M\n", $abstime );
        VDB_retc=0;
        VDB_cnt=VDB_cnt-1;
        $fclose(outfile);
      end
      if((VDB > 140) &&  (VDB_retc!=1))
      begin
        outfile=$fopen(errFileName,"a");
        $strobe("nhsj1_10      VDB     leaving   OCA ( 140.000 V ..  ) at %7.4r  %M", $abstime );
        $fwrite(outfile,"nhsj1_10      VDB     leaving   OCA ( 140.000 V ..  ) at %7.4r  %M\n", $abstime );
        VDB_retc=1;
        VDB_cnt=VDB_cnt-1;
        $fclose(outfile);
      end
   end
   else
   begin
      if(VDB_cnt==0)
      begin
        outfile=$fopen(errFileName,"a");
        $strobe("nhsj1_10      VDB     error limit ( %d ) reached at %7.4r  %M", maxEv, $abstime );
        $fwrite(outfile,"nhsj1_10      VDB     error limit ( %d ) reached at %7.4r  %M\n", maxEv, $abstime );
        VDB_cnt=VDB_cnt-1;
        $fclose(outfile);
      end
   end

//      VSB
   VSB = V_S_B;
   if((VSB_cnt>0) || ( maxEv_flg==0 ))   begin
      if( (VSB < -0.1) && (VSB_retc!=-1))
      begin
        outfile=$fopen(errFileName,"a");
        $strobe("nhsj1_10      VSB     leaving   OCA (  .. -0.100 V ) at %7.4r  %M", $abstime );
        $fwrite(outfile,"nhsj1_10      VSB     leaving   OCA (  .. -0.100 V ) at %7.4r  %M\n", $abstime );
        VSB_retc=-1;
        VSB_cnt=VSB_cnt-1;
        $fclose(outfile);
      end
      if((VSB >= -0.1) &&  (VSB <= 5.5) && (VSB_retc!=0))
      begin
        outfile=$fopen(errFileName,"a");
        $strobe("nhsj1_10      VSB     entering SOCA ( -0.100 V .. 5.500 V ) at %7.4r  %M", $abstime );
        $fwrite(outfile,"nhsj1_10      VSB     entering SOCA ( -0.100 V .. 5.500 V ) at %7.4r  %M\n", $abstime );
        VSB_retc=0;
        VSB_cnt=VSB_cnt-1;
        $fclose(outfile);
      end
      if((VSB > 5.5) &&  (VSB_retc!=1))
      begin
        outfile=$fopen(errFileName,"a");
        $strobe("nhsj1_10      VSB     leaving   OCA ( 5.500 V ..  ) at %7.4r  %M", $abstime );
        $fwrite(outfile,"nhsj1_10      VSB     leaving   OCA ( 5.500 V ..  ) at %7.4r  %M\n", $abstime );
        VSB_retc=1;
        VSB_cnt=VSB_cnt-1;
        $fclose(outfile);
      end
   end
   else
   begin
      if(VSB_cnt==0)
      begin
        outfile=$fopen(errFileName,"a");
        $strobe("nhsj1_10      VSB     error limit ( %d ) reached at %7.4r  %M", maxEv, $abstime );
        $fwrite(outfile,"nhsj1_10      VSB     error limit ( %d ) reached at %7.4r  %M\n", maxEv, $abstime );
        VSB_cnt=VSB_cnt-1;
        $fclose(outfile);
      end
   end

//      VDHW
   VDHW = V_D_HW;
   if((VDHW_cnt>0) || ( maxEv_flg==0 ))   begin
      if( (VDHW < -1.5) && (VDHW_retc!=-1))
      begin
        outfile=$fopen(errFileName,"a");
        $strobe("nhsj1_10      VDHW    leaving   OCA (  .. -1.500 V ) at %7.4r  %M", $abstime );
        $fwrite(outfile,"nhsj1_10      VDHW    leaving   OCA (  .. -1.500 V ) at %7.4r  %M\n", $abstime );
        VDHW_retc=-1;
        VDHW_cnt=VDHW_cnt-1;
        $fclose(outfile);
      end
      if((VDHW >= -1.5) &&  (VDHW <= 200) && (VDHW_retc!=0))
      begin
        outfile=$fopen(errFileName,"a");
        $strobe("nhsj1_10      VDHW    entering SOCA ( -1.500 V .. 200.000 V ) at %7.4r  %M", $abstime );
        $fwrite(outfile,"nhsj1_10      VDHW    entering SOCA ( -1.500 V .. 200.000 V ) at %7.4r  %M\n", $abstime );
        VDHW_retc=0;
        VDHW_cnt=VDHW_cnt-1;
        $fclose(outfile);
      end
      if((VDHW > 200) &&  (VDHW_retc!=1))
      begin
        outfile=$fopen(errFileName,"a");
        $strobe("nhsj1_10      VDHW    leaving   OCA ( 200.000 V ..  ) at %7.4r  %M", $abstime );
        $fwrite(outfile,"nhsj1_10      VDHW    leaving   OCA ( 200.000 V ..  ) at %7.4r  %M\n", $abstime );
        VDHW_retc=1;
        VDHW_cnt=VDHW_cnt-1;
        $fclose(outfile);
      end
   end
   else
   begin
      if(VDHW_cnt==0)
      begin
        outfile=$fopen(errFileName,"a");
        $strobe("nhsj1_10      VDHW    error limit ( %d ) reached at %7.4r  %M", maxEv, $abstime );
        $fwrite(outfile,"nhsj1_10      VDHW    error limit ( %d ) reached at %7.4r  %M\n", maxEv, $abstime );
        VDHW_cnt=VDHW_cnt-1;
        $fclose(outfile);
      end
   end

end // analog
endmodule // nhsj1_10

// Verilog-A OC Watch for device nhsj1_16c Parameters  VGS VGD VDS VDB VSB VDHW
module nhsj1_16c_ahdl(D,G,S,B,HW);
parameter tstep_occ=100n;
parameter errFileName="./occ.err";
parameter maxEv = 25;
parameter maxEv_flg = 0;
inout D,G,S,B,HW;
electrical D,G,S,B,HW;

integer outfile;
real V_D_HW;
real V_S_B;
real V_D_B;
real V_D_S;
real V_G_D;
real V_G_S;
real VGS;
integer VGS_retc;
integer VGS_cnt;
real VGD;
integer VGD_retc;
integer VGD_cnt;
real VDS;
integer VDS_retc;
integer VDS_cnt;
real VDB;
integer VDB_retc;
integer VDB_cnt;
real VSB;
integer VSB_retc;
integer VSB_cnt;
real VDHW;
integer VDHW_retc;
integer VDHW_cnt;

analog begin
   $bound_step( tstep_occ );
   @(initial_step) begin
      VGS_retc=0;
      VGS_cnt = maxEv;
      VGD_retc=0;
      VGD_cnt = maxEv;
      VDS_retc=0;
      VDS_cnt = maxEv;
      VDB_retc=0;
      VDB_cnt = maxEv;
      VSB_retc=0;
      VSB_cnt = maxEv;
      VDHW_retc=0;
      VDHW_cnt = maxEv;
   end
   V_D_HW = V(D,HW);
   V_S_B = V(S,B);
   V_D_B = V(D,B);
   V_D_S = V(D,S);
   V_G_D = V(G,D);
   V_G_S = V(G,S);

//      VGS
   VGS = V_G_S;
   if((VGS_cnt>0) || ( maxEv_flg==0 ))   begin
      if( (VGS < -5.5) && (VGS_retc!=-1))
      begin
        outfile=$fopen(errFileName,"a");
        $strobe("nhsj1_16c     VGS     leaving   OCA (  .. -5.500 V ) at %7.4r  %M", $abstime );
        $fwrite(outfile,"nhsj1_16c     VGS     leaving   OCA (  .. -5.500 V ) at %7.4r  %M\n", $abstime );
        VGS_retc=-1;
        VGS_cnt=VGS_cnt-1;
        $fclose(outfile);
      end
      if((VGS >= -5.5) &&  (VGS <= 5.5) && (VGS_retc!=0))
      begin
        outfile=$fopen(errFileName,"a");
        $strobe("nhsj1_16c     VGS     entering SOCA ( -5.500 V .. 5.500 V ) at %7.4r  %M", $abstime );
        $fwrite(outfile,"nhsj1_16c     VGS     entering SOCA ( -5.500 V .. 5.500 V ) at %7.4r  %M\n", $abstime );
        VGS_retc=0;
        VGS_cnt=VGS_cnt-1;
        $fclose(outfile);
      end
      if((VGS > 5.5) &&  (VGS_retc!=1))
      begin
        outfile=$fopen(errFileName,"a");
        $strobe("nhsj1_16c     VGS     leaving   OCA ( 5.500 V ..  ) at %7.4r  %M", $abstime );
        $fwrite(outfile,"nhsj1_16c     VGS     leaving   OCA ( 5.500 V ..  ) at %7.4r  %M\n", $abstime );
        VGS_retc=1;
        VGS_cnt=VGS_cnt-1;
        $fclose(outfile);
      end
   end
   else
   begin
      if(VGS_cnt==0)
      begin
        outfile=$fopen(errFileName,"a");
        $strobe("nhsj1_16c     VGS     error limit ( %d ) reached at %7.4r  %M", maxEv, $abstime );
        $fwrite(outfile,"nhsj1_16c     VGS     error limit ( %d ) reached at %7.4r  %M\n", maxEv, $abstime );
        VGS_cnt=VGS_cnt-1;
        $fclose(outfile);
      end
   end

//      VGD
   VGD = V_G_D;
   if((VGD_cnt>0) || ( maxEv_flg==0 ))   begin
      if( (VGD < -200) && (VGD_retc!=-1))
      begin
        outfile=$fopen(errFileName,"a");
        $strobe("nhsj1_16c     VGD     leaving   OCA (  .. -200.000 V ) at %7.4r  %M", $abstime );
        $fwrite(outfile,"nhsj1_16c     VGD     leaving   OCA (  .. -200.000 V ) at %7.4r  %M\n", $abstime );
        VGD_retc=-1;
        VGD_cnt=VGD_cnt-1;
        $fclose(outfile);
      end
      if((VGD >= -200) &&  (VGD <= 5.5) && (VGD_retc!=0))
      begin
        outfile=$fopen(errFileName,"a");
        $strobe("nhsj1_16c     VGD     entering SOCA ( -200.000 V .. 5.500 V ) at %7.4r  %M", $abstime );
        $fwrite(outfile,"nhsj1_16c     VGD     entering SOCA ( -200.000 V .. 5.500 V ) at %7.4r  %M\n", $abstime );
        VGD_retc=0;
        VGD_cnt=VGD_cnt-1;
        $fclose(outfile);
      end
      if((VGD > 5.5) &&  (VGD_retc!=1))
      begin
        outfile=$fopen(errFileName,"a");
        $strobe("nhsj1_16c     VGD     leaving   OCA ( 5.500 V ..  ) at %7.4r  %M", $abstime );
        $fwrite(outfile,"nhsj1_16c     VGD     leaving   OCA ( 5.500 V ..  ) at %7.4r  %M\n", $abstime );
        VGD_retc=1;
        VGD_cnt=VGD_cnt-1;
        $fclose(outfile);
      end
   end
   else
   begin
      if(VGD_cnt==0)
      begin
        outfile=$fopen(errFileName,"a");
        $strobe("nhsj1_16c     VGD     error limit ( %d ) reached at %7.4r  %M", maxEv, $abstime );
        $fwrite(outfile,"nhsj1_16c     VGD     error limit ( %d ) reached at %7.4r  %M\n", maxEv, $abstime );
        VGD_cnt=VGD_cnt-1;
        $fclose(outfile);
      end
   end

//      VDS
   VDS = V_D_S;
   if((VDS_cnt>0) || ( maxEv_flg==0 ))   begin
      if( (VDS < -1.5) && (VDS_retc!=-1))
      begin
        outfile=$fopen(errFileName,"a");
        $strobe("nhsj1_16c     VDS     leaving   OCA (  .. -1.500 V ) at %7.4r  %M", $abstime );
        $fwrite(outfile,"nhsj1_16c     VDS     leaving   OCA (  .. -1.500 V ) at %7.4r  %M\n", $abstime );
        VDS_retc=-1;
        VDS_cnt=VDS_cnt-1;
        $fclose(outfile);
      end
      if((VDS >= -1.5) &&  (VDS <= 200) && (VDS_retc!=0))
      begin
        outfile=$fopen(errFileName,"a");
        $strobe("nhsj1_16c     VDS     entering SOCA ( -1.500 V .. 200.000 V ) at %7.4r  %M", $abstime );
        $fwrite(outfile,"nhsj1_16c     VDS     entering SOCA ( -1.500 V .. 200.000 V ) at %7.4r  %M\n", $abstime );
        VDS_retc=0;
        VDS_cnt=VDS_cnt-1;
        $fclose(outfile);
      end
      if((VDS > 200) &&  (VDS_retc!=1))
      begin
        outfile=$fopen(errFileName,"a");
        $strobe("nhsj1_16c     VDS     leaving   OCA ( 200.000 V ..  ) at %7.4r  %M", $abstime );
        $fwrite(outfile,"nhsj1_16c     VDS     leaving   OCA ( 200.000 V ..  ) at %7.4r  %M\n", $abstime );
        VDS_retc=1;
        VDS_cnt=VDS_cnt-1;
        $fclose(outfile);
      end
   end
   else
   begin
      if(VDS_cnt==0)
      begin
        outfile=$fopen(errFileName,"a");
        $strobe("nhsj1_16c     VDS     error limit ( %d ) reached at %7.4r  %M", maxEv, $abstime );
        $fwrite(outfile,"nhsj1_16c     VDS     error limit ( %d ) reached at %7.4r  %M\n", maxEv, $abstime );
        VDS_cnt=VDS_cnt-1;
        $fclose(outfile);
      end
   end

//      VDB
   VDB = V_D_B;
   if((VDB_cnt>0) || ( maxEv_flg==0 ))   begin
      if( (VDB < -1.5) && (VDB_retc!=-1))
      begin
        outfile=$fopen(errFileName,"a");
        $strobe("nhsj1_16c     VDB     leaving   OCA (  .. -1.500 V ) at %7.4r  %M", $abstime );
        $fwrite(outfile,"nhsj1_16c     VDB     leaving   OCA (  .. -1.500 V ) at %7.4r  %M\n", $abstime );
        VDB_retc=-1;
        VDB_cnt=VDB_cnt-1;
        $fclose(outfile);
      end
      if((VDB >= -1.5) &&  (VDB <= 200) && (VDB_retc!=0))
      begin
        outfile=$fopen(errFileName,"a");
        $strobe("nhsj1_16c     VDB     entering SOCA ( -1.500 V .. 200.000 V ) at %7.4r  %M", $abstime );
        $fwrite(outfile,"nhsj1_16c     VDB     entering SOCA ( -1.500 V .. 200.000 V ) at %7.4r  %M\n", $abstime );
        VDB_retc=0;
        VDB_cnt=VDB_cnt-1;
        $fclose(outfile);
      end
      if((VDB > 200) &&  (VDB_retc!=1))
      begin
        outfile=$fopen(errFileName,"a");
        $strobe("nhsj1_16c     VDB     leaving   OCA ( 200.000 V ..  ) at %7.4r  %M", $abstime );
        $fwrite(outfile,"nhsj1_16c     VDB     leaving   OCA ( 200.000 V ..  ) at %7.4r  %M\n", $abstime );
        VDB_retc=1;
        VDB_cnt=VDB_cnt-1;
        $fclose(outfile);
      end
   end
   else
   begin
      if(VDB_cnt==0)
      begin
        outfile=$fopen(errFileName,"a");
        $strobe("nhsj1_16c     VDB     error limit ( %d ) reached at %7.4r  %M", maxEv, $abstime );
        $fwrite(outfile,"nhsj1_16c     VDB     error limit ( %d ) reached at %7.4r  %M\n", maxEv, $abstime );
        VDB_cnt=VDB_cnt-1;
        $fclose(outfile);
      end
   end

//      VSB
   VSB = V_S_B;
   if((VSB_cnt>0) || ( maxEv_flg==0 ))   begin
      if( (VSB < -0.1) && (VSB_retc!=-1))
      begin
        outfile=$fopen(errFileName,"a");
        $strobe("nhsj1_16c     VSB     leaving   OCA (  .. -0.100 V ) at %7.4r  %M", $abstime );
        $fwrite(outfile,"nhsj1_16c     VSB     leaving   OCA (  .. -0.100 V ) at %7.4r  %M\n", $abstime );
        VSB_retc=-1;
        VSB_cnt=VSB_cnt-1;
        $fclose(outfile);
      end
      if((VSB >= -0.1) &&  (VSB <= 5.5) && (VSB_retc!=0))
      begin
        outfile=$fopen(errFileName,"a");
        $strobe("nhsj1_16c     VSB     entering SOCA ( -0.100 V .. 5.500 V ) at %7.4r  %M", $abstime );
        $fwrite(outfile,"nhsj1_16c     VSB     entering SOCA ( -0.100 V .. 5.500 V ) at %7.4r  %M\n", $abstime );
        VSB_retc=0;
        VSB_cnt=VSB_cnt-1;
        $fclose(outfile);
      end
      if((VSB > 5.5) &&  (VSB_retc!=1))
      begin
        outfile=$fopen(errFileName,"a");
        $strobe("nhsj1_16c     VSB     leaving   OCA ( 5.500 V ..  ) at %7.4r  %M", $abstime );
        $fwrite(outfile,"nhsj1_16c     VSB     leaving   OCA ( 5.500 V ..  ) at %7.4r  %M\n", $abstime );
        VSB_retc=1;
        VSB_cnt=VSB_cnt-1;
        $fclose(outfile);
      end
   end
   else
   begin
      if(VSB_cnt==0)
      begin
        outfile=$fopen(errFileName,"a");
        $strobe("nhsj1_16c     VSB     error limit ( %d ) reached at %7.4r  %M", maxEv, $abstime );
        $fwrite(outfile,"nhsj1_16c     VSB     error limit ( %d ) reached at %7.4r  %M\n", maxEv, $abstime );
        VSB_cnt=VSB_cnt-1;
        $fclose(outfile);
      end
   end

//      VDHW
   VDHW = V_D_HW;
   if((VDHW_cnt>0) || ( maxEv_flg==0 ))   begin
      if( (VDHW < -1.5) && (VDHW_retc!=-1))
      begin
        outfile=$fopen(errFileName,"a");
        $strobe("nhsj1_16c     VDHW    leaving   OCA (  .. -1.500 V ) at %7.4r  %M", $abstime );
        $fwrite(outfile,"nhsj1_16c     VDHW    leaving   OCA (  .. -1.500 V ) at %7.4r  %M\n", $abstime );
        VDHW_retc=-1;
        VDHW_cnt=VDHW_cnt-1;
        $fclose(outfile);
      end
      if((VDHW >= -1.5) &&  (VDHW <= 200) && (VDHW_retc!=0))
      begin
        outfile=$fopen(errFileName,"a");
        $strobe("nhsj1_16c     VDHW    entering SOCA ( -1.500 V .. 200.000 V ) at %7.4r  %M", $abstime );
        $fwrite(outfile,"nhsj1_16c     VDHW    entering SOCA ( -1.500 V .. 200.000 V ) at %7.4r  %M\n", $abstime );
        VDHW_retc=0;
        VDHW_cnt=VDHW_cnt-1;
        $fclose(outfile);
      end
      if((VDHW > 200) &&  (VDHW_retc!=1))
      begin
        outfile=$fopen(errFileName,"a");
        $strobe("nhsj1_16c     VDHW    leaving   OCA ( 200.000 V ..  ) at %7.4r  %M", $abstime );
        $fwrite(outfile,"nhsj1_16c     VDHW    leaving   OCA ( 200.000 V ..  ) at %7.4r  %M\n", $abstime );
        VDHW_retc=1;
        VDHW_cnt=VDHW_cnt-1;
        $fclose(outfile);
      end
   end
   else
   begin
      if(VDHW_cnt==0)
      begin
        outfile=$fopen(errFileName,"a");
        $strobe("nhsj1_16c     VDHW    error limit ( %d ) reached at %7.4r  %M", maxEv, $abstime );
        $fwrite(outfile,"nhsj1_16c     VDHW    error limit ( %d ) reached at %7.4r  %M\n", maxEv, $abstime );
        VDHW_cnt=VDHW_cnt-1;
        $fclose(outfile);
      end
   end

end // analog
endmodule // nhsj1_16c

// Verilog-A OC Watch for device nisj1_16 Parameters  VCE VCHW VGC VGE
module nisj1_16_ahdl(C,G,E,HW);
parameter tstep_occ=100n;
parameter errFileName="./occ.err";
parameter maxEv = 25;
parameter maxEv_flg = 0;
inout C,G,E,HW;
electrical C,G,E,HW;

integer outfile;
real V_G_E;
real V_G_C;
real V_C_HW;
real V_C_E;
real VCE;
integer VCE_retc;
integer VCE_cnt;
real VCHW;
integer VCHW_retc;
integer VCHW_cnt;
real VGC;
integer VGC_retc;
integer VGC_cnt;
real VGE;
integer VGE_retc;
integer VGE_cnt;

analog begin
   $bound_step( tstep_occ );
   @(initial_step) begin
      VCE_retc=0;
      VCE_cnt = maxEv;
      VCHW_retc=0;
      VCHW_cnt = maxEv;
      VGC_retc=0;
      VGC_cnt = maxEv;
      VGE_retc=0;
      VGE_cnt = maxEv;
   end
   V_G_E = V(G,E);
   V_G_C = V(G,C);
   V_C_HW = V(C,HW);
   V_C_E = V(C,E);

//      VCE
   VCE = V_C_E;
   if((VCE_cnt>0) || ( maxEv_flg==0 ))   begin
      if( (VCE < -2) && (VCE_retc!=-1))
      begin
        outfile=$fopen(errFileName,"a");
        $strobe("nisj1_16      VCE     leaving   OCA (  .. -2.000 V ) at %7.4r  %M", $abstime );
        $fwrite(outfile,"nisj1_16      VCE     leaving   OCA (  .. -2.000 V ) at %7.4r  %M\n", $abstime );
        VCE_retc=-1;
        VCE_cnt=VCE_cnt-1;
        $fclose(outfile);
      end
      if((VCE >= -2) &&  (VCE <= 200) && (VCE_retc!=0))
      begin
        outfile=$fopen(errFileName,"a");
        $strobe("nisj1_16      VCE     entering SOCA ( -2.000 V .. 200.000 V ) at %7.4r  %M", $abstime );
        $fwrite(outfile,"nisj1_16      VCE     entering SOCA ( -2.000 V .. 200.000 V ) at %7.4r  %M\n", $abstime );
        VCE_retc=0;
        VCE_cnt=VCE_cnt-1;
        $fclose(outfile);
      end
      if((VCE > 200) &&  (VCE_retc!=1))
      begin
        outfile=$fopen(errFileName,"a");
        $strobe("nisj1_16      VCE     leaving   OCA ( 200.000 V ..  ) at %7.4r  %M", $abstime );
        $fwrite(outfile,"nisj1_16      VCE     leaving   OCA ( 200.000 V ..  ) at %7.4r  %M\n", $abstime );
        VCE_retc=1;
        VCE_cnt=VCE_cnt-1;
        $fclose(outfile);
      end
   end
   else
   begin
      if(VCE_cnt==0)
      begin
        outfile=$fopen(errFileName,"a");
        $strobe("nisj1_16      VCE     error limit ( %d ) reached at %7.4r  %M", maxEv, $abstime );
        $fwrite(outfile,"nisj1_16      VCE     error limit ( %d ) reached at %7.4r  %M\n", maxEv, $abstime );
        VCE_cnt=VCE_cnt-1;
        $fclose(outfile);
      end
   end

//      VCHW
   VCHW = V_C_HW;
   if((VCHW_cnt>0) || ( maxEv_flg==0 ))   begin
      if( (VCHW < -0.1) && (VCHW_retc!=-1))
      begin
        outfile=$fopen(errFileName,"a");
        $strobe("nisj1_16      VCHW    leaving   OCA (  .. -0.100 V ) at %7.4r  %M", $abstime );
        $fwrite(outfile,"nisj1_16      VCHW    leaving   OCA (  .. -0.100 V ) at %7.4r  %M\n", $abstime );
        VCHW_retc=-1;
        VCHW_cnt=VCHW_cnt-1;
        $fclose(outfile);
      end
      if((VCHW >= -0.1) &&  (VCHW <= 200) && (VCHW_retc!=0))
      begin
        outfile=$fopen(errFileName,"a");
        $strobe("nisj1_16      VCHW    entering SOCA ( -0.100 V .. 200.000 V ) at %7.4r  %M", $abstime );
        $fwrite(outfile,"nisj1_16      VCHW    entering SOCA ( -0.100 V .. 200.000 V ) at %7.4r  %M\n", $abstime );
        VCHW_retc=0;
        VCHW_cnt=VCHW_cnt-1;
        $fclose(outfile);
      end
      if((VCHW > 200) &&  (VCHW_retc!=1))
      begin
        outfile=$fopen(errFileName,"a");
        $strobe("nisj1_16      VCHW    leaving   OCA ( 200.000 V ..  ) at %7.4r  %M", $abstime );
        $fwrite(outfile,"nisj1_16      VCHW    leaving   OCA ( 200.000 V ..  ) at %7.4r  %M\n", $abstime );
        VCHW_retc=1;
        VCHW_cnt=VCHW_cnt-1;
        $fclose(outfile);
      end
   end
   else
   begin
      if(VCHW_cnt==0)
      begin
        outfile=$fopen(errFileName,"a");
        $strobe("nisj1_16      VCHW    error limit ( %d ) reached at %7.4r  %M", maxEv, $abstime );
        $fwrite(outfile,"nisj1_16      VCHW    error limit ( %d ) reached at %7.4r  %M\n", maxEv, $abstime );
        VCHW_cnt=VCHW_cnt-1;
        $fclose(outfile);
      end
   end

//      VGC
   VGC = V_G_C;
   if((VGC_cnt>0) || ( maxEv_flg==0 ))   begin
      if( (VGC < -200) && (VGC_retc!=-1))
      begin
        outfile=$fopen(errFileName,"a");
        $strobe("nisj1_16      VGC     leaving   OCA (  .. -200.000 V ) at %7.4r  %M", $abstime );
        $fwrite(outfile,"nisj1_16      VGC     leaving   OCA (  .. -200.000 V ) at %7.4r  %M\n", $abstime );
        VGC_retc=-1;
        VGC_cnt=VGC_cnt-1;
        $fclose(outfile);
      end
      if((VGC >= -200) &&  (VGC <= 5.5) && (VGC_retc!=0))
      begin
        outfile=$fopen(errFileName,"a");
        $strobe("nisj1_16      VGC     entering SOCA ( -200.000 V .. 5.500 V ) at %7.4r  %M", $abstime );
        $fwrite(outfile,"nisj1_16      VGC     entering SOCA ( -200.000 V .. 5.500 V ) at %7.4r  %M\n", $abstime );
        VGC_retc=0;
        VGC_cnt=VGC_cnt-1;
        $fclose(outfile);
      end
      if((VGC > 5.5) &&  (VGC_retc!=1))
      begin
        outfile=$fopen(errFileName,"a");
        $strobe("nisj1_16      VGC     leaving   OCA ( 5.500 V ..  ) at %7.4r  %M", $abstime );
        $fwrite(outfile,"nisj1_16      VGC     leaving   OCA ( 5.500 V ..  ) at %7.4r  %M\n", $abstime );
        VGC_retc=1;
        VGC_cnt=VGC_cnt-1;
        $fclose(outfile);
      end
   end
   else
   begin
      if(VGC_cnt==0)
      begin
        outfile=$fopen(errFileName,"a");
        $strobe("nisj1_16      VGC     error limit ( %d ) reached at %7.4r  %M", maxEv, $abstime );
        $fwrite(outfile,"nisj1_16      VGC     error limit ( %d ) reached at %7.4r  %M\n", maxEv, $abstime );
        VGC_cnt=VGC_cnt-1;
        $fclose(outfile);
      end
   end

//      VGE
   VGE = V_G_E;
   if((VGE_cnt>0) || ( maxEv_flg==0 ))   begin
      if( (VGE < -5.5) && (VGE_retc!=-1))
      begin
        outfile=$fopen(errFileName,"a");
        $strobe("nisj1_16      VGE     leaving   OCA (  .. -5.500 V ) at %7.4r  %M", $abstime );
        $fwrite(outfile,"nisj1_16      VGE     leaving   OCA (  .. -5.500 V ) at %7.4r  %M\n", $abstime );
        VGE_retc=-1;
        VGE_cnt=VGE_cnt-1;
        $fclose(outfile);
      end
      if((VGE >= -5.5) &&  (VGE <= 5.5) && (VGE_retc!=0))
      begin
        outfile=$fopen(errFileName,"a");
        $strobe("nisj1_16      VGE     entering SOCA ( -5.500 V .. 5.500 V ) at %7.4r  %M", $abstime );
        $fwrite(outfile,"nisj1_16      VGE     entering SOCA ( -5.500 V .. 5.500 V ) at %7.4r  %M\n", $abstime );
        VGE_retc=0;
        VGE_cnt=VGE_cnt-1;
        $fclose(outfile);
      end
      if((VGE > 5.5) &&  (VGE_retc!=1))
      begin
        outfile=$fopen(errFileName,"a");
        $strobe("nisj1_16      VGE     leaving   OCA ( 5.500 V ..  ) at %7.4r  %M", $abstime );
        $fwrite(outfile,"nisj1_16      VGE     leaving   OCA ( 5.500 V ..  ) at %7.4r  %M\n", $abstime );
        VGE_retc=1;
        VGE_cnt=VGE_cnt-1;
        $fclose(outfile);
      end
   end
   else
   begin
      if(VGE_cnt==0)
      begin
        outfile=$fopen(errFileName,"a");
        $strobe("nisj1_16      VGE     error limit ( %d ) reached at %7.4r  %M", maxEv, $abstime );
        $fwrite(outfile,"nisj1_16      VGE     error limit ( %d ) reached at %7.4r  %M\n", maxEv, $abstime );
        VGE_cnt=VGE_cnt-1;
        $fclose(outfile);
      end
   end

end // analog
endmodule // nisj1_16

// Verilog-A OC Watch for device phsj1_7 Parameters  VGS VGD VDS VDB VSB VBHW
module phsj1_7_ahdl(D,G,S,B,HW);
parameter tstep_occ=100n;
parameter errFileName="./occ.err";
parameter maxEv = 25;
parameter maxEv_flg = 0;
inout D,G,S,B,HW;
electrical D,G,S,B,HW;

integer outfile;
real V_B_HW;
real V_S_B;
real V_D_B;
real V_D_S;
real V_G_D;
real V_G_S;
real VGS;
integer VGS_retc;
integer VGS_cnt;
real VGD;
integer VGD_retc;
integer VGD_cnt;
real VDS;
integer VDS_retc;
integer VDS_cnt;
real VDB;
integer VDB_retc;
integer VDB_cnt;
real VSB;
integer VSB_retc;
integer VSB_cnt;
real VBHW;
integer VBHW_retc;
integer VBHW_cnt;

analog begin
   $bound_step( tstep_occ );
   @(initial_step) begin
      VGS_retc=0;
      VGS_cnt = maxEv;
      VGD_retc=0;
      VGD_cnt = maxEv;
      VDS_retc=0;
      VDS_cnt = maxEv;
      VDB_retc=0;
      VDB_cnt = maxEv;
      VSB_retc=0;
      VSB_cnt = maxEv;
      VBHW_retc=0;
      VBHW_cnt = maxEv;
   end
   V_B_HW = V(B,HW);
   V_S_B = V(S,B);
   V_D_B = V(D,B);
   V_D_S = V(D,S);
   V_G_D = V(G,D);
   V_G_S = V(G,S);

//      VGS
   VGS = V_G_S;
   if((VGS_cnt>0) || ( maxEv_flg==0 ))   begin
      if( (VGS < -5.5) && (VGS_retc!=-1))
      begin
        outfile=$fopen(errFileName,"a");
        $strobe("phsj1_7       VGS     leaving   OCA (  .. -5.500 V ) at %7.4r  %M", $abstime );
        $fwrite(outfile,"phsj1_7       VGS     leaving   OCA (  .. -5.500 V ) at %7.4r  %M\n", $abstime );
        VGS_retc=-1;
        VGS_cnt=VGS_cnt-1;
        $fclose(outfile);
      end
      if((VGS >= -5.5) &&  (VGS <= 5.5) && (VGS_retc!=0))
      begin
        outfile=$fopen(errFileName,"a");
        $strobe("phsj1_7       VGS     entering SOCA ( -5.500 V .. 5.500 V ) at %7.4r  %M", $abstime );
        $fwrite(outfile,"phsj1_7       VGS     entering SOCA ( -5.500 V .. 5.500 V ) at %7.4r  %M\n", $abstime );
        VGS_retc=0;
        VGS_cnt=VGS_cnt-1;
        $fclose(outfile);
      end
      if((VGS > 5.5) &&  (VGS_retc!=1))
      begin
        outfile=$fopen(errFileName,"a");
        $strobe("phsj1_7       VGS     leaving   OCA ( 5.500 V ..  ) at %7.4r  %M", $abstime );
        $fwrite(outfile,"phsj1_7       VGS     leaving   OCA ( 5.500 V ..  ) at %7.4r  %M\n", $abstime );
        VGS_retc=1;
        VGS_cnt=VGS_cnt-1;
        $fclose(outfile);
      end
   end
   else
   begin
      if(VGS_cnt==0)
      begin
        outfile=$fopen(errFileName,"a");
        $strobe("phsj1_7       VGS     error limit ( %d ) reached at %7.4r  %M", maxEv, $abstime );
        $fwrite(outfile,"phsj1_7       VGS     error limit ( %d ) reached at %7.4r  %M\n", maxEv, $abstime );
        VGS_cnt=VGS_cnt-1;
        $fclose(outfile);
      end
   end

//      VGD
   VGD = V_G_D;
   if((VGD_cnt>0) || ( maxEv_flg==0 ))   begin
      if( (VGD < -5.5) && (VGD_retc!=-1))
      begin
        outfile=$fopen(errFileName,"a");
        $strobe("phsj1_7       VGD     leaving   OCA (  .. -5.500 V ) at %7.4r  %M", $abstime );
        $fwrite(outfile,"phsj1_7       VGD     leaving   OCA (  .. -5.500 V ) at %7.4r  %M\n", $abstime );
        VGD_retc=-1;
        VGD_cnt=VGD_cnt-1;
        $fclose(outfile);
      end
      if((VGD >= -5.5) &&  (VGD <= 100) && (VGD_retc!=0))
      begin
        outfile=$fopen(errFileName,"a");
        $strobe("phsj1_7       VGD     entering SOCA ( -5.500 V .. 100.000 V ) at %7.4r  %M", $abstime );
        $fwrite(outfile,"phsj1_7       VGD     entering SOCA ( -5.500 V .. 100.000 V ) at %7.4r  %M\n", $abstime );
        VGD_retc=0;
        VGD_cnt=VGD_cnt-1;
        $fclose(outfile);
      end
      if((VGD > 100) &&  (VGD_retc!=1))
      begin
        outfile=$fopen(errFileName,"a");
        $strobe("phsj1_7       VGD     leaving   OCA ( 100.000 V ..  ) at %7.4r  %M", $abstime );
        $fwrite(outfile,"phsj1_7       VGD     leaving   OCA ( 100.000 V ..  ) at %7.4r  %M\n", $abstime );
        VGD_retc=1;
        VGD_cnt=VGD_cnt-1;
        $fclose(outfile);
      end
   end
   else
   begin
      if(VGD_cnt==0)
      begin
        outfile=$fopen(errFileName,"a");
        $strobe("phsj1_7       VGD     error limit ( %d ) reached at %7.4r  %M", maxEv, $abstime );
        $fwrite(outfile,"phsj1_7       VGD     error limit ( %d ) reached at %7.4r  %M\n", maxEv, $abstime );
        VGD_cnt=VGD_cnt-1;
        $fclose(outfile);
      end
   end

//      VDS
   VDS = V_D_S;
   if((VDS_cnt>0) || ( maxEv_flg==0 ))   begin
      if( (VDS < -100) && (VDS_retc!=-1))
      begin
        outfile=$fopen(errFileName,"a");
        $strobe("phsj1_7       VDS     leaving   OCA (  .. -100.000 V ) at %7.4r  %M", $abstime );
        $fwrite(outfile,"phsj1_7       VDS     leaving   OCA (  .. -100.000 V ) at %7.4r  %M\n", $abstime );
        VDS_retc=-1;
        VDS_cnt=VDS_cnt-1;
        $fclose(outfile);
      end
      if((VDS >= -100) &&  (VDS <= 1.5) && (VDS_retc!=0))
      begin
        outfile=$fopen(errFileName,"a");
        $strobe("phsj1_7       VDS     entering SOCA ( -100.000 V .. 1.500 V ) at %7.4r  %M", $abstime );
        $fwrite(outfile,"phsj1_7       VDS     entering SOCA ( -100.000 V .. 1.500 V ) at %7.4r  %M\n", $abstime );
        VDS_retc=0;
        VDS_cnt=VDS_cnt-1;
        $fclose(outfile);
      end
      if((VDS > 1.5) &&  (VDS_retc!=1))
      begin
        outfile=$fopen(errFileName,"a");
        $strobe("phsj1_7       VDS     leaving   OCA ( 1.500 V ..  ) at %7.4r  %M", $abstime );
        $fwrite(outfile,"phsj1_7       VDS     leaving   OCA ( 1.500 V ..  ) at %7.4r  %M\n", $abstime );
        VDS_retc=1;
        VDS_cnt=VDS_cnt-1;
        $fclose(outfile);
      end
   end
   else
   begin
      if(VDS_cnt==0)
      begin
        outfile=$fopen(errFileName,"a");
        $strobe("phsj1_7       VDS     error limit ( %d ) reached at %7.4r  %M", maxEv, $abstime );
        $fwrite(outfile,"phsj1_7       VDS     error limit ( %d ) reached at %7.4r  %M\n", maxEv, $abstime );
        VDS_cnt=VDS_cnt-1;
        $fclose(outfile);
      end
   end

//      VDB
   VDB = V_D_B;
   if((VDB_cnt>0) || ( maxEv_flg==0 ))   begin
      if( (VDB < -100) && (VDB_retc!=-1))
      begin
        outfile=$fopen(errFileName,"a");
        $strobe("phsj1_7       VDB     leaving   OCA (  .. -100.000 V ) at %7.4r  %M", $abstime );
        $fwrite(outfile,"phsj1_7       VDB     leaving   OCA (  .. -100.000 V ) at %7.4r  %M\n", $abstime );
        VDB_retc=-1;
        VDB_cnt=VDB_cnt-1;
        $fclose(outfile);
      end
      if((VDB >= -100) &&  (VDB <= 1.5) && (VDB_retc!=0))
      begin
        outfile=$fopen(errFileName,"a");
        $strobe("phsj1_7       VDB     entering SOCA ( -100.000 V .. 1.500 V ) at %7.4r  %M", $abstime );
        $fwrite(outfile,"phsj1_7       VDB     entering SOCA ( -100.000 V .. 1.500 V ) at %7.4r  %M\n", $abstime );
        VDB_retc=0;
        VDB_cnt=VDB_cnt-1;
        $fclose(outfile);
      end
      if((VDB > 1.5) &&  (VDB_retc!=1))
      begin
        outfile=$fopen(errFileName,"a");
        $strobe("phsj1_7       VDB     leaving   OCA ( 1.500 V ..  ) at %7.4r  %M", $abstime );
        $fwrite(outfile,"phsj1_7       VDB     leaving   OCA ( 1.500 V ..  ) at %7.4r  %M\n", $abstime );
        VDB_retc=1;
        VDB_cnt=VDB_cnt-1;
        $fclose(outfile);
      end
   end
   else
   begin
      if(VDB_cnt==0)
      begin
        outfile=$fopen(errFileName,"a");
        $strobe("phsj1_7       VDB     error limit ( %d ) reached at %7.4r  %M", maxEv, $abstime );
        $fwrite(outfile,"phsj1_7       VDB     error limit ( %d ) reached at %7.4r  %M\n", maxEv, $abstime );
        VDB_cnt=VDB_cnt-1;
        $fclose(outfile);
      end
   end

//      VSB
   VSB = V_S_B;
   if((VSB_cnt>0) || ( maxEv_flg==0 ))   begin
      if( (VSB < -5.5) && (VSB_retc!=-1))
      begin
        outfile=$fopen(errFileName,"a");
        $strobe("phsj1_7       VSB     leaving   OCA (  .. -5.500 V ) at %7.4r  %M", $abstime );
        $fwrite(outfile,"phsj1_7       VSB     leaving   OCA (  .. -5.500 V ) at %7.4r  %M\n", $abstime );
        VSB_retc=-1;
        VSB_cnt=VSB_cnt-1;
        $fclose(outfile);
      end
      if((VSB >= -5.5) &&  (VSB <= 0.1) && (VSB_retc!=0))
      begin
        outfile=$fopen(errFileName,"a");
        $strobe("phsj1_7       VSB     entering SOCA ( -5.500 V .. 0.100 V ) at %7.4r  %M", $abstime );
        $fwrite(outfile,"phsj1_7       VSB     entering SOCA ( -5.500 V .. 0.100 V ) at %7.4r  %M\n", $abstime );
        VSB_retc=0;
        VSB_cnt=VSB_cnt-1;
        $fclose(outfile);
      end
      if((VSB > 0.1) &&  (VSB_retc!=1))
      begin
        outfile=$fopen(errFileName,"a");
        $strobe("phsj1_7       VSB     leaving   OCA ( 0.100 V ..  ) at %7.4r  %M", $abstime );
        $fwrite(outfile,"phsj1_7       VSB     leaving   OCA ( 0.100 V ..  ) at %7.4r  %M\n", $abstime );
        VSB_retc=1;
        VSB_cnt=VSB_cnt-1;
        $fclose(outfile);
      end
   end
   else
   begin
      if(VSB_cnt==0)
      begin
        outfile=$fopen(errFileName,"a");
        $strobe("phsj1_7       VSB     error limit ( %d ) reached at %7.4r  %M", maxEv, $abstime );
        $fwrite(outfile,"phsj1_7       VSB     error limit ( %d ) reached at %7.4r  %M\n", maxEv, $abstime );
        VSB_cnt=VSB_cnt-1;
        $fclose(outfile);
      end
   end

//      VBHW
   VBHW = V_B_HW;
   if((VBHW_cnt>0) || ( maxEv_flg==0 ))   begin
      if( (VBHW < -0.1) && (VBHW_retc!=-1))
      begin
        outfile=$fopen(errFileName,"a");
        $strobe("phsj1_7       VBHW    leaving   OCA (  .. -0.100 V ) at %7.4r  %M", $abstime );
        $fwrite(outfile,"phsj1_7       VBHW    leaving   OCA (  .. -0.100 V ) at %7.4r  %M\n", $abstime );
        VBHW_retc=-1;
        VBHW_cnt=VBHW_cnt-1;
        $fclose(outfile);
      end
      if((VBHW >= -0.1) &&  (VBHW <= 200) && (VBHW_retc!=0))
      begin
        outfile=$fopen(errFileName,"a");
        $strobe("phsj1_7       VBHW    entering SOCA ( -0.100 V .. 200.000 V ) at %7.4r  %M", $abstime );
        $fwrite(outfile,"phsj1_7       VBHW    entering SOCA ( -0.100 V .. 200.000 V ) at %7.4r  %M\n", $abstime );
        VBHW_retc=0;
        VBHW_cnt=VBHW_cnt-1;
        $fclose(outfile);
      end
      if((VBHW > 200) &&  (VBHW_retc!=1))
      begin
        outfile=$fopen(errFileName,"a");
        $strobe("phsj1_7       VBHW    leaving   OCA ( 200.000 V ..  ) at %7.4r  %M", $abstime );
        $fwrite(outfile,"phsj1_7       VBHW    leaving   OCA ( 200.000 V ..  ) at %7.4r  %M\n", $abstime );
        VBHW_retc=1;
        VBHW_cnt=VBHW_cnt-1;
        $fclose(outfile);
      end
   end
   else
   begin
      if(VBHW_cnt==0)
      begin
        outfile=$fopen(errFileName,"a");
        $strobe("phsj1_7       VBHW    error limit ( %d ) reached at %7.4r  %M", maxEv, $abstime );
        $fwrite(outfile,"phsj1_7       VBHW    error limit ( %d ) reached at %7.4r  %M\n", maxEv, $abstime );
        VBHW_cnt=VBHW_cnt-1;
        $fclose(outfile);
      end
   end

end // analog
endmodule // phsj1_7

// Verilog-A OC Watch for device phsj1_10 Parameters  VGS VGD VDS VDB VSB VBHW
module phsj1_10_ahdl(D,G,S,B,HW);
parameter tstep_occ=100n;
parameter errFileName="./occ.err";
parameter maxEv = 25;
parameter maxEv_flg = 0;
inout D,G,S,B,HW;
electrical D,G,S,B,HW;

integer outfile;
real V_B_HW;
real V_S_B;
real V_D_B;
real V_D_S;
real V_G_D;
real V_G_S;
real VGS;
integer VGS_retc;
integer VGS_cnt;
real VGD;
integer VGD_retc;
integer VGD_cnt;
real VDS;
integer VDS_retc;
integer VDS_cnt;
real VDB;
integer VDB_retc;
integer VDB_cnt;
real VSB;
integer VSB_retc;
integer VSB_cnt;
real VBHW;
integer VBHW_retc;
integer VBHW_cnt;

analog begin
   $bound_step( tstep_occ );
   @(initial_step) begin
      VGS_retc=0;
      VGS_cnt = maxEv;
      VGD_retc=0;
      VGD_cnt = maxEv;
      VDS_retc=0;
      VDS_cnt = maxEv;
      VDB_retc=0;
      VDB_cnt = maxEv;
      VSB_retc=0;
      VSB_cnt = maxEv;
      VBHW_retc=0;
      VBHW_cnt = maxEv;
   end
   V_B_HW = V(B,HW);
   V_S_B = V(S,B);
   V_D_B = V(D,B);
   V_D_S = V(D,S);
   V_G_D = V(G,D);
   V_G_S = V(G,S);

//      VGS
   VGS = V_G_S;
   if((VGS_cnt>0) || ( maxEv_flg==0 ))   begin
      if( (VGS < -5.5) && (VGS_retc!=-1))
      begin
        outfile=$fopen(errFileName,"a");
        $strobe("phsj1_10      VGS     leaving   OCA (  .. -5.500 V ) at %7.4r  %M", $abstime );
        $fwrite(outfile,"phsj1_10      VGS     leaving   OCA (  .. -5.500 V ) at %7.4r  %M\n", $abstime );
        VGS_retc=-1;
        VGS_cnt=VGS_cnt-1;
        $fclose(outfile);
      end
      if((VGS >= -5.5) &&  (VGS <= 5.5) && (VGS_retc!=0))
      begin
        outfile=$fopen(errFileName,"a");
        $strobe("phsj1_10      VGS     entering SOCA ( -5.500 V .. 5.500 V ) at %7.4r  %M", $abstime );
        $fwrite(outfile,"phsj1_10      VGS     entering SOCA ( -5.500 V .. 5.500 V ) at %7.4r  %M\n", $abstime );
        VGS_retc=0;
        VGS_cnt=VGS_cnt-1;
        $fclose(outfile);
      end
      if((VGS > 5.5) &&  (VGS_retc!=1))
      begin
        outfile=$fopen(errFileName,"a");
        $strobe("phsj1_10      VGS     leaving   OCA ( 5.500 V ..  ) at %7.4r  %M", $abstime );
        $fwrite(outfile,"phsj1_10      VGS     leaving   OCA ( 5.500 V ..  ) at %7.4r  %M\n", $abstime );
        VGS_retc=1;
        VGS_cnt=VGS_cnt-1;
        $fclose(outfile);
      end
   end
   else
   begin
      if(VGS_cnt==0)
      begin
        outfile=$fopen(errFileName,"a");
        $strobe("phsj1_10      VGS     error limit ( %d ) reached at %7.4r  %M", maxEv, $abstime );
        $fwrite(outfile,"phsj1_10      VGS     error limit ( %d ) reached at %7.4r  %M\n", maxEv, $abstime );
        VGS_cnt=VGS_cnt-1;
        $fclose(outfile);
      end
   end

//      VGD
   VGD = V_G_D;
   if((VGD_cnt>0) || ( maxEv_flg==0 ))   begin
      if( (VGD < -5.5) && (VGD_retc!=-1))
      begin
        outfile=$fopen(errFileName,"a");
        $strobe("phsj1_10      VGD     leaving   OCA (  .. -5.500 V ) at %7.4r  %M", $abstime );
        $fwrite(outfile,"phsj1_10      VGD     leaving   OCA (  .. -5.500 V ) at %7.4r  %M\n", $abstime );
        VGD_retc=-1;
        VGD_cnt=VGD_cnt-1;
        $fclose(outfile);
      end
      if((VGD >= -5.5) &&  (VGD <= 140) && (VGD_retc!=0))
      begin
        outfile=$fopen(errFileName,"a");
        $strobe("phsj1_10      VGD     entering SOCA ( -5.500 V .. 140.000 V ) at %7.4r  %M", $abstime );
        $fwrite(outfile,"phsj1_10      VGD     entering SOCA ( -5.500 V .. 140.000 V ) at %7.4r  %M\n", $abstime );
        VGD_retc=0;
        VGD_cnt=VGD_cnt-1;
        $fclose(outfile);
      end
      if((VGD > 140) &&  (VGD_retc!=1))
      begin
        outfile=$fopen(errFileName,"a");
        $strobe("phsj1_10      VGD     leaving   OCA ( 140.000 V ..  ) at %7.4r  %M", $abstime );
        $fwrite(outfile,"phsj1_10      VGD     leaving   OCA ( 140.000 V ..  ) at %7.4r  %M\n", $abstime );
        VGD_retc=1;
        VGD_cnt=VGD_cnt-1;
        $fclose(outfile);
      end
   end
   else
   begin
      if(VGD_cnt==0)
      begin
        outfile=$fopen(errFileName,"a");
        $strobe("phsj1_10      VGD     error limit ( %d ) reached at %7.4r  %M", maxEv, $abstime );
        $fwrite(outfile,"phsj1_10      VGD     error limit ( %d ) reached at %7.4r  %M\n", maxEv, $abstime );
        VGD_cnt=VGD_cnt-1;
        $fclose(outfile);
      end
   end

//      VDS
   VDS = V_D_S;
   if((VDS_cnt>0) || ( maxEv_flg==0 ))   begin
      if( (VDS < -140) && (VDS_retc!=-1))
      begin
        outfile=$fopen(errFileName,"a");
        $strobe("phsj1_10      VDS     leaving   OCA (  .. -140.000 V ) at %7.4r  %M", $abstime );
        $fwrite(outfile,"phsj1_10      VDS     leaving   OCA (  .. -140.000 V ) at %7.4r  %M\n", $abstime );
        VDS_retc=-1;
        VDS_cnt=VDS_cnt-1;
        $fclose(outfile);
      end
      if((VDS >= -140) &&  (VDS <= 1.5) && (VDS_retc!=0))
      begin
        outfile=$fopen(errFileName,"a");
        $strobe("phsj1_10      VDS     entering SOCA ( -140.000 V .. 1.500 V ) at %7.4r  %M", $abstime );
        $fwrite(outfile,"phsj1_10      VDS     entering SOCA ( -140.000 V .. 1.500 V ) at %7.4r  %M\n", $abstime );
        VDS_retc=0;
        VDS_cnt=VDS_cnt-1;
        $fclose(outfile);
      end
      if((VDS > 1.5) &&  (VDS_retc!=1))
      begin
        outfile=$fopen(errFileName,"a");
        $strobe("phsj1_10      VDS     leaving   OCA ( 1.500 V ..  ) at %7.4r  %M", $abstime );
        $fwrite(outfile,"phsj1_10      VDS     leaving   OCA ( 1.500 V ..  ) at %7.4r  %M\n", $abstime );
        VDS_retc=1;
        VDS_cnt=VDS_cnt-1;
        $fclose(outfile);
      end
   end
   else
   begin
      if(VDS_cnt==0)
      begin
        outfile=$fopen(errFileName,"a");
        $strobe("phsj1_10      VDS     error limit ( %d ) reached at %7.4r  %M", maxEv, $abstime );
        $fwrite(outfile,"phsj1_10      VDS     error limit ( %d ) reached at %7.4r  %M\n", maxEv, $abstime );
        VDS_cnt=VDS_cnt-1;
        $fclose(outfile);
      end
   end

//      VDB
   VDB = V_D_B;
   if((VDB_cnt>0) || ( maxEv_flg==0 ))   begin
      if( (VDB < -140) && (VDB_retc!=-1))
      begin
        outfile=$fopen(errFileName,"a");
        $strobe("phsj1_10      VDB     leaving   OCA (  .. -140.000 V ) at %7.4r  %M", $abstime );
        $fwrite(outfile,"phsj1_10      VDB     leaving   OCA (  .. -140.000 V ) at %7.4r  %M\n", $abstime );
        VDB_retc=-1;
        VDB_cnt=VDB_cnt-1;
        $fclose(outfile);
      end
      if((VDB >= -140) &&  (VDB <= 1.5) && (VDB_retc!=0))
      begin
        outfile=$fopen(errFileName,"a");
        $strobe("phsj1_10      VDB     entering SOCA ( -140.000 V .. 1.500 V ) at %7.4r  %M", $abstime );
        $fwrite(outfile,"phsj1_10      VDB     entering SOCA ( -140.000 V .. 1.500 V ) at %7.4r  %M\n", $abstime );
        VDB_retc=0;
        VDB_cnt=VDB_cnt-1;
        $fclose(outfile);
      end
      if((VDB > 1.5) &&  (VDB_retc!=1))
      begin
        outfile=$fopen(errFileName,"a");
        $strobe("phsj1_10      VDB     leaving   OCA ( 1.500 V ..  ) at %7.4r  %M", $abstime );
        $fwrite(outfile,"phsj1_10      VDB     leaving   OCA ( 1.500 V ..  ) at %7.4r  %M\n", $abstime );
        VDB_retc=1;
        VDB_cnt=VDB_cnt-1;
        $fclose(outfile);
      end
   end
   else
   begin
      if(VDB_cnt==0)
      begin
        outfile=$fopen(errFileName,"a");
        $strobe("phsj1_10      VDB     error limit ( %d ) reached at %7.4r  %M", maxEv, $abstime );
        $fwrite(outfile,"phsj1_10      VDB     error limit ( %d ) reached at %7.4r  %M\n", maxEv, $abstime );
        VDB_cnt=VDB_cnt-1;
        $fclose(outfile);
      end
   end

//      VSB
   VSB = V_S_B;
   if((VSB_cnt>0) || ( maxEv_flg==0 ))   begin
      if( (VSB < -5.5) && (VSB_retc!=-1))
      begin
        outfile=$fopen(errFileName,"a");
        $strobe("phsj1_10      VSB     leaving   OCA (  .. -5.500 V ) at %7.4r  %M", $abstime );
        $fwrite(outfile,"phsj1_10      VSB     leaving   OCA (  .. -5.500 V ) at %7.4r  %M\n", $abstime );
        VSB_retc=-1;
        VSB_cnt=VSB_cnt-1;
        $fclose(outfile);
      end
      if((VSB >= -5.5) &&  (VSB <= 0.1) && (VSB_retc!=0))
      begin
        outfile=$fopen(errFileName,"a");
        $strobe("phsj1_10      VSB     entering SOCA ( -5.500 V .. 0.100 V ) at %7.4r  %M", $abstime );
        $fwrite(outfile,"phsj1_10      VSB     entering SOCA ( -5.500 V .. 0.100 V ) at %7.4r  %M\n", $abstime );
        VSB_retc=0;
        VSB_cnt=VSB_cnt-1;
        $fclose(outfile);
      end
      if((VSB > 0.1) &&  (VSB_retc!=1))
      begin
        outfile=$fopen(errFileName,"a");
        $strobe("phsj1_10      VSB     leaving   OCA ( 0.100 V ..  ) at %7.4r  %M", $abstime );
        $fwrite(outfile,"phsj1_10      VSB     leaving   OCA ( 0.100 V ..  ) at %7.4r  %M\n", $abstime );
        VSB_retc=1;
        VSB_cnt=VSB_cnt-1;
        $fclose(outfile);
      end
   end
   else
   begin
      if(VSB_cnt==0)
      begin
        outfile=$fopen(errFileName,"a");
        $strobe("phsj1_10      VSB     error limit ( %d ) reached at %7.4r  %M", maxEv, $abstime );
        $fwrite(outfile,"phsj1_10      VSB     error limit ( %d ) reached at %7.4r  %M\n", maxEv, $abstime );
        VSB_cnt=VSB_cnt-1;
        $fclose(outfile);
      end
   end

//      VBHW
   VBHW = V_B_HW;
   if((VBHW_cnt>0) || ( maxEv_flg==0 ))   begin
      if( (VBHW < -0.1) && (VBHW_retc!=-1))
      begin
        outfile=$fopen(errFileName,"a");
        $strobe("phsj1_10      VBHW    leaving   OCA (  .. -0.100 V ) at %7.4r  %M", $abstime );
        $fwrite(outfile,"phsj1_10      VBHW    leaving   OCA (  .. -0.100 V ) at %7.4r  %M\n", $abstime );
        VBHW_retc=-1;
        VBHW_cnt=VBHW_cnt-1;
        $fclose(outfile);
      end
      if((VBHW >= -0.1) &&  (VBHW <= 200) && (VBHW_retc!=0))
      begin
        outfile=$fopen(errFileName,"a");
        $strobe("phsj1_10      VBHW    entering SOCA ( -0.100 V .. 200.000 V ) at %7.4r  %M", $abstime );
        $fwrite(outfile,"phsj1_10      VBHW    entering SOCA ( -0.100 V .. 200.000 V ) at %7.4r  %M\n", $abstime );
        VBHW_retc=0;
        VBHW_cnt=VBHW_cnt-1;
        $fclose(outfile);
      end
      if((VBHW > 200) &&  (VBHW_retc!=1))
      begin
        outfile=$fopen(errFileName,"a");
        $strobe("phsj1_10      VBHW    leaving   OCA ( 200.000 V ..  ) at %7.4r  %M", $abstime );
        $fwrite(outfile,"phsj1_10      VBHW    leaving   OCA ( 200.000 V ..  ) at %7.4r  %M\n", $abstime );
        VBHW_retc=1;
        VBHW_cnt=VBHW_cnt-1;
        $fclose(outfile);
      end
   end
   else
   begin
      if(VBHW_cnt==0)
      begin
        outfile=$fopen(errFileName,"a");
        $strobe("phsj1_10      VBHW    error limit ( %d ) reached at %7.4r  %M", maxEv, $abstime );
        $fwrite(outfile,"phsj1_10      VBHW    error limit ( %d ) reached at %7.4r  %M\n", maxEv, $abstime );
        VBHW_cnt=VBHW_cnt-1;
        $fclose(outfile);
      end
   end

end // analog
endmodule // phsj1_10

// Verilog-A OC Watch for device phsj1_16c Parameters  VGS VGD VDS VDB VSB VBHW
module phsj1_16c_ahdl(D,G,S,B,HW);
parameter tstep_occ=100n;
parameter errFileName="./occ.err";
parameter maxEv = 25;
parameter maxEv_flg = 0;
inout D,G,S,B,HW;
electrical D,G,S,B,HW;

integer outfile;
real V_B_HW;
real V_S_B;
real V_D_B;
real V_D_S;
real V_G_D;
real V_G_S;
real VGS;
integer VGS_retc;
integer VGS_cnt;
real VGD;
integer VGD_retc;
integer VGD_cnt;
real VDS;
integer VDS_retc;
integer VDS_cnt;
real VDB;
integer VDB_retc;
integer VDB_cnt;
real VSB;
integer VSB_retc;
integer VSB_cnt;
real VBHW;
integer VBHW_retc;
integer VBHW_cnt;

analog begin
   $bound_step( tstep_occ );
   @(initial_step) begin
      VGS_retc=0;
      VGS_cnt = maxEv;
      VGD_retc=0;
      VGD_cnt = maxEv;
      VDS_retc=0;
      VDS_cnt = maxEv;
      VDB_retc=0;
      VDB_cnt = maxEv;
      VSB_retc=0;
      VSB_cnt = maxEv;
      VBHW_retc=0;
      VBHW_cnt = maxEv;
   end
   V_B_HW = V(B,HW);
   V_S_B = V(S,B);
   V_D_B = V(D,B);
   V_D_S = V(D,S);
   V_G_D = V(G,D);
   V_G_S = V(G,S);

//      VGS
   VGS = V_G_S;
   if((VGS_cnt>0) || ( maxEv_flg==0 ))   begin
      if( (VGS < -5.5) && (VGS_retc!=-1))
      begin
        outfile=$fopen(errFileName,"a");
        $strobe("phsj1_16c     VGS     leaving   OCA (  .. -5.500 V ) at %7.4r  %M", $abstime );
        $fwrite(outfile,"phsj1_16c     VGS     leaving   OCA (  .. -5.500 V ) at %7.4r  %M\n", $abstime );
        VGS_retc=-1;
        VGS_cnt=VGS_cnt-1;
        $fclose(outfile);
      end
      if((VGS >= -5.5) &&  (VGS <= 5.5) && (VGS_retc!=0))
      begin
        outfile=$fopen(errFileName,"a");
        $strobe("phsj1_16c     VGS     entering SOCA ( -5.500 V .. 5.500 V ) at %7.4r  %M", $abstime );
        $fwrite(outfile,"phsj1_16c     VGS     entering SOCA ( -5.500 V .. 5.500 V ) at %7.4r  %M\n", $abstime );
        VGS_retc=0;
        VGS_cnt=VGS_cnt-1;
        $fclose(outfile);
      end
      if((VGS > 5.5) &&  (VGS_retc!=1))
      begin
        outfile=$fopen(errFileName,"a");
        $strobe("phsj1_16c     VGS     leaving   OCA ( 5.500 V ..  ) at %7.4r  %M", $abstime );
        $fwrite(outfile,"phsj1_16c     VGS     leaving   OCA ( 5.500 V ..  ) at %7.4r  %M\n", $abstime );
        VGS_retc=1;
        VGS_cnt=VGS_cnt-1;
        $fclose(outfile);
      end
   end
   else
   begin
      if(VGS_cnt==0)
      begin
        outfile=$fopen(errFileName,"a");
        $strobe("phsj1_16c     VGS     error limit ( %d ) reached at %7.4r  %M", maxEv, $abstime );
        $fwrite(outfile,"phsj1_16c     VGS     error limit ( %d ) reached at %7.4r  %M\n", maxEv, $abstime );
        VGS_cnt=VGS_cnt-1;
        $fclose(outfile);
      end
   end

//      VGD
   VGD = V_G_D;
   if((VGD_cnt>0) || ( maxEv_flg==0 ))   begin
      if( (VGD < -5.5) && (VGD_retc!=-1))
      begin
        outfile=$fopen(errFileName,"a");
        $strobe("phsj1_16c     VGD     leaving   OCA (  .. -5.500 V ) at %7.4r  %M", $abstime );
        $fwrite(outfile,"phsj1_16c     VGD     leaving   OCA (  .. -5.500 V ) at %7.4r  %M\n", $abstime );
        VGD_retc=-1;
        VGD_cnt=VGD_cnt-1;
        $fclose(outfile);
      end
      if((VGD >= -5.5) &&  (VGD <= 200) && (VGD_retc!=0))
      begin
        outfile=$fopen(errFileName,"a");
        $strobe("phsj1_16c     VGD     entering SOCA ( -5.500 V .. 200.000 V ) at %7.4r  %M", $abstime );
        $fwrite(outfile,"phsj1_16c     VGD     entering SOCA ( -5.500 V .. 200.000 V ) at %7.4r  %M\n", $abstime );
        VGD_retc=0;
        VGD_cnt=VGD_cnt-1;
        $fclose(outfile);
      end
      if((VGD > 200) &&  (VGD_retc!=1))
      begin
        outfile=$fopen(errFileName,"a");
        $strobe("phsj1_16c     VGD     leaving   OCA ( 200.000 V ..  ) at %7.4r  %M", $abstime );
        $fwrite(outfile,"phsj1_16c     VGD     leaving   OCA ( 200.000 V ..  ) at %7.4r  %M\n", $abstime );
        VGD_retc=1;
        VGD_cnt=VGD_cnt-1;
        $fclose(outfile);
      end
   end
   else
   begin
      if(VGD_cnt==0)
      begin
        outfile=$fopen(errFileName,"a");
        $strobe("phsj1_16c     VGD     error limit ( %d ) reached at %7.4r  %M", maxEv, $abstime );
        $fwrite(outfile,"phsj1_16c     VGD     error limit ( %d ) reached at %7.4r  %M\n", maxEv, $abstime );
        VGD_cnt=VGD_cnt-1;
        $fclose(outfile);
      end
   end

//      VDS
   VDS = V_D_S;
   if((VDS_cnt>0) || ( maxEv_flg==0 ))   begin
      if( (VDS < -200) && (VDS_retc!=-1))
      begin
        outfile=$fopen(errFileName,"a");
        $strobe("phsj1_16c     VDS     leaving   OCA (  .. -200.000 V ) at %7.4r  %M", $abstime );
        $fwrite(outfile,"phsj1_16c     VDS     leaving   OCA (  .. -200.000 V ) at %7.4r  %M\n", $abstime );
        VDS_retc=-1;
        VDS_cnt=VDS_cnt-1;
        $fclose(outfile);
      end
      if((VDS >= -200) &&  (VDS <= 1.5) && (VDS_retc!=0))
      begin
        outfile=$fopen(errFileName,"a");
        $strobe("phsj1_16c     VDS     entering SOCA ( -200.000 V .. 1.500 V ) at %7.4r  %M", $abstime );
        $fwrite(outfile,"phsj1_16c     VDS     entering SOCA ( -200.000 V .. 1.500 V ) at %7.4r  %M\n", $abstime );
        VDS_retc=0;
        VDS_cnt=VDS_cnt-1;
        $fclose(outfile);
      end
      if((VDS > 1.5) &&  (VDS_retc!=1))
      begin
        outfile=$fopen(errFileName,"a");
        $strobe("phsj1_16c     VDS     leaving   OCA ( 1.500 V ..  ) at %7.4r  %M", $abstime );
        $fwrite(outfile,"phsj1_16c     VDS     leaving   OCA ( 1.500 V ..  ) at %7.4r  %M\n", $abstime );
        VDS_retc=1;
        VDS_cnt=VDS_cnt-1;
        $fclose(outfile);
      end
   end
   else
   begin
      if(VDS_cnt==0)
      begin
        outfile=$fopen(errFileName,"a");
        $strobe("phsj1_16c     VDS     error limit ( %d ) reached at %7.4r  %M", maxEv, $abstime );
        $fwrite(outfile,"phsj1_16c     VDS     error limit ( %d ) reached at %7.4r  %M\n", maxEv, $abstime );
        VDS_cnt=VDS_cnt-1;
        $fclose(outfile);
      end
   end

//      VDB
   VDB = V_D_B;
   if((VDB_cnt>0) || ( maxEv_flg==0 ))   begin
      if( (VDB < -200) && (VDB_retc!=-1))
      begin
        outfile=$fopen(errFileName,"a");
        $strobe("phsj1_16c     VDB     leaving   OCA (  .. -200.000 V ) at %7.4r  %M", $abstime );
        $fwrite(outfile,"phsj1_16c     VDB     leaving   OCA (  .. -200.000 V ) at %7.4r  %M\n", $abstime );
        VDB_retc=-1;
        VDB_cnt=VDB_cnt-1;
        $fclose(outfile);
      end
      if((VDB >= -200) &&  (VDB <= 1.5) && (VDB_retc!=0))
      begin
        outfile=$fopen(errFileName,"a");
        $strobe("phsj1_16c     VDB     entering SOCA ( -200.000 V .. 1.500 V ) at %7.4r  %M", $abstime );
        $fwrite(outfile,"phsj1_16c     VDB     entering SOCA ( -200.000 V .. 1.500 V ) at %7.4r  %M\n", $abstime );
        VDB_retc=0;
        VDB_cnt=VDB_cnt-1;
        $fclose(outfile);
      end
      if((VDB > 1.5) &&  (VDB_retc!=1))
      begin
        outfile=$fopen(errFileName,"a");
        $strobe("phsj1_16c     VDB     leaving   OCA ( 1.500 V ..  ) at %7.4r  %M", $abstime );
        $fwrite(outfile,"phsj1_16c     VDB     leaving   OCA ( 1.500 V ..  ) at %7.4r  %M\n", $abstime );
        VDB_retc=1;
        VDB_cnt=VDB_cnt-1;
        $fclose(outfile);
      end
   end
   else
   begin
      if(VDB_cnt==0)
      begin
        outfile=$fopen(errFileName,"a");
        $strobe("phsj1_16c     VDB     error limit ( %d ) reached at %7.4r  %M", maxEv, $abstime );
        $fwrite(outfile,"phsj1_16c     VDB     error limit ( %d ) reached at %7.4r  %M\n", maxEv, $abstime );
        VDB_cnt=VDB_cnt-1;
        $fclose(outfile);
      end
   end

//      VSB
   VSB = V_S_B;
   if((VSB_cnt>0) || ( maxEv_flg==0 ))   begin
      if( (VSB < -5.5) && (VSB_retc!=-1))
      begin
        outfile=$fopen(errFileName,"a");
        $strobe("phsj1_16c     VSB     leaving   OCA (  .. -5.500 V ) at %7.4r  %M", $abstime );
        $fwrite(outfile,"phsj1_16c     VSB     leaving   OCA (  .. -5.500 V ) at %7.4r  %M\n", $abstime );
        VSB_retc=-1;
        VSB_cnt=VSB_cnt-1;
        $fclose(outfile);
      end
      if((VSB >= -5.5) &&  (VSB <= 0.1) && (VSB_retc!=0))
      begin
        outfile=$fopen(errFileName,"a");
        $strobe("phsj1_16c     VSB     entering SOCA ( -5.500 V .. 0.100 V ) at %7.4r  %M", $abstime );
        $fwrite(outfile,"phsj1_16c     VSB     entering SOCA ( -5.500 V .. 0.100 V ) at %7.4r  %M\n", $abstime );
        VSB_retc=0;
        VSB_cnt=VSB_cnt-1;
        $fclose(outfile);
      end
      if((VSB > 0.1) &&  (VSB_retc!=1))
      begin
        outfile=$fopen(errFileName,"a");
        $strobe("phsj1_16c     VSB     leaving   OCA ( 0.100 V ..  ) at %7.4r  %M", $abstime );
        $fwrite(outfile,"phsj1_16c     VSB     leaving   OCA ( 0.100 V ..  ) at %7.4r  %M\n", $abstime );
        VSB_retc=1;
        VSB_cnt=VSB_cnt-1;
        $fclose(outfile);
      end
   end
   else
   begin
      if(VSB_cnt==0)
      begin
        outfile=$fopen(errFileName,"a");
        $strobe("phsj1_16c     VSB     error limit ( %d ) reached at %7.4r  %M", maxEv, $abstime );
        $fwrite(outfile,"phsj1_16c     VSB     error limit ( %d ) reached at %7.4r  %M\n", maxEv, $abstime );
        VSB_cnt=VSB_cnt-1;
        $fclose(outfile);
      end
   end

//      VBHW
   VBHW = V_B_HW;
   if((VBHW_cnt>0) || ( maxEv_flg==0 ))   begin
      if( (VBHW < -0.1) && (VBHW_retc!=-1))
      begin
        outfile=$fopen(errFileName,"a");
        $strobe("phsj1_16c     VBHW    leaving   OCA (  .. -0.100 V ) at %7.4r  %M", $abstime );
        $fwrite(outfile,"phsj1_16c     VBHW    leaving   OCA (  .. -0.100 V ) at %7.4r  %M\n", $abstime );
        VBHW_retc=-1;
        VBHW_cnt=VBHW_cnt-1;
        $fclose(outfile);
      end
      if((VBHW >= -0.1) &&  (VBHW <= 200) && (VBHW_retc!=0))
      begin
        outfile=$fopen(errFileName,"a");
        $strobe("phsj1_16c     VBHW    entering SOCA ( -0.100 V .. 200.000 V ) at %7.4r  %M", $abstime );
        $fwrite(outfile,"phsj1_16c     VBHW    entering SOCA ( -0.100 V .. 200.000 V ) at %7.4r  %M\n", $abstime );
        VBHW_retc=0;
        VBHW_cnt=VBHW_cnt-1;
        $fclose(outfile);
      end
      if((VBHW > 200) &&  (VBHW_retc!=1))
      begin
        outfile=$fopen(errFileName,"a");
        $strobe("phsj1_16c     VBHW    leaving   OCA ( 200.000 V ..  ) at %7.4r  %M", $abstime );
        $fwrite(outfile,"phsj1_16c     VBHW    leaving   OCA ( 200.000 V ..  ) at %7.4r  %M\n", $abstime );
        VBHW_retc=1;
        VBHW_cnt=VBHW_cnt-1;
        $fclose(outfile);
      end
   end
   else
   begin
      if(VBHW_cnt==0)
      begin
        outfile=$fopen(errFileName,"a");
        $strobe("phsj1_16c     VBHW    error limit ( %d ) reached at %7.4r  %M", maxEv, $abstime );
        $fwrite(outfile,"phsj1_16c     VBHW    error limit ( %d ) reached at %7.4r  %M\n", maxEv, $abstime );
        VBHW_cnt=VBHW_cnt-1;
        $fclose(outfile);
      end
   end

end // analog
endmodule // phsj1_16c

// Verilog-A OC Watch for device qpva Parameters  VCE VEB VBC
module qpva_ahdl(C,B,E);
parameter tstep_occ=100n;
parameter errFileName="./occ.err";
parameter maxEv = 25;
parameter maxEv_flg = 0;
inout C,B,E;
electrical C,B,E;

integer outfile;
real V_B_C;
real V_E_B;
real V_C_E;
real VCE;
integer VCE_retc;
integer VCE_cnt;
real VEB;
integer VEB_retc;
integer VEB_cnt;
real VBC;
integer VBC_retc;
integer VBC_cnt;

analog begin
   $bound_step( tstep_occ );
   @(initial_step) begin
      VCE_retc=0;
      VCE_cnt = maxEv;
      VEB_retc=0;
      VEB_cnt = maxEv;
      VBC_retc=0;
      VBC_cnt = maxEv;
   end
   V_B_C = V(B,C);
   V_E_B = V(E,B);
   V_C_E = V(C,E);

//      VCE
   VCE = V_C_E;
   if((VCE_cnt>0) || ( maxEv_flg==0 ))   begin
      if( (VCE < -1.98) && (VCE_retc!=-1))
      begin
        outfile=$fopen(errFileName,"a");
        $strobe("qpva          VCE     leaving   OCA (  .. -1.980 V ) at %7.4r  %M", $abstime );
        $fwrite(outfile,"qpva          VCE     leaving   OCA (  .. -1.980 V ) at %7.4r  %M\n", $abstime );
        VCE_retc=-1;
        VCE_cnt=VCE_cnt-1;
        $fclose(outfile);
      end
      if((VCE >= -1.98) &&  (VCE <= 0.1) && (VCE_retc!=0))
      begin
        outfile=$fopen(errFileName,"a");
        $strobe("qpva          VCE     entering SOCA ( -1.980 V .. 0.100 V ) at %7.4r  %M", $abstime );
        $fwrite(outfile,"qpva          VCE     entering SOCA ( -1.980 V .. 0.100 V ) at %7.4r  %M\n", $abstime );
        VCE_retc=0;
        VCE_cnt=VCE_cnt-1;
        $fclose(outfile);
      end
      if((VCE > 0.1) &&  (VCE_retc!=1))
      begin
        outfile=$fopen(errFileName,"a");
        $strobe("qpva          VCE     leaving   OCA ( 0.100 V ..  ) at %7.4r  %M", $abstime );
        $fwrite(outfile,"qpva          VCE     leaving   OCA ( 0.100 V ..  ) at %7.4r  %M\n", $abstime );
        VCE_retc=1;
        VCE_cnt=VCE_cnt-1;
        $fclose(outfile);
      end
   end
   else
   begin
      if(VCE_cnt==0)
      begin
        outfile=$fopen(errFileName,"a");
        $strobe("qpva          VCE     error limit ( %d ) reached at %7.4r  %M", maxEv, $abstime );
        $fwrite(outfile,"qpva          VCE     error limit ( %d ) reached at %7.4r  %M\n", maxEv, $abstime );
        VCE_cnt=VCE_cnt-1;
        $fclose(outfile);
      end
   end

//      VEB
   VEB = V_E_B;
   if((VEB_cnt>0) || ( maxEv_flg==0 ))   begin
      if( (VEB < -1.98) && (VEB_retc!=-1))
      begin
        outfile=$fopen(errFileName,"a");
        $strobe("qpva          VEB     leaving   OCA (  .. -1.980 V ) at %7.4r  %M", $abstime );
        $fwrite(outfile,"qpva          VEB     leaving   OCA (  .. -1.980 V ) at %7.4r  %M\n", $abstime );
        VEB_retc=-1;
        VEB_cnt=VEB_cnt-1;
        $fclose(outfile);
      end
      if((VEB >= -1.98) &&  (VEB <= 1.5) && (VEB_retc!=0))
      begin
        outfile=$fopen(errFileName,"a");
        $strobe("qpva          VEB     entering SOCA ( -1.980 V .. 1.500 V ) at %7.4r  %M", $abstime );
        $fwrite(outfile,"qpva          VEB     entering SOCA ( -1.980 V .. 1.500 V ) at %7.4r  %M\n", $abstime );
        VEB_retc=0;
        VEB_cnt=VEB_cnt-1;
        $fclose(outfile);
      end
      if((VEB > 1.5) &&  (VEB_retc!=1))
      begin
        outfile=$fopen(errFileName,"a");
        $strobe("qpva          VEB     leaving   OCA ( 1.500 V ..  ) at %7.4r  %M", $abstime );
        $fwrite(outfile,"qpva          VEB     leaving   OCA ( 1.500 V ..  ) at %7.4r  %M\n", $abstime );
        VEB_retc=1;
        VEB_cnt=VEB_cnt-1;
        $fclose(outfile);
      end
   end
   else
   begin
      if(VEB_cnt==0)
      begin
        outfile=$fopen(errFileName,"a");
        $strobe("qpva          VEB     error limit ( %d ) reached at %7.4r  %M", maxEv, $abstime );
        $fwrite(outfile,"qpva          VEB     error limit ( %d ) reached at %7.4r  %M\n", maxEv, $abstime );
        VEB_cnt=VEB_cnt-1;
        $fclose(outfile);
      end
   end

//      VBC
   VBC = V_B_C;
   if((VBC_cnt>0) || ( maxEv_flg==0 ))   begin
      if( (VBC < -0.1) && (VBC_retc!=-1))
      begin
        outfile=$fopen(errFileName,"a");
        $strobe("qpva          VBC     leaving   OCA (  .. -0.100 V ) at %7.4r  %M", $abstime );
        $fwrite(outfile,"qpva          VBC     leaving   OCA (  .. -0.100 V ) at %7.4r  %M\n", $abstime );
        VBC_retc=-1;
        VBC_cnt=VBC_cnt-1;
        $fclose(outfile);
      end
      if((VBC >= -0.1) &&  (VBC <= 1.98) && (VBC_retc!=0))
      begin
        outfile=$fopen(errFileName,"a");
        $strobe("qpva          VBC     entering SOCA ( -0.100 V .. 1.980 V ) at %7.4r  %M", $abstime );
        $fwrite(outfile,"qpva          VBC     entering SOCA ( -0.100 V .. 1.980 V ) at %7.4r  %M\n", $abstime );
        VBC_retc=0;
        VBC_cnt=VBC_cnt-1;
        $fclose(outfile);
      end
      if((VBC > 1.98) &&  (VBC_retc!=1))
      begin
        outfile=$fopen(errFileName,"a");
        $strobe("qpva          VBC     leaving   OCA ( 1.980 V ..  ) at %7.4r  %M", $abstime );
        $fwrite(outfile,"qpva          VBC     leaving   OCA ( 1.980 V ..  ) at %7.4r  %M\n", $abstime );
        VBC_retc=1;
        VBC_cnt=VBC_cnt-1;
        $fclose(outfile);
      end
   end
   else
   begin
      if(VBC_cnt==0)
      begin
        outfile=$fopen(errFileName,"a");
        $strobe("qpva          VBC     error limit ( %d ) reached at %7.4r  %M", maxEv, $abstime );
        $fwrite(outfile,"qpva          VBC     error limit ( %d ) reached at %7.4r  %M\n", maxEv, $abstime );
        VBC_cnt=VBC_cnt-1;
        $fclose(outfile);
      end
   end

end // analog
endmodule // qpva

// Verilog-A OC Watch for device qpvb Parameters  VCE VEB VBC
module qpvb_ahdl(C,B,E);
parameter tstep_occ=100n;
parameter errFileName="./occ.err";
parameter maxEv = 25;
parameter maxEv_flg = 0;
inout C,B,E;
electrical C,B,E;

integer outfile;
real V_B_C;
real V_E_B;
real V_C_E;
real VCE;
integer VCE_retc;
integer VCE_cnt;
real VEB;
integer VEB_retc;
integer VEB_cnt;
real VBC;
integer VBC_retc;
integer VBC_cnt;

analog begin
   $bound_step( tstep_occ );
   @(initial_step) begin
      VCE_retc=0;
      VCE_cnt = maxEv;
      VEB_retc=0;
      VEB_cnt = maxEv;
      VBC_retc=0;
      VBC_cnt = maxEv;
   end
   V_B_C = V(B,C);
   V_E_B = V(E,B);
   V_C_E = V(C,E);

//      VCE
   VCE = V_C_E;
   if((VCE_cnt>0) || ( maxEv_flg==0 ))   begin
      if( (VCE < -1.98) && (VCE_retc!=-1))
      begin
        outfile=$fopen(errFileName,"a");
        $strobe("qpvb          VCE     leaving   OCA (  .. -1.980 V ) at %7.4r  %M", $abstime );
        $fwrite(outfile,"qpvb          VCE     leaving   OCA (  .. -1.980 V ) at %7.4r  %M\n", $abstime );
        VCE_retc=-1;
        VCE_cnt=VCE_cnt-1;
        $fclose(outfile);
      end
      if((VCE >= -1.98) &&  (VCE <= 0.1) && (VCE_retc!=0))
      begin
        outfile=$fopen(errFileName,"a");
        $strobe("qpvb          VCE     entering SOCA ( -1.980 V .. 0.100 V ) at %7.4r  %M", $abstime );
        $fwrite(outfile,"qpvb          VCE     entering SOCA ( -1.980 V .. 0.100 V ) at %7.4r  %M\n", $abstime );
        VCE_retc=0;
        VCE_cnt=VCE_cnt-1;
        $fclose(outfile);
      end
      if((VCE > 0.1) &&  (VCE_retc!=1))
      begin
        outfile=$fopen(errFileName,"a");
        $strobe("qpvb          VCE     leaving   OCA ( 0.100 V ..  ) at %7.4r  %M", $abstime );
        $fwrite(outfile,"qpvb          VCE     leaving   OCA ( 0.100 V ..  ) at %7.4r  %M\n", $abstime );
        VCE_retc=1;
        VCE_cnt=VCE_cnt-1;
        $fclose(outfile);
      end
   end
   else
   begin
      if(VCE_cnt==0)
      begin
        outfile=$fopen(errFileName,"a");
        $strobe("qpvb          VCE     error limit ( %d ) reached at %7.4r  %M", maxEv, $abstime );
        $fwrite(outfile,"qpvb          VCE     error limit ( %d ) reached at %7.4r  %M\n", maxEv, $abstime );
        VCE_cnt=VCE_cnt-1;
        $fclose(outfile);
      end
   end

//      VEB
   VEB = V_E_B;
   if((VEB_cnt>0) || ( maxEv_flg==0 ))   begin
      if( (VEB < -1.98) && (VEB_retc!=-1))
      begin
        outfile=$fopen(errFileName,"a");
        $strobe("qpvb          VEB     leaving   OCA (  .. -1.980 V ) at %7.4r  %M", $abstime );
        $fwrite(outfile,"qpvb          VEB     leaving   OCA (  .. -1.980 V ) at %7.4r  %M\n", $abstime );
        VEB_retc=-1;
        VEB_cnt=VEB_cnt-1;
        $fclose(outfile);
      end
      if((VEB >= -1.98) &&  (VEB <= 1.5) && (VEB_retc!=0))
      begin
        outfile=$fopen(errFileName,"a");
        $strobe("qpvb          VEB     entering SOCA ( -1.980 V .. 1.500 V ) at %7.4r  %M", $abstime );
        $fwrite(outfile,"qpvb          VEB     entering SOCA ( -1.980 V .. 1.500 V ) at %7.4r  %M\n", $abstime );
        VEB_retc=0;
        VEB_cnt=VEB_cnt-1;
        $fclose(outfile);
      end
      if((VEB > 1.5) &&  (VEB_retc!=1))
      begin
        outfile=$fopen(errFileName,"a");
        $strobe("qpvb          VEB     leaving   OCA ( 1.500 V ..  ) at %7.4r  %M", $abstime );
        $fwrite(outfile,"qpvb          VEB     leaving   OCA ( 1.500 V ..  ) at %7.4r  %M\n", $abstime );
        VEB_retc=1;
        VEB_cnt=VEB_cnt-1;
        $fclose(outfile);
      end
   end
   else
   begin
      if(VEB_cnt==0)
      begin
        outfile=$fopen(errFileName,"a");
        $strobe("qpvb          VEB     error limit ( %d ) reached at %7.4r  %M", maxEv, $abstime );
        $fwrite(outfile,"qpvb          VEB     error limit ( %d ) reached at %7.4r  %M\n", maxEv, $abstime );
        VEB_cnt=VEB_cnt-1;
        $fclose(outfile);
      end
   end

//      VBC
   VBC = V_B_C;
   if((VBC_cnt>0) || ( maxEv_flg==0 ))   begin
      if( (VBC < -0.1) && (VBC_retc!=-1))
      begin
        outfile=$fopen(errFileName,"a");
        $strobe("qpvb          VBC     leaving   OCA (  .. -0.100 V ) at %7.4r  %M", $abstime );
        $fwrite(outfile,"qpvb          VBC     leaving   OCA (  .. -0.100 V ) at %7.4r  %M\n", $abstime );
        VBC_retc=-1;
        VBC_cnt=VBC_cnt-1;
        $fclose(outfile);
      end
      if((VBC >= -0.1) &&  (VBC <= 1.98) && (VBC_retc!=0))
      begin
        outfile=$fopen(errFileName,"a");
        $strobe("qpvb          VBC     entering SOCA ( -0.100 V .. 1.980 V ) at %7.4r  %M", $abstime );
        $fwrite(outfile,"qpvb          VBC     entering SOCA ( -0.100 V .. 1.980 V ) at %7.4r  %M\n", $abstime );
        VBC_retc=0;
        VBC_cnt=VBC_cnt-1;
        $fclose(outfile);
      end
      if((VBC > 1.98) &&  (VBC_retc!=1))
      begin
        outfile=$fopen(errFileName,"a");
        $strobe("qpvb          VBC     leaving   OCA ( 1.980 V ..  ) at %7.4r  %M", $abstime );
        $fwrite(outfile,"qpvb          VBC     leaving   OCA ( 1.980 V ..  ) at %7.4r  %M\n", $abstime );
        VBC_retc=1;
        VBC_cnt=VBC_cnt-1;
        $fclose(outfile);
      end
   end
   else
   begin
      if(VBC_cnt==0)
      begin
        outfile=$fopen(errFileName,"a");
        $strobe("qpvb          VBC     error limit ( %d ) reached at %7.4r  %M", maxEv, $abstime );
        $fwrite(outfile,"qpvb          VBC     error limit ( %d ) reached at %7.4r  %M\n", maxEv, $abstime );
        VBC_cnt=VBC_cnt-1;
        $fclose(outfile);
      end
   end

end // analog
endmodule // qpvb

// Verilog-A OC Watch for device qpvc Parameters  VCE VEB VBC
module qpvc_ahdl(C,B,E);
parameter tstep_occ=100n;
parameter errFileName="./occ.err";
parameter maxEv = 25;
parameter maxEv_flg = 0;
inout C,B,E;
electrical C,B,E;

integer outfile;
real V_B_C;
real V_E_B;
real V_C_E;
real VCE;
integer VCE_retc;
integer VCE_cnt;
real VEB;
integer VEB_retc;
integer VEB_cnt;
real VBC;
integer VBC_retc;
integer VBC_cnt;

analog begin
   $bound_step( tstep_occ );
   @(initial_step) begin
      VCE_retc=0;
      VCE_cnt = maxEv;
      VEB_retc=0;
      VEB_cnt = maxEv;
      VBC_retc=0;
      VBC_cnt = maxEv;
   end
   V_B_C = V(B,C);
   V_E_B = V(E,B);
   V_C_E = V(C,E);

//      VCE
   VCE = V_C_E;
   if((VCE_cnt>0) || ( maxEv_flg==0 ))   begin
      if( (VCE < -1.98) && (VCE_retc!=-1))
      begin
        outfile=$fopen(errFileName,"a");
        $strobe("qpvc          VCE     leaving   OCA (  .. -1.980 V ) at %7.4r  %M", $abstime );
        $fwrite(outfile,"qpvc          VCE     leaving   OCA (  .. -1.980 V ) at %7.4r  %M\n", $abstime );
        VCE_retc=-1;
        VCE_cnt=VCE_cnt-1;
        $fclose(outfile);
      end
      if((VCE >= -1.98) &&  (VCE <= 0.1) && (VCE_retc!=0))
      begin
        outfile=$fopen(errFileName,"a");
        $strobe("qpvc          VCE     entering SOCA ( -1.980 V .. 0.100 V ) at %7.4r  %M", $abstime );
        $fwrite(outfile,"qpvc          VCE     entering SOCA ( -1.980 V .. 0.100 V ) at %7.4r  %M\n", $abstime );
        VCE_retc=0;
        VCE_cnt=VCE_cnt-1;
        $fclose(outfile);
      end
      if((VCE > 0.1) &&  (VCE_retc!=1))
      begin
        outfile=$fopen(errFileName,"a");
        $strobe("qpvc          VCE     leaving   OCA ( 0.100 V ..  ) at %7.4r  %M", $abstime );
        $fwrite(outfile,"qpvc          VCE     leaving   OCA ( 0.100 V ..  ) at %7.4r  %M\n", $abstime );
        VCE_retc=1;
        VCE_cnt=VCE_cnt-1;
        $fclose(outfile);
      end
   end
   else
   begin
      if(VCE_cnt==0)
      begin
        outfile=$fopen(errFileName,"a");
        $strobe("qpvc          VCE     error limit ( %d ) reached at %7.4r  %M", maxEv, $abstime );
        $fwrite(outfile,"qpvc          VCE     error limit ( %d ) reached at %7.4r  %M\n", maxEv, $abstime );
        VCE_cnt=VCE_cnt-1;
        $fclose(outfile);
      end
   end

//      VEB
   VEB = V_E_B;
   if((VEB_cnt>0) || ( maxEv_flg==0 ))   begin
      if( (VEB < -1.98) && (VEB_retc!=-1))
      begin
        outfile=$fopen(errFileName,"a");
        $strobe("qpvc          VEB     leaving   OCA (  .. -1.980 V ) at %7.4r  %M", $abstime );
        $fwrite(outfile,"qpvc          VEB     leaving   OCA (  .. -1.980 V ) at %7.4r  %M\n", $abstime );
        VEB_retc=-1;
        VEB_cnt=VEB_cnt-1;
        $fclose(outfile);
      end
      if((VEB >= -1.98) &&  (VEB <= 1.5) && (VEB_retc!=0))
      begin
        outfile=$fopen(errFileName,"a");
        $strobe("qpvc          VEB     entering SOCA ( -1.980 V .. 1.500 V ) at %7.4r  %M", $abstime );
        $fwrite(outfile,"qpvc          VEB     entering SOCA ( -1.980 V .. 1.500 V ) at %7.4r  %M\n", $abstime );
        VEB_retc=0;
        VEB_cnt=VEB_cnt-1;
        $fclose(outfile);
      end
      if((VEB > 1.5) &&  (VEB_retc!=1))
      begin
        outfile=$fopen(errFileName,"a");
        $strobe("qpvc          VEB     leaving   OCA ( 1.500 V ..  ) at %7.4r  %M", $abstime );
        $fwrite(outfile,"qpvc          VEB     leaving   OCA ( 1.500 V ..  ) at %7.4r  %M\n", $abstime );
        VEB_retc=1;
        VEB_cnt=VEB_cnt-1;
        $fclose(outfile);
      end
   end
   else
   begin
      if(VEB_cnt==0)
      begin
        outfile=$fopen(errFileName,"a");
        $strobe("qpvc          VEB     error limit ( %d ) reached at %7.4r  %M", maxEv, $abstime );
        $fwrite(outfile,"qpvc          VEB     error limit ( %d ) reached at %7.4r  %M\n", maxEv, $abstime );
        VEB_cnt=VEB_cnt-1;
        $fclose(outfile);
      end
   end

//      VBC
   VBC = V_B_C;
   if((VBC_cnt>0) || ( maxEv_flg==0 ))   begin
      if( (VBC < -0.1) && (VBC_retc!=-1))
      begin
        outfile=$fopen(errFileName,"a");
        $strobe("qpvc          VBC     leaving   OCA (  .. -0.100 V ) at %7.4r  %M", $abstime );
        $fwrite(outfile,"qpvc          VBC     leaving   OCA (  .. -0.100 V ) at %7.4r  %M\n", $abstime );
        VBC_retc=-1;
        VBC_cnt=VBC_cnt-1;
        $fclose(outfile);
      end
      if((VBC >= -0.1) &&  (VBC <= 1.98) && (VBC_retc!=0))
      begin
        outfile=$fopen(errFileName,"a");
        $strobe("qpvc          VBC     entering SOCA ( -0.100 V .. 1.980 V ) at %7.4r  %M", $abstime );
        $fwrite(outfile,"qpvc          VBC     entering SOCA ( -0.100 V .. 1.980 V ) at %7.4r  %M\n", $abstime );
        VBC_retc=0;
        VBC_cnt=VBC_cnt-1;
        $fclose(outfile);
      end
      if((VBC > 1.98) &&  (VBC_retc!=1))
      begin
        outfile=$fopen(errFileName,"a");
        $strobe("qpvc          VBC     leaving   OCA ( 1.980 V ..  ) at %7.4r  %M", $abstime );
        $fwrite(outfile,"qpvc          VBC     leaving   OCA ( 1.980 V ..  ) at %7.4r  %M\n", $abstime );
        VBC_retc=1;
        VBC_cnt=VBC_cnt-1;
        $fclose(outfile);
      end
   end
   else
   begin
      if(VBC_cnt==0)
      begin
        outfile=$fopen(errFileName,"a");
        $strobe("qpvc          VBC     error limit ( %d ) reached at %7.4r  %M", maxEv, $abstime );
        $fwrite(outfile,"qpvc          VBC     error limit ( %d ) reached at %7.4r  %M\n", maxEv, $abstime );
        VBC_cnt=VBC_cnt-1;
        $fclose(outfile);
      end
   end

end // analog
endmodule // qpvc

// Verilog-A OC Watch for device qpve Parameters  VCE VEB VBC
module qpve_ahdl(C,B,E);
parameter tstep_occ=100n;
parameter errFileName="./occ.err";
parameter maxEv = 25;
parameter maxEv_flg = 0;
inout C,B,E;
electrical C,B,E;

integer outfile;
real V_B_C;
real V_E_B;
real V_C_E;
real VCE;
integer VCE_retc;
integer VCE_cnt;
real VEB;
integer VEB_retc;
integer VEB_cnt;
real VBC;
integer VBC_retc;
integer VBC_cnt;

analog begin
   $bound_step( tstep_occ );
   @(initial_step) begin
      VCE_retc=0;
      VCE_cnt = maxEv;
      VEB_retc=0;
      VEB_cnt = maxEv;
      VBC_retc=0;
      VBC_cnt = maxEv;
   end
   V_B_C = V(B,C);
   V_E_B = V(E,B);
   V_C_E = V(C,E);

//      VCE
   VCE = V_C_E;
   if((VCE_cnt>0) || ( maxEv_flg==0 ))   begin
      if( (VCE < -1.98) && (VCE_retc!=-1))
      begin
        outfile=$fopen(errFileName,"a");
        $strobe("qpve          VCE     leaving   OCA (  .. -1.980 V ) at %7.4r  %M", $abstime );
        $fwrite(outfile,"qpve          VCE     leaving   OCA (  .. -1.980 V ) at %7.4r  %M\n", $abstime );
        VCE_retc=-1;
        VCE_cnt=VCE_cnt-1;
        $fclose(outfile);
      end
      if((VCE >= -1.98) &&  (VCE <= 0.1) && (VCE_retc!=0))
      begin
        outfile=$fopen(errFileName,"a");
        $strobe("qpve          VCE     entering SOCA ( -1.980 V .. 0.100 V ) at %7.4r  %M", $abstime );
        $fwrite(outfile,"qpve          VCE     entering SOCA ( -1.980 V .. 0.100 V ) at %7.4r  %M\n", $abstime );
        VCE_retc=0;
        VCE_cnt=VCE_cnt-1;
        $fclose(outfile);
      end
      if((VCE > 0.1) &&  (VCE_retc!=1))
      begin
        outfile=$fopen(errFileName,"a");
        $strobe("qpve          VCE     leaving   OCA ( 0.100 V ..  ) at %7.4r  %M", $abstime );
        $fwrite(outfile,"qpve          VCE     leaving   OCA ( 0.100 V ..  ) at %7.4r  %M\n", $abstime );
        VCE_retc=1;
        VCE_cnt=VCE_cnt-1;
        $fclose(outfile);
      end
   end
   else
   begin
      if(VCE_cnt==0)
      begin
        outfile=$fopen(errFileName,"a");
        $strobe("qpve          VCE     error limit ( %d ) reached at %7.4r  %M", maxEv, $abstime );
        $fwrite(outfile,"qpve          VCE     error limit ( %d ) reached at %7.4r  %M\n", maxEv, $abstime );
        VCE_cnt=VCE_cnt-1;
        $fclose(outfile);
      end
   end

//      VEB
   VEB = V_E_B;
   if((VEB_cnt>0) || ( maxEv_flg==0 ))   begin
      if( (VEB < -1.98) && (VEB_retc!=-1))
      begin
        outfile=$fopen(errFileName,"a");
        $strobe("qpve          VEB     leaving   OCA (  .. -1.980 V ) at %7.4r  %M", $abstime );
        $fwrite(outfile,"qpve          VEB     leaving   OCA (  .. -1.980 V ) at %7.4r  %M\n", $abstime );
        VEB_retc=-1;
        VEB_cnt=VEB_cnt-1;
        $fclose(outfile);
      end
      if((VEB >= -1.98) &&  (VEB <= 1.5) && (VEB_retc!=0))
      begin
        outfile=$fopen(errFileName,"a");
        $strobe("qpve          VEB     entering SOCA ( -1.980 V .. 1.500 V ) at %7.4r  %M", $abstime );
        $fwrite(outfile,"qpve          VEB     entering SOCA ( -1.980 V .. 1.500 V ) at %7.4r  %M\n", $abstime );
        VEB_retc=0;
        VEB_cnt=VEB_cnt-1;
        $fclose(outfile);
      end
      if((VEB > 1.5) &&  (VEB_retc!=1))
      begin
        outfile=$fopen(errFileName,"a");
        $strobe("qpve          VEB     leaving   OCA ( 1.500 V ..  ) at %7.4r  %M", $abstime );
        $fwrite(outfile,"qpve          VEB     leaving   OCA ( 1.500 V ..  ) at %7.4r  %M\n", $abstime );
        VEB_retc=1;
        VEB_cnt=VEB_cnt-1;
        $fclose(outfile);
      end
   end
   else
   begin
      if(VEB_cnt==0)
      begin
        outfile=$fopen(errFileName,"a");
        $strobe("qpve          VEB     error limit ( %d ) reached at %7.4r  %M", maxEv, $abstime );
        $fwrite(outfile,"qpve          VEB     error limit ( %d ) reached at %7.4r  %M\n", maxEv, $abstime );
        VEB_cnt=VEB_cnt-1;
        $fclose(outfile);
      end
   end

//      VBC
   VBC = V_B_C;
   if((VBC_cnt>0) || ( maxEv_flg==0 ))   begin
      if( (VBC < -0.1) && (VBC_retc!=-1))
      begin
        outfile=$fopen(errFileName,"a");
        $strobe("qpve          VBC     leaving   OCA (  .. -0.100 V ) at %7.4r  %M", $abstime );
        $fwrite(outfile,"qpve          VBC     leaving   OCA (  .. -0.100 V ) at %7.4r  %M\n", $abstime );
        VBC_retc=-1;
        VBC_cnt=VBC_cnt-1;
        $fclose(outfile);
      end
      if((VBC >= -0.1) &&  (VBC <= 1.98) && (VBC_retc!=0))
      begin
        outfile=$fopen(errFileName,"a");
        $strobe("qpve          VBC     entering SOCA ( -0.100 V .. 1.980 V ) at %7.4r  %M", $abstime );
        $fwrite(outfile,"qpve          VBC     entering SOCA ( -0.100 V .. 1.980 V ) at %7.4r  %M\n", $abstime );
        VBC_retc=0;
        VBC_cnt=VBC_cnt-1;
        $fclose(outfile);
      end
      if((VBC > 1.98) &&  (VBC_retc!=1))
      begin
        outfile=$fopen(errFileName,"a");
        $strobe("qpve          VBC     leaving   OCA ( 1.980 V ..  ) at %7.4r  %M", $abstime );
        $fwrite(outfile,"qpve          VBC     leaving   OCA ( 1.980 V ..  ) at %7.4r  %M\n", $abstime );
        VBC_retc=1;
        VBC_cnt=VBC_cnt-1;
        $fclose(outfile);
      end
   end
   else
   begin
      if(VBC_cnt==0)
      begin
        outfile=$fopen(errFileName,"a");
        $strobe("qpve          VBC     error limit ( %d ) reached at %7.4r  %M", maxEv, $abstime );
        $fwrite(outfile,"qpve          VBC     error limit ( %d ) reached at %7.4r  %M\n", maxEv, $abstime );
        VBC_cnt=VBC_cnt-1;
        $fclose(outfile);
      end
   end

end // analog
endmodule // qpve

// Verilog-A OC Watch for device qpvf Parameters  VCE VEB VBC
module qpvf_ahdl(C,B,E);
parameter tstep_occ=100n;
parameter errFileName="./occ.err";
parameter maxEv = 25;
parameter maxEv_flg = 0;
inout C,B,E;
electrical C,B,E;

integer outfile;
real V_B_C;
real V_E_B;
real V_C_E;
real VCE;
integer VCE_retc;
integer VCE_cnt;
real VEB;
integer VEB_retc;
integer VEB_cnt;
real VBC;
integer VBC_retc;
integer VBC_cnt;

analog begin
   $bound_step( tstep_occ );
   @(initial_step) begin
      VCE_retc=0;
      VCE_cnt = maxEv;
      VEB_retc=0;
      VEB_cnt = maxEv;
      VBC_retc=0;
      VBC_cnt = maxEv;
   end
   V_B_C = V(B,C);
   V_E_B = V(E,B);
   V_C_E = V(C,E);

//      VCE
   VCE = V_C_E;
   if((VCE_cnt>0) || ( maxEv_flg==0 ))   begin
      if( (VCE < -1.98) && (VCE_retc!=-1))
      begin
        outfile=$fopen(errFileName,"a");
        $strobe("qpvf          VCE     leaving   OCA (  .. -1.980 V ) at %7.4r  %M", $abstime );
        $fwrite(outfile,"qpvf          VCE     leaving   OCA (  .. -1.980 V ) at %7.4r  %M\n", $abstime );
        VCE_retc=-1;
        VCE_cnt=VCE_cnt-1;
        $fclose(outfile);
      end
      if((VCE >= -1.98) &&  (VCE <= 0.1) && (VCE_retc!=0))
      begin
        outfile=$fopen(errFileName,"a");
        $strobe("qpvf          VCE     entering SOCA ( -1.980 V .. 0.100 V ) at %7.4r  %M", $abstime );
        $fwrite(outfile,"qpvf          VCE     entering SOCA ( -1.980 V .. 0.100 V ) at %7.4r  %M\n", $abstime );
        VCE_retc=0;
        VCE_cnt=VCE_cnt-1;
        $fclose(outfile);
      end
      if((VCE > 0.1) &&  (VCE_retc!=1))
      begin
        outfile=$fopen(errFileName,"a");
        $strobe("qpvf          VCE     leaving   OCA ( 0.100 V ..  ) at %7.4r  %M", $abstime );
        $fwrite(outfile,"qpvf          VCE     leaving   OCA ( 0.100 V ..  ) at %7.4r  %M\n", $abstime );
        VCE_retc=1;
        VCE_cnt=VCE_cnt-1;
        $fclose(outfile);
      end
   end
   else
   begin
      if(VCE_cnt==0)
      begin
        outfile=$fopen(errFileName,"a");
        $strobe("qpvf          VCE     error limit ( %d ) reached at %7.4r  %M", maxEv, $abstime );
        $fwrite(outfile,"qpvf          VCE     error limit ( %d ) reached at %7.4r  %M\n", maxEv, $abstime );
        VCE_cnt=VCE_cnt-1;
        $fclose(outfile);
      end
   end

//      VEB
   VEB = V_E_B;
   if((VEB_cnt>0) || ( maxEv_flg==0 ))   begin
      if( (VEB < -1.98) && (VEB_retc!=-1))
      begin
        outfile=$fopen(errFileName,"a");
        $strobe("qpvf          VEB     leaving   OCA (  .. -1.980 V ) at %7.4r  %M", $abstime );
        $fwrite(outfile,"qpvf          VEB     leaving   OCA (  .. -1.980 V ) at %7.4r  %M\n", $abstime );
        VEB_retc=-1;
        VEB_cnt=VEB_cnt-1;
        $fclose(outfile);
      end
      if((VEB >= -1.98) &&  (VEB <= 1.5) && (VEB_retc!=0))
      begin
        outfile=$fopen(errFileName,"a");
        $strobe("qpvf          VEB     entering SOCA ( -1.980 V .. 1.500 V ) at %7.4r  %M", $abstime );
        $fwrite(outfile,"qpvf          VEB     entering SOCA ( -1.980 V .. 1.500 V ) at %7.4r  %M\n", $abstime );
        VEB_retc=0;
        VEB_cnt=VEB_cnt-1;
        $fclose(outfile);
      end
      if((VEB > 1.5) &&  (VEB_retc!=1))
      begin
        outfile=$fopen(errFileName,"a");
        $strobe("qpvf          VEB     leaving   OCA ( 1.500 V ..  ) at %7.4r  %M", $abstime );
        $fwrite(outfile,"qpvf          VEB     leaving   OCA ( 1.500 V ..  ) at %7.4r  %M\n", $abstime );
        VEB_retc=1;
        VEB_cnt=VEB_cnt-1;
        $fclose(outfile);
      end
   end
   else
   begin
      if(VEB_cnt==0)
      begin
        outfile=$fopen(errFileName,"a");
        $strobe("qpvf          VEB     error limit ( %d ) reached at %7.4r  %M", maxEv, $abstime );
        $fwrite(outfile,"qpvf          VEB     error limit ( %d ) reached at %7.4r  %M\n", maxEv, $abstime );
        VEB_cnt=VEB_cnt-1;
        $fclose(outfile);
      end
   end

//      VBC
   VBC = V_B_C;
   if((VBC_cnt>0) || ( maxEv_flg==0 ))   begin
      if( (VBC < -0.1) && (VBC_retc!=-1))
      begin
        outfile=$fopen(errFileName,"a");
        $strobe("qpvf          VBC     leaving   OCA (  .. -0.100 V ) at %7.4r  %M", $abstime );
        $fwrite(outfile,"qpvf          VBC     leaving   OCA (  .. -0.100 V ) at %7.4r  %M\n", $abstime );
        VBC_retc=-1;
        VBC_cnt=VBC_cnt-1;
        $fclose(outfile);
      end
      if((VBC >= -0.1) &&  (VBC <= 1.98) && (VBC_retc!=0))
      begin
        outfile=$fopen(errFileName,"a");
        $strobe("qpvf          VBC     entering SOCA ( -0.100 V .. 1.980 V ) at %7.4r  %M", $abstime );
        $fwrite(outfile,"qpvf          VBC     entering SOCA ( -0.100 V .. 1.980 V ) at %7.4r  %M\n", $abstime );
        VBC_retc=0;
        VBC_cnt=VBC_cnt-1;
        $fclose(outfile);
      end
      if((VBC > 1.98) &&  (VBC_retc!=1))
      begin
        outfile=$fopen(errFileName,"a");
        $strobe("qpvf          VBC     leaving   OCA ( 1.980 V ..  ) at %7.4r  %M", $abstime );
        $fwrite(outfile,"qpvf          VBC     leaving   OCA ( 1.980 V ..  ) at %7.4r  %M\n", $abstime );
        VBC_retc=1;
        VBC_cnt=VBC_cnt-1;
        $fclose(outfile);
      end
   end
   else
   begin
      if(VBC_cnt==0)
      begin
        outfile=$fopen(errFileName,"a");
        $strobe("qpvf          VBC     error limit ( %d ) reached at %7.4r  %M", maxEv, $abstime );
        $fwrite(outfile,"qpvf          VBC     error limit ( %d ) reached at %7.4r  %M\n", maxEv, $abstime );
        VBC_cnt=VBC_cnt-1;
        $fclose(outfile);
      end
   end

end // analog
endmodule // qpvf

// Verilog-A OC Watch for device qpvg Parameters  VCE VEB VBC
module qpvg_ahdl(C,B,E);
parameter tstep_occ=100n;
parameter errFileName="./occ.err";
parameter maxEv = 25;
parameter maxEv_flg = 0;
inout C,B,E;
electrical C,B,E;

integer outfile;
real V_B_C;
real V_E_B;
real V_C_E;
real VCE;
integer VCE_retc;
integer VCE_cnt;
real VEB;
integer VEB_retc;
integer VEB_cnt;
real VBC;
integer VBC_retc;
integer VBC_cnt;

analog begin
   $bound_step( tstep_occ );
   @(initial_step) begin
      VCE_retc=0;
      VCE_cnt = maxEv;
      VEB_retc=0;
      VEB_cnt = maxEv;
      VBC_retc=0;
      VBC_cnt = maxEv;
   end
   V_B_C = V(B,C);
   V_E_B = V(E,B);
   V_C_E = V(C,E);

//      VCE
   VCE = V_C_E;
   if((VCE_cnt>0) || ( maxEv_flg==0 ))   begin
      if( (VCE < -1.98) && (VCE_retc!=-1))
      begin
        outfile=$fopen(errFileName,"a");
        $strobe("qpvg          VCE     leaving   OCA (  .. -1.980 V ) at %7.4r  %M", $abstime );
        $fwrite(outfile,"qpvg          VCE     leaving   OCA (  .. -1.980 V ) at %7.4r  %M\n", $abstime );
        VCE_retc=-1;
        VCE_cnt=VCE_cnt-1;
        $fclose(outfile);
      end
      if((VCE >= -1.98) &&  (VCE <= 0.1) && (VCE_retc!=0))
      begin
        outfile=$fopen(errFileName,"a");
        $strobe("qpvg          VCE     entering SOCA ( -1.980 V .. 0.100 V ) at %7.4r  %M", $abstime );
        $fwrite(outfile,"qpvg          VCE     entering SOCA ( -1.980 V .. 0.100 V ) at %7.4r  %M\n", $abstime );
        VCE_retc=0;
        VCE_cnt=VCE_cnt-1;
        $fclose(outfile);
      end
      if((VCE > 0.1) &&  (VCE_retc!=1))
      begin
        outfile=$fopen(errFileName,"a");
        $strobe("qpvg          VCE     leaving   OCA ( 0.100 V ..  ) at %7.4r  %M", $abstime );
        $fwrite(outfile,"qpvg          VCE     leaving   OCA ( 0.100 V ..  ) at %7.4r  %M\n", $abstime );
        VCE_retc=1;
        VCE_cnt=VCE_cnt-1;
        $fclose(outfile);
      end
   end
   else
   begin
      if(VCE_cnt==0)
      begin
        outfile=$fopen(errFileName,"a");
        $strobe("qpvg          VCE     error limit ( %d ) reached at %7.4r  %M", maxEv, $abstime );
        $fwrite(outfile,"qpvg          VCE     error limit ( %d ) reached at %7.4r  %M\n", maxEv, $abstime );
        VCE_cnt=VCE_cnt-1;
        $fclose(outfile);
      end
   end

//      VEB
   VEB = V_E_B;
   if((VEB_cnt>0) || ( maxEv_flg==0 ))   begin
      if( (VEB < -1.98) && (VEB_retc!=-1))
      begin
        outfile=$fopen(errFileName,"a");
        $strobe("qpvg          VEB     leaving   OCA (  .. -1.980 V ) at %7.4r  %M", $abstime );
        $fwrite(outfile,"qpvg          VEB     leaving   OCA (  .. -1.980 V ) at %7.4r  %M\n", $abstime );
        VEB_retc=-1;
        VEB_cnt=VEB_cnt-1;
        $fclose(outfile);
      end
      if((VEB >= -1.98) &&  (VEB <= 1.5) && (VEB_retc!=0))
      begin
        outfile=$fopen(errFileName,"a");
        $strobe("qpvg          VEB     entering SOCA ( -1.980 V .. 1.500 V ) at %7.4r  %M", $abstime );
        $fwrite(outfile,"qpvg          VEB     entering SOCA ( -1.980 V .. 1.500 V ) at %7.4r  %M\n", $abstime );
        VEB_retc=0;
        VEB_cnt=VEB_cnt-1;
        $fclose(outfile);
      end
      if((VEB > 1.5) &&  (VEB_retc!=1))
      begin
        outfile=$fopen(errFileName,"a");
        $strobe("qpvg          VEB     leaving   OCA ( 1.500 V ..  ) at %7.4r  %M", $abstime );
        $fwrite(outfile,"qpvg          VEB     leaving   OCA ( 1.500 V ..  ) at %7.4r  %M\n", $abstime );
        VEB_retc=1;
        VEB_cnt=VEB_cnt-1;
        $fclose(outfile);
      end
   end
   else
   begin
      if(VEB_cnt==0)
      begin
        outfile=$fopen(errFileName,"a");
        $strobe("qpvg          VEB     error limit ( %d ) reached at %7.4r  %M", maxEv, $abstime );
        $fwrite(outfile,"qpvg          VEB     error limit ( %d ) reached at %7.4r  %M\n", maxEv, $abstime );
        VEB_cnt=VEB_cnt-1;
        $fclose(outfile);
      end
   end

//      VBC
   VBC = V_B_C;
   if((VBC_cnt>0) || ( maxEv_flg==0 ))   begin
      if( (VBC < -0.1) && (VBC_retc!=-1))
      begin
        outfile=$fopen(errFileName,"a");
        $strobe("qpvg          VBC     leaving   OCA (  .. -0.100 V ) at %7.4r  %M", $abstime );
        $fwrite(outfile,"qpvg          VBC     leaving   OCA (  .. -0.100 V ) at %7.4r  %M\n", $abstime );
        VBC_retc=-1;
        VBC_cnt=VBC_cnt-1;
        $fclose(outfile);
      end
      if((VBC >= -0.1) &&  (VBC <= 1.98) && (VBC_retc!=0))
      begin
        outfile=$fopen(errFileName,"a");
        $strobe("qpvg          VBC     entering SOCA ( -0.100 V .. 1.980 V ) at %7.4r  %M", $abstime );
        $fwrite(outfile,"qpvg          VBC     entering SOCA ( -0.100 V .. 1.980 V ) at %7.4r  %M\n", $abstime );
        VBC_retc=0;
        VBC_cnt=VBC_cnt-1;
        $fclose(outfile);
      end
      if((VBC > 1.98) &&  (VBC_retc!=1))
      begin
        outfile=$fopen(errFileName,"a");
        $strobe("qpvg          VBC     leaving   OCA ( 1.980 V ..  ) at %7.4r  %M", $abstime );
        $fwrite(outfile,"qpvg          VBC     leaving   OCA ( 1.980 V ..  ) at %7.4r  %M\n", $abstime );
        VBC_retc=1;
        VBC_cnt=VBC_cnt-1;
        $fclose(outfile);
      end
   end
   else
   begin
      if(VBC_cnt==0)
      begin
        outfile=$fopen(errFileName,"a");
        $strobe("qpvg          VBC     error limit ( %d ) reached at %7.4r  %M", maxEv, $abstime );
        $fwrite(outfile,"qpvg          VBC     error limit ( %d ) reached at %7.4r  %M\n", maxEv, $abstime );
        VBC_cnt=VBC_cnt-1;
        $fclose(outfile);
      end
   end

end // analog
endmodule // qpvg

// Verilog-A OC Watch for device qpva5 Parameters  VCE VEB VBC
module qpva5_ahdl(C,B,E);
parameter tstep_occ=100n;
parameter errFileName="./occ.err";
parameter maxEv = 25;
parameter maxEv_flg = 0;
inout C,B,E;
electrical C,B,E;

integer outfile;
real V_B_C;
real V_E_B;
real V_C_E;
real VCE;
integer VCE_retc;
integer VCE_cnt;
real VEB;
integer VEB_retc;
integer VEB_cnt;
real VBC;
integer VBC_retc;
integer VBC_cnt;

analog begin
   $bound_step( tstep_occ );
   @(initial_step) begin
      VCE_retc=0;
      VCE_cnt = maxEv;
      VEB_retc=0;
      VEB_cnt = maxEv;
      VBC_retc=0;
      VBC_cnt = maxEv;
   end
   V_B_C = V(B,C);
   V_E_B = V(E,B);
   V_C_E = V(C,E);

//      VCE
   VCE = V_C_E;
   if((VCE_cnt>0) || ( maxEv_flg==0 ))   begin
      if( (VCE < -5.5) && (VCE_retc!=-1))
      begin
        outfile=$fopen(errFileName,"a");
        $strobe("qpva5         VCE     leaving   OCA (  .. -5.500 V ) at %7.4r  %M", $abstime );
        $fwrite(outfile,"qpva5         VCE     leaving   OCA (  .. -5.500 V ) at %7.4r  %M\n", $abstime );
        VCE_retc=-1;
        VCE_cnt=VCE_cnt-1;
        $fclose(outfile);
      end
      if((VCE >= -5.5) &&  (VCE <= 0.1) && (VCE_retc!=0))
      begin
        outfile=$fopen(errFileName,"a");
        $strobe("qpva5         VCE     entering SOCA ( -5.500 V .. 0.100 V ) at %7.4r  %M", $abstime );
        $fwrite(outfile,"qpva5         VCE     entering SOCA ( -5.500 V .. 0.100 V ) at %7.4r  %M\n", $abstime );
        VCE_retc=0;
        VCE_cnt=VCE_cnt-1;
        $fclose(outfile);
      end
      if((VCE > 0.1) &&  (VCE_retc!=1))
      begin
        outfile=$fopen(errFileName,"a");
        $strobe("qpva5         VCE     leaving   OCA ( 0.100 V ..  ) at %7.4r  %M", $abstime );
        $fwrite(outfile,"qpva5         VCE     leaving   OCA ( 0.100 V ..  ) at %7.4r  %M\n", $abstime );
        VCE_retc=1;
        VCE_cnt=VCE_cnt-1;
        $fclose(outfile);
      end
   end
   else
   begin
      if(VCE_cnt==0)
      begin
        outfile=$fopen(errFileName,"a");
        $strobe("qpva5         VCE     error limit ( %d ) reached at %7.4r  %M", maxEv, $abstime );
        $fwrite(outfile,"qpva5         VCE     error limit ( %d ) reached at %7.4r  %M\n", maxEv, $abstime );
        VCE_cnt=VCE_cnt-1;
        $fclose(outfile);
      end
   end

//      VEB
   VEB = V_E_B;
   if((VEB_cnt>0) || ( maxEv_flg==0 ))   begin
      if( (VEB < -5.5) && (VEB_retc!=-1))
      begin
        outfile=$fopen(errFileName,"a");
        $strobe("qpva5         VEB     leaving   OCA (  .. -5.500 V ) at %7.4r  %M", $abstime );
        $fwrite(outfile,"qpva5         VEB     leaving   OCA (  .. -5.500 V ) at %7.4r  %M\n", $abstime );
        VEB_retc=-1;
        VEB_cnt=VEB_cnt-1;
        $fclose(outfile);
      end
      if((VEB >= -5.5) &&  (VEB <= 1.5) && (VEB_retc!=0))
      begin
        outfile=$fopen(errFileName,"a");
        $strobe("qpva5         VEB     entering SOCA ( -5.500 V .. 1.500 V ) at %7.4r  %M", $abstime );
        $fwrite(outfile,"qpva5         VEB     entering SOCA ( -5.500 V .. 1.500 V ) at %7.4r  %M\n", $abstime );
        VEB_retc=0;
        VEB_cnt=VEB_cnt-1;
        $fclose(outfile);
      end
      if((VEB > 1.5) &&  (VEB_retc!=1))
      begin
        outfile=$fopen(errFileName,"a");
        $strobe("qpva5         VEB     leaving   OCA ( 1.500 V ..  ) at %7.4r  %M", $abstime );
        $fwrite(outfile,"qpva5         VEB     leaving   OCA ( 1.500 V ..  ) at %7.4r  %M\n", $abstime );
        VEB_retc=1;
        VEB_cnt=VEB_cnt-1;
        $fclose(outfile);
      end
   end
   else
   begin
      if(VEB_cnt==0)
      begin
        outfile=$fopen(errFileName,"a");
        $strobe("qpva5         VEB     error limit ( %d ) reached at %7.4r  %M", maxEv, $abstime );
        $fwrite(outfile,"qpva5         VEB     error limit ( %d ) reached at %7.4r  %M\n", maxEv, $abstime );
        VEB_cnt=VEB_cnt-1;
        $fclose(outfile);
      end
   end

//      VBC
   VBC = V_B_C;
   if((VBC_cnt>0) || ( maxEv_flg==0 ))   begin
      if( (VBC < -0.1) && (VBC_retc!=-1))
      begin
        outfile=$fopen(errFileName,"a");
        $strobe("qpva5         VBC     leaving   OCA (  .. -0.100 V ) at %7.4r  %M", $abstime );
        $fwrite(outfile,"qpva5         VBC     leaving   OCA (  .. -0.100 V ) at %7.4r  %M\n", $abstime );
        VBC_retc=-1;
        VBC_cnt=VBC_cnt-1;
        $fclose(outfile);
      end
      if((VBC >= -0.1) &&  (VBC <= 5.5) && (VBC_retc!=0))
      begin
        outfile=$fopen(errFileName,"a");
        $strobe("qpva5         VBC     entering SOCA ( -0.100 V .. 5.500 V ) at %7.4r  %M", $abstime );
        $fwrite(outfile,"qpva5         VBC     entering SOCA ( -0.100 V .. 5.500 V ) at %7.4r  %M\n", $abstime );
        VBC_retc=0;
        VBC_cnt=VBC_cnt-1;
        $fclose(outfile);
      end
      if((VBC > 5.5) &&  (VBC_retc!=1))
      begin
        outfile=$fopen(errFileName,"a");
        $strobe("qpva5         VBC     leaving   OCA ( 5.500 V ..  ) at %7.4r  %M", $abstime );
        $fwrite(outfile,"qpva5         VBC     leaving   OCA ( 5.500 V ..  ) at %7.4r  %M\n", $abstime );
        VBC_retc=1;
        VBC_cnt=VBC_cnt-1;
        $fclose(outfile);
      end
   end
   else
   begin
      if(VBC_cnt==0)
      begin
        outfile=$fopen(errFileName,"a");
        $strobe("qpva5         VBC     error limit ( %d ) reached at %7.4r  %M", maxEv, $abstime );
        $fwrite(outfile,"qpva5         VBC     error limit ( %d ) reached at %7.4r  %M\n", maxEv, $abstime );
        VBC_cnt=VBC_cnt-1;
        $fclose(outfile);
      end
   end

end // analog
endmodule // qpva5

// Verilog-A OC Watch for device qpvb5 Parameters  VCE VEB VBC
module qpvb5_ahdl(C,B,E);
parameter tstep_occ=100n;
parameter errFileName="./occ.err";
parameter maxEv = 25;
parameter maxEv_flg = 0;
inout C,B,E;
electrical C,B,E;

integer outfile;
real V_B_C;
real V_E_B;
real V_C_E;
real VCE;
integer VCE_retc;
integer VCE_cnt;
real VEB;
integer VEB_retc;
integer VEB_cnt;
real VBC;
integer VBC_retc;
integer VBC_cnt;

analog begin
   $bound_step( tstep_occ );
   @(initial_step) begin
      VCE_retc=0;
      VCE_cnt = maxEv;
      VEB_retc=0;
      VEB_cnt = maxEv;
      VBC_retc=0;
      VBC_cnt = maxEv;
   end
   V_B_C = V(B,C);
   V_E_B = V(E,B);
   V_C_E = V(C,E);

//      VCE
   VCE = V_C_E;
   if((VCE_cnt>0) || ( maxEv_flg==0 ))   begin
      if( (VCE < -5.5) && (VCE_retc!=-1))
      begin
        outfile=$fopen(errFileName,"a");
        $strobe("qpvb5         VCE     leaving   OCA (  .. -5.500 V ) at %7.4r  %M", $abstime );
        $fwrite(outfile,"qpvb5         VCE     leaving   OCA (  .. -5.500 V ) at %7.4r  %M\n", $abstime );
        VCE_retc=-1;
        VCE_cnt=VCE_cnt-1;
        $fclose(outfile);
      end
      if((VCE >= -5.5) &&  (VCE <= 0.1) && (VCE_retc!=0))
      begin
        outfile=$fopen(errFileName,"a");
        $strobe("qpvb5         VCE     entering SOCA ( -5.500 V .. 0.100 V ) at %7.4r  %M", $abstime );
        $fwrite(outfile,"qpvb5         VCE     entering SOCA ( -5.500 V .. 0.100 V ) at %7.4r  %M\n", $abstime );
        VCE_retc=0;
        VCE_cnt=VCE_cnt-1;
        $fclose(outfile);
      end
      if((VCE > 0.1) &&  (VCE_retc!=1))
      begin
        outfile=$fopen(errFileName,"a");
        $strobe("qpvb5         VCE     leaving   OCA ( 0.100 V ..  ) at %7.4r  %M", $abstime );
        $fwrite(outfile,"qpvb5         VCE     leaving   OCA ( 0.100 V ..  ) at %7.4r  %M\n", $abstime );
        VCE_retc=1;
        VCE_cnt=VCE_cnt-1;
        $fclose(outfile);
      end
   end
   else
   begin
      if(VCE_cnt==0)
      begin
        outfile=$fopen(errFileName,"a");
        $strobe("qpvb5         VCE     error limit ( %d ) reached at %7.4r  %M", maxEv, $abstime );
        $fwrite(outfile,"qpvb5         VCE     error limit ( %d ) reached at %7.4r  %M\n", maxEv, $abstime );
        VCE_cnt=VCE_cnt-1;
        $fclose(outfile);
      end
   end

//      VEB
   VEB = V_E_B;
   if((VEB_cnt>0) || ( maxEv_flg==0 ))   begin
      if( (VEB < -5.5) && (VEB_retc!=-1))
      begin
        outfile=$fopen(errFileName,"a");
        $strobe("qpvb5         VEB     leaving   OCA (  .. -5.500 V ) at %7.4r  %M", $abstime );
        $fwrite(outfile,"qpvb5         VEB     leaving   OCA (  .. -5.500 V ) at %7.4r  %M\n", $abstime );
        VEB_retc=-1;
        VEB_cnt=VEB_cnt-1;
        $fclose(outfile);
      end
      if((VEB >= -5.5) &&  (VEB <= 1.5) && (VEB_retc!=0))
      begin
        outfile=$fopen(errFileName,"a");
        $strobe("qpvb5         VEB     entering SOCA ( -5.500 V .. 1.500 V ) at %7.4r  %M", $abstime );
        $fwrite(outfile,"qpvb5         VEB     entering SOCA ( -5.500 V .. 1.500 V ) at %7.4r  %M\n", $abstime );
        VEB_retc=0;
        VEB_cnt=VEB_cnt-1;
        $fclose(outfile);
      end
      if((VEB > 1.5) &&  (VEB_retc!=1))
      begin
        outfile=$fopen(errFileName,"a");
        $strobe("qpvb5         VEB     leaving   OCA ( 1.500 V ..  ) at %7.4r  %M", $abstime );
        $fwrite(outfile,"qpvb5         VEB     leaving   OCA ( 1.500 V ..  ) at %7.4r  %M\n", $abstime );
        VEB_retc=1;
        VEB_cnt=VEB_cnt-1;
        $fclose(outfile);
      end
   end
   else
   begin
      if(VEB_cnt==0)
      begin
        outfile=$fopen(errFileName,"a");
        $strobe("qpvb5         VEB     error limit ( %d ) reached at %7.4r  %M", maxEv, $abstime );
        $fwrite(outfile,"qpvb5         VEB     error limit ( %d ) reached at %7.4r  %M\n", maxEv, $abstime );
        VEB_cnt=VEB_cnt-1;
        $fclose(outfile);
      end
   end

//      VBC
   VBC = V_B_C;
   if((VBC_cnt>0) || ( maxEv_flg==0 ))   begin
      if( (VBC < -0.1) && (VBC_retc!=-1))
      begin
        outfile=$fopen(errFileName,"a");
        $strobe("qpvb5         VBC     leaving   OCA (  .. -0.100 V ) at %7.4r  %M", $abstime );
        $fwrite(outfile,"qpvb5         VBC     leaving   OCA (  .. -0.100 V ) at %7.4r  %M\n", $abstime );
        VBC_retc=-1;
        VBC_cnt=VBC_cnt-1;
        $fclose(outfile);
      end
      if((VBC >= -0.1) &&  (VBC <= 5.5) && (VBC_retc!=0))
      begin
        outfile=$fopen(errFileName,"a");
        $strobe("qpvb5         VBC     entering SOCA ( -0.100 V .. 5.500 V ) at %7.4r  %M", $abstime );
        $fwrite(outfile,"qpvb5         VBC     entering SOCA ( -0.100 V .. 5.500 V ) at %7.4r  %M\n", $abstime );
        VBC_retc=0;
        VBC_cnt=VBC_cnt-1;
        $fclose(outfile);
      end
      if((VBC > 5.5) &&  (VBC_retc!=1))
      begin
        outfile=$fopen(errFileName,"a");
        $strobe("qpvb5         VBC     leaving   OCA ( 5.500 V ..  ) at %7.4r  %M", $abstime );
        $fwrite(outfile,"qpvb5         VBC     leaving   OCA ( 5.500 V ..  ) at %7.4r  %M\n", $abstime );
        VBC_retc=1;
        VBC_cnt=VBC_cnt-1;
        $fclose(outfile);
      end
   end
   else
   begin
      if(VBC_cnt==0)
      begin
        outfile=$fopen(errFileName,"a");
        $strobe("qpvb5         VBC     error limit ( %d ) reached at %7.4r  %M", maxEv, $abstime );
        $fwrite(outfile,"qpvb5         VBC     error limit ( %d ) reached at %7.4r  %M\n", maxEv, $abstime );
        VBC_cnt=VBC_cnt-1;
        $fclose(outfile);
      end
   end

end // analog
endmodule // qpvb5

// Verilog-A OC Watch for device qpvc5 Parameters  VCE VEB VBC
module qpvc5_ahdl(C,B,E);
parameter tstep_occ=100n;
parameter errFileName="./occ.err";
parameter maxEv = 25;
parameter maxEv_flg = 0;
inout C,B,E;
electrical C,B,E;

integer outfile;
real V_B_C;
real V_E_B;
real V_C_E;
real VCE;
integer VCE_retc;
integer VCE_cnt;
real VEB;
integer VEB_retc;
integer VEB_cnt;
real VBC;
integer VBC_retc;
integer VBC_cnt;

analog begin
   $bound_step( tstep_occ );
   @(initial_step) begin
      VCE_retc=0;
      VCE_cnt = maxEv;
      VEB_retc=0;
      VEB_cnt = maxEv;
      VBC_retc=0;
      VBC_cnt = maxEv;
   end
   V_B_C = V(B,C);
   V_E_B = V(E,B);
   V_C_E = V(C,E);

//      VCE
   VCE = V_C_E;
   if((VCE_cnt>0) || ( maxEv_flg==0 ))   begin
      if( (VCE < -5.5) && (VCE_retc!=-1))
      begin
        outfile=$fopen(errFileName,"a");
        $strobe("qpvc5         VCE     leaving   OCA (  .. -5.500 V ) at %7.4r  %M", $abstime );
        $fwrite(outfile,"qpvc5         VCE     leaving   OCA (  .. -5.500 V ) at %7.4r  %M\n", $abstime );
        VCE_retc=-1;
        VCE_cnt=VCE_cnt-1;
        $fclose(outfile);
      end
      if((VCE >= -5.5) &&  (VCE <= 0.1) && (VCE_retc!=0))
      begin
        outfile=$fopen(errFileName,"a");
        $strobe("qpvc5         VCE     entering SOCA ( -5.500 V .. 0.100 V ) at %7.4r  %M", $abstime );
        $fwrite(outfile,"qpvc5         VCE     entering SOCA ( -5.500 V .. 0.100 V ) at %7.4r  %M\n", $abstime );
        VCE_retc=0;
        VCE_cnt=VCE_cnt-1;
        $fclose(outfile);
      end
      if((VCE > 0.1) &&  (VCE_retc!=1))
      begin
        outfile=$fopen(errFileName,"a");
        $strobe("qpvc5         VCE     leaving   OCA ( 0.100 V ..  ) at %7.4r  %M", $abstime );
        $fwrite(outfile,"qpvc5         VCE     leaving   OCA ( 0.100 V ..  ) at %7.4r  %M\n", $abstime );
        VCE_retc=1;
        VCE_cnt=VCE_cnt-1;
        $fclose(outfile);
      end
   end
   else
   begin
      if(VCE_cnt==0)
      begin
        outfile=$fopen(errFileName,"a");
        $strobe("qpvc5         VCE     error limit ( %d ) reached at %7.4r  %M", maxEv, $abstime );
        $fwrite(outfile,"qpvc5         VCE     error limit ( %d ) reached at %7.4r  %M\n", maxEv, $abstime );
        VCE_cnt=VCE_cnt-1;
        $fclose(outfile);
      end
   end

//      VEB
   VEB = V_E_B;
   if((VEB_cnt>0) || ( maxEv_flg==0 ))   begin
      if( (VEB < -5.5) && (VEB_retc!=-1))
      begin
        outfile=$fopen(errFileName,"a");
        $strobe("qpvc5         VEB     leaving   OCA (  .. -5.500 V ) at %7.4r  %M", $abstime );
        $fwrite(outfile,"qpvc5         VEB     leaving   OCA (  .. -5.500 V ) at %7.4r  %M\n", $abstime );
        VEB_retc=-1;
        VEB_cnt=VEB_cnt-1;
        $fclose(outfile);
      end
      if((VEB >= -5.5) &&  (VEB <= 1.5) && (VEB_retc!=0))
      begin
        outfile=$fopen(errFileName,"a");
        $strobe("qpvc5         VEB     entering SOCA ( -5.500 V .. 1.500 V ) at %7.4r  %M", $abstime );
        $fwrite(outfile,"qpvc5         VEB     entering SOCA ( -5.500 V .. 1.500 V ) at %7.4r  %M\n", $abstime );
        VEB_retc=0;
        VEB_cnt=VEB_cnt-1;
        $fclose(outfile);
      end
      if((VEB > 1.5) &&  (VEB_retc!=1))
      begin
        outfile=$fopen(errFileName,"a");
        $strobe("qpvc5         VEB     leaving   OCA ( 1.500 V ..  ) at %7.4r  %M", $abstime );
        $fwrite(outfile,"qpvc5         VEB     leaving   OCA ( 1.500 V ..  ) at %7.4r  %M\n", $abstime );
        VEB_retc=1;
        VEB_cnt=VEB_cnt-1;
        $fclose(outfile);
      end
   end
   else
   begin
      if(VEB_cnt==0)
      begin
        outfile=$fopen(errFileName,"a");
        $strobe("qpvc5         VEB     error limit ( %d ) reached at %7.4r  %M", maxEv, $abstime );
        $fwrite(outfile,"qpvc5         VEB     error limit ( %d ) reached at %7.4r  %M\n", maxEv, $abstime );
        VEB_cnt=VEB_cnt-1;
        $fclose(outfile);
      end
   end

//      VBC
   VBC = V_B_C;
   if((VBC_cnt>0) || ( maxEv_flg==0 ))   begin
      if( (VBC < -0.1) && (VBC_retc!=-1))
      begin
        outfile=$fopen(errFileName,"a");
        $strobe("qpvc5         VBC     leaving   OCA (  .. -0.100 V ) at %7.4r  %M", $abstime );
        $fwrite(outfile,"qpvc5         VBC     leaving   OCA (  .. -0.100 V ) at %7.4r  %M\n", $abstime );
        VBC_retc=-1;
        VBC_cnt=VBC_cnt-1;
        $fclose(outfile);
      end
      if((VBC >= -0.1) &&  (VBC <= 5.5) && (VBC_retc!=0))
      begin
        outfile=$fopen(errFileName,"a");
        $strobe("qpvc5         VBC     entering SOCA ( -0.100 V .. 5.500 V ) at %7.4r  %M", $abstime );
        $fwrite(outfile,"qpvc5         VBC     entering SOCA ( -0.100 V .. 5.500 V ) at %7.4r  %M\n", $abstime );
        VBC_retc=0;
        VBC_cnt=VBC_cnt-1;
        $fclose(outfile);
      end
      if((VBC > 5.5) &&  (VBC_retc!=1))
      begin
        outfile=$fopen(errFileName,"a");
        $strobe("qpvc5         VBC     leaving   OCA ( 5.500 V ..  ) at %7.4r  %M", $abstime );
        $fwrite(outfile,"qpvc5         VBC     leaving   OCA ( 5.500 V ..  ) at %7.4r  %M\n", $abstime );
        VBC_retc=1;
        VBC_cnt=VBC_cnt-1;
        $fclose(outfile);
      end
   end
   else
   begin
      if(VBC_cnt==0)
      begin
        outfile=$fopen(errFileName,"a");
        $strobe("qpvc5         VBC     error limit ( %d ) reached at %7.4r  %M", maxEv, $abstime );
        $fwrite(outfile,"qpvc5         VBC     error limit ( %d ) reached at %7.4r  %M\n", maxEv, $abstime );
        VBC_cnt=VBC_cnt-1;
        $fclose(outfile);
      end
   end

end // analog
endmodule // qpvc5

// Verilog-A OC Watch for device qpve5 Parameters  VCE VEB VBC
module qpve5_ahdl(C,B,E);
parameter tstep_occ=100n;
parameter errFileName="./occ.err";
parameter maxEv = 25;
parameter maxEv_flg = 0;
inout C,B,E;
electrical C,B,E;

integer outfile;
real V_B_C;
real V_E_B;
real V_C_E;
real VCE;
integer VCE_retc;
integer VCE_cnt;
real VEB;
integer VEB_retc;
integer VEB_cnt;
real VBC;
integer VBC_retc;
integer VBC_cnt;

analog begin
   $bound_step( tstep_occ );
   @(initial_step) begin
      VCE_retc=0;
      VCE_cnt = maxEv;
      VEB_retc=0;
      VEB_cnt = maxEv;
      VBC_retc=0;
      VBC_cnt = maxEv;
   end
   V_B_C = V(B,C);
   V_E_B = V(E,B);
   V_C_E = V(C,E);

//      VCE
   VCE = V_C_E;
   if((VCE_cnt>0) || ( maxEv_flg==0 ))   begin
      if( (VCE < -5.5) && (VCE_retc!=-1))
      begin
        outfile=$fopen(errFileName,"a");
        $strobe("qpve5         VCE     leaving   OCA (  .. -5.500 V ) at %7.4r  %M", $abstime );
        $fwrite(outfile,"qpve5         VCE     leaving   OCA (  .. -5.500 V ) at %7.4r  %M\n", $abstime );
        VCE_retc=-1;
        VCE_cnt=VCE_cnt-1;
        $fclose(outfile);
      end
      if((VCE >= -5.5) &&  (VCE <= 0.1) && (VCE_retc!=0))
      begin
        outfile=$fopen(errFileName,"a");
        $strobe("qpve5         VCE     entering SOCA ( -5.500 V .. 0.100 V ) at %7.4r  %M", $abstime );
        $fwrite(outfile,"qpve5         VCE     entering SOCA ( -5.500 V .. 0.100 V ) at %7.4r  %M\n", $abstime );
        VCE_retc=0;
        VCE_cnt=VCE_cnt-1;
        $fclose(outfile);
      end
      if((VCE > 0.1) &&  (VCE_retc!=1))
      begin
        outfile=$fopen(errFileName,"a");
        $strobe("qpve5         VCE     leaving   OCA ( 0.100 V ..  ) at %7.4r  %M", $abstime );
        $fwrite(outfile,"qpve5         VCE     leaving   OCA ( 0.100 V ..  ) at %7.4r  %M\n", $abstime );
        VCE_retc=1;
        VCE_cnt=VCE_cnt-1;
        $fclose(outfile);
      end
   end
   else
   begin
      if(VCE_cnt==0)
      begin
        outfile=$fopen(errFileName,"a");
        $strobe("qpve5         VCE     error limit ( %d ) reached at %7.4r  %M", maxEv, $abstime );
        $fwrite(outfile,"qpve5         VCE     error limit ( %d ) reached at %7.4r  %M\n", maxEv, $abstime );
        VCE_cnt=VCE_cnt-1;
        $fclose(outfile);
      end
   end

//      VEB
   VEB = V_E_B;
   if((VEB_cnt>0) || ( maxEv_flg==0 ))   begin
      if( (VEB < -5.5) && (VEB_retc!=-1))
      begin
        outfile=$fopen(errFileName,"a");
        $strobe("qpve5         VEB     leaving   OCA (  .. -5.500 V ) at %7.4r  %M", $abstime );
        $fwrite(outfile,"qpve5         VEB     leaving   OCA (  .. -5.500 V ) at %7.4r  %M\n", $abstime );
        VEB_retc=-1;
        VEB_cnt=VEB_cnt-1;
        $fclose(outfile);
      end
      if((VEB >= -5.5) &&  (VEB <= 1.5) && (VEB_retc!=0))
      begin
        outfile=$fopen(errFileName,"a");
        $strobe("qpve5         VEB     entering SOCA ( -5.500 V .. 1.500 V ) at %7.4r  %M", $abstime );
        $fwrite(outfile,"qpve5         VEB     entering SOCA ( -5.500 V .. 1.500 V ) at %7.4r  %M\n", $abstime );
        VEB_retc=0;
        VEB_cnt=VEB_cnt-1;
        $fclose(outfile);
      end
      if((VEB > 1.5) &&  (VEB_retc!=1))
      begin
        outfile=$fopen(errFileName,"a");
        $strobe("qpve5         VEB     leaving   OCA ( 1.500 V ..  ) at %7.4r  %M", $abstime );
        $fwrite(outfile,"qpve5         VEB     leaving   OCA ( 1.500 V ..  ) at %7.4r  %M\n", $abstime );
        VEB_retc=1;
        VEB_cnt=VEB_cnt-1;
        $fclose(outfile);
      end
   end
   else
   begin
      if(VEB_cnt==0)
      begin
        outfile=$fopen(errFileName,"a");
        $strobe("qpve5         VEB     error limit ( %d ) reached at %7.4r  %M", maxEv, $abstime );
        $fwrite(outfile,"qpve5         VEB     error limit ( %d ) reached at %7.4r  %M\n", maxEv, $abstime );
        VEB_cnt=VEB_cnt-1;
        $fclose(outfile);
      end
   end

//      VBC
   VBC = V_B_C;
   if((VBC_cnt>0) || ( maxEv_flg==0 ))   begin
      if( (VBC < -0.1) && (VBC_retc!=-1))
      begin
        outfile=$fopen(errFileName,"a");
        $strobe("qpve5         VBC     leaving   OCA (  .. -0.100 V ) at %7.4r  %M", $abstime );
        $fwrite(outfile,"qpve5         VBC     leaving   OCA (  .. -0.100 V ) at %7.4r  %M\n", $abstime );
        VBC_retc=-1;
        VBC_cnt=VBC_cnt-1;
        $fclose(outfile);
      end
      if((VBC >= -0.1) &&  (VBC <= 5.5) && (VBC_retc!=0))
      begin
        outfile=$fopen(errFileName,"a");
        $strobe("qpve5         VBC     entering SOCA ( -0.100 V .. 5.500 V ) at %7.4r  %M", $abstime );
        $fwrite(outfile,"qpve5         VBC     entering SOCA ( -0.100 V .. 5.500 V ) at %7.4r  %M\n", $abstime );
        VBC_retc=0;
        VBC_cnt=VBC_cnt-1;
        $fclose(outfile);
      end
      if((VBC > 5.5) &&  (VBC_retc!=1))
      begin
        outfile=$fopen(errFileName,"a");
        $strobe("qpve5         VBC     leaving   OCA ( 5.500 V ..  ) at %7.4r  %M", $abstime );
        $fwrite(outfile,"qpve5         VBC     leaving   OCA ( 5.500 V ..  ) at %7.4r  %M\n", $abstime );
        VBC_retc=1;
        VBC_cnt=VBC_cnt-1;
        $fclose(outfile);
      end
   end
   else
   begin
      if(VBC_cnt==0)
      begin
        outfile=$fopen(errFileName,"a");
        $strobe("qpve5         VBC     error limit ( %d ) reached at %7.4r  %M", maxEv, $abstime );
        $fwrite(outfile,"qpve5         VBC     error limit ( %d ) reached at %7.4r  %M\n", maxEv, $abstime );
        VBC_cnt=VBC_cnt-1;
        $fclose(outfile);
      end
   end

end // analog
endmodule // qpve5

// Verilog-A OC Watch for device qpvf5 Parameters  VCE VEB VBC
module qpvf5_ahdl(C,B,E);
parameter tstep_occ=100n;
parameter errFileName="./occ.err";
parameter maxEv = 25;
parameter maxEv_flg = 0;
inout C,B,E;
electrical C,B,E;

integer outfile;
real V_B_C;
real V_E_B;
real V_C_E;
real VCE;
integer VCE_retc;
integer VCE_cnt;
real VEB;
integer VEB_retc;
integer VEB_cnt;
real VBC;
integer VBC_retc;
integer VBC_cnt;

analog begin
   $bound_step( tstep_occ );
   @(initial_step) begin
      VCE_retc=0;
      VCE_cnt = maxEv;
      VEB_retc=0;
      VEB_cnt = maxEv;
      VBC_retc=0;
      VBC_cnt = maxEv;
   end
   V_B_C = V(B,C);
   V_E_B = V(E,B);
   V_C_E = V(C,E);

//      VCE
   VCE = V_C_E;
   if((VCE_cnt>0) || ( maxEv_flg==0 ))   begin
      if( (VCE < -5.5) && (VCE_retc!=-1))
      begin
        outfile=$fopen(errFileName,"a");
        $strobe("qpvf5         VCE     leaving   OCA (  .. -5.500 V ) at %7.4r  %M", $abstime );
        $fwrite(outfile,"qpvf5         VCE     leaving   OCA (  .. -5.500 V ) at %7.4r  %M\n", $abstime );
        VCE_retc=-1;
        VCE_cnt=VCE_cnt-1;
        $fclose(outfile);
      end
      if((VCE >= -5.5) &&  (VCE <= 0.1) && (VCE_retc!=0))
      begin
        outfile=$fopen(errFileName,"a");
        $strobe("qpvf5         VCE     entering SOCA ( -5.500 V .. 0.100 V ) at %7.4r  %M", $abstime );
        $fwrite(outfile,"qpvf5         VCE     entering SOCA ( -5.500 V .. 0.100 V ) at %7.4r  %M\n", $abstime );
        VCE_retc=0;
        VCE_cnt=VCE_cnt-1;
        $fclose(outfile);
      end
      if((VCE > 0.1) &&  (VCE_retc!=1))
      begin
        outfile=$fopen(errFileName,"a");
        $strobe("qpvf5         VCE     leaving   OCA ( 0.100 V ..  ) at %7.4r  %M", $abstime );
        $fwrite(outfile,"qpvf5         VCE     leaving   OCA ( 0.100 V ..  ) at %7.4r  %M\n", $abstime );
        VCE_retc=1;
        VCE_cnt=VCE_cnt-1;
        $fclose(outfile);
      end
   end
   else
   begin
      if(VCE_cnt==0)
      begin
        outfile=$fopen(errFileName,"a");
        $strobe("qpvf5         VCE     error limit ( %d ) reached at %7.4r  %M", maxEv, $abstime );
        $fwrite(outfile,"qpvf5         VCE     error limit ( %d ) reached at %7.4r  %M\n", maxEv, $abstime );
        VCE_cnt=VCE_cnt-1;
        $fclose(outfile);
      end
   end

//      VEB
   VEB = V_E_B;
   if((VEB_cnt>0) || ( maxEv_flg==0 ))   begin
      if( (VEB < -5.5) && (VEB_retc!=-1))
      begin
        outfile=$fopen(errFileName,"a");
        $strobe("qpvf5         VEB     leaving   OCA (  .. -5.500 V ) at %7.4r  %M", $abstime );
        $fwrite(outfile,"qpvf5         VEB     leaving   OCA (  .. -5.500 V ) at %7.4r  %M\n", $abstime );
        VEB_retc=-1;
        VEB_cnt=VEB_cnt-1;
        $fclose(outfile);
      end
      if((VEB >= -5.5) &&  (VEB <= 1.5) && (VEB_retc!=0))
      begin
        outfile=$fopen(errFileName,"a");
        $strobe("qpvf5         VEB     entering SOCA ( -5.500 V .. 1.500 V ) at %7.4r  %M", $abstime );
        $fwrite(outfile,"qpvf5         VEB     entering SOCA ( -5.500 V .. 1.500 V ) at %7.4r  %M\n", $abstime );
        VEB_retc=0;
        VEB_cnt=VEB_cnt-1;
        $fclose(outfile);
      end
      if((VEB > 1.5) &&  (VEB_retc!=1))
      begin
        outfile=$fopen(errFileName,"a");
        $strobe("qpvf5         VEB     leaving   OCA ( 1.500 V ..  ) at %7.4r  %M", $abstime );
        $fwrite(outfile,"qpvf5         VEB     leaving   OCA ( 1.500 V ..  ) at %7.4r  %M\n", $abstime );
        VEB_retc=1;
        VEB_cnt=VEB_cnt-1;
        $fclose(outfile);
      end
   end
   else
   begin
      if(VEB_cnt==0)
      begin
        outfile=$fopen(errFileName,"a");
        $strobe("qpvf5         VEB     error limit ( %d ) reached at %7.4r  %M", maxEv, $abstime );
        $fwrite(outfile,"qpvf5         VEB     error limit ( %d ) reached at %7.4r  %M\n", maxEv, $abstime );
        VEB_cnt=VEB_cnt-1;
        $fclose(outfile);
      end
   end

//      VBC
   VBC = V_B_C;
   if((VBC_cnt>0) || ( maxEv_flg==0 ))   begin
      if( (VBC < -0.1) && (VBC_retc!=-1))
      begin
        outfile=$fopen(errFileName,"a");
        $strobe("qpvf5         VBC     leaving   OCA (  .. -0.100 V ) at %7.4r  %M", $abstime );
        $fwrite(outfile,"qpvf5         VBC     leaving   OCA (  .. -0.100 V ) at %7.4r  %M\n", $abstime );
        VBC_retc=-1;
        VBC_cnt=VBC_cnt-1;
        $fclose(outfile);
      end
      if((VBC >= -0.1) &&  (VBC <= 5.5) && (VBC_retc!=0))
      begin
        outfile=$fopen(errFileName,"a");
        $strobe("qpvf5         VBC     entering SOCA ( -0.100 V .. 5.500 V ) at %7.4r  %M", $abstime );
        $fwrite(outfile,"qpvf5         VBC     entering SOCA ( -0.100 V .. 5.500 V ) at %7.4r  %M\n", $abstime );
        VBC_retc=0;
        VBC_cnt=VBC_cnt-1;
        $fclose(outfile);
      end
      if((VBC > 5.5) &&  (VBC_retc!=1))
      begin
        outfile=$fopen(errFileName,"a");
        $strobe("qpvf5         VBC     leaving   OCA ( 5.500 V ..  ) at %7.4r  %M", $abstime );
        $fwrite(outfile,"qpvf5         VBC     leaving   OCA ( 5.500 V ..  ) at %7.4r  %M\n", $abstime );
        VBC_retc=1;
        VBC_cnt=VBC_cnt-1;
        $fclose(outfile);
      end
   end
   else
   begin
      if(VBC_cnt==0)
      begin
        outfile=$fopen(errFileName,"a");
        $strobe("qpvf5         VBC     error limit ( %d ) reached at %7.4r  %M", maxEv, $abstime );
        $fwrite(outfile,"qpvf5         VBC     error limit ( %d ) reached at %7.4r  %M\n", maxEv, $abstime );
        VBC_cnt=VBC_cnt-1;
        $fclose(outfile);
      end
   end

end // analog
endmodule // qpvf5

// Verilog-A OC Watch for device qpvg5 Parameters  VCE VEB VBC
module qpvg5_ahdl(C,B,E);
parameter tstep_occ=100n;
parameter errFileName="./occ.err";
parameter maxEv = 25;
parameter maxEv_flg = 0;
inout C,B,E;
electrical C,B,E;

integer outfile;
real V_B_C;
real V_E_B;
real V_C_E;
real VCE;
integer VCE_retc;
integer VCE_cnt;
real VEB;
integer VEB_retc;
integer VEB_cnt;
real VBC;
integer VBC_retc;
integer VBC_cnt;

analog begin
   $bound_step( tstep_occ );
   @(initial_step) begin
      VCE_retc=0;
      VCE_cnt = maxEv;
      VEB_retc=0;
      VEB_cnt = maxEv;
      VBC_retc=0;
      VBC_cnt = maxEv;
   end
   V_B_C = V(B,C);
   V_E_B = V(E,B);
   V_C_E = V(C,E);

//      VCE
   VCE = V_C_E;
   if((VCE_cnt>0) || ( maxEv_flg==0 ))   begin
      if( (VCE < -5.5) && (VCE_retc!=-1))
      begin
        outfile=$fopen(errFileName,"a");
        $strobe("qpvg5         VCE     leaving   OCA (  .. -5.500 V ) at %7.4r  %M", $abstime );
        $fwrite(outfile,"qpvg5         VCE     leaving   OCA (  .. -5.500 V ) at %7.4r  %M\n", $abstime );
        VCE_retc=-1;
        VCE_cnt=VCE_cnt-1;
        $fclose(outfile);
      end
      if((VCE >= -5.5) &&  (VCE <= 0.1) && (VCE_retc!=0))
      begin
        outfile=$fopen(errFileName,"a");
        $strobe("qpvg5         VCE     entering SOCA ( -5.500 V .. 0.100 V ) at %7.4r  %M", $abstime );
        $fwrite(outfile,"qpvg5         VCE     entering SOCA ( -5.500 V .. 0.100 V ) at %7.4r  %M\n", $abstime );
        VCE_retc=0;
        VCE_cnt=VCE_cnt-1;
        $fclose(outfile);
      end
      if((VCE > 0.1) &&  (VCE_retc!=1))
      begin
        outfile=$fopen(errFileName,"a");
        $strobe("qpvg5         VCE     leaving   OCA ( 0.100 V ..  ) at %7.4r  %M", $abstime );
        $fwrite(outfile,"qpvg5         VCE     leaving   OCA ( 0.100 V ..  ) at %7.4r  %M\n", $abstime );
        VCE_retc=1;
        VCE_cnt=VCE_cnt-1;
        $fclose(outfile);
      end
   end
   else
   begin
      if(VCE_cnt==0)
      begin
        outfile=$fopen(errFileName,"a");
        $strobe("qpvg5         VCE     error limit ( %d ) reached at %7.4r  %M", maxEv, $abstime );
        $fwrite(outfile,"qpvg5         VCE     error limit ( %d ) reached at %7.4r  %M\n", maxEv, $abstime );
        VCE_cnt=VCE_cnt-1;
        $fclose(outfile);
      end
   end

//      VEB
   VEB = V_E_B;
   if((VEB_cnt>0) || ( maxEv_flg==0 ))   begin
      if( (VEB < -5.5) && (VEB_retc!=-1))
      begin
        outfile=$fopen(errFileName,"a");
        $strobe("qpvg5         VEB     leaving   OCA (  .. -5.500 V ) at %7.4r  %M", $abstime );
        $fwrite(outfile,"qpvg5         VEB     leaving   OCA (  .. -5.500 V ) at %7.4r  %M\n", $abstime );
        VEB_retc=-1;
        VEB_cnt=VEB_cnt-1;
        $fclose(outfile);
      end
      if((VEB >= -5.5) &&  (VEB <= 1.5) && (VEB_retc!=0))
      begin
        outfile=$fopen(errFileName,"a");
        $strobe("qpvg5         VEB     entering SOCA ( -5.500 V .. 1.500 V ) at %7.4r  %M", $abstime );
        $fwrite(outfile,"qpvg5         VEB     entering SOCA ( -5.500 V .. 1.500 V ) at %7.4r  %M\n", $abstime );
        VEB_retc=0;
        VEB_cnt=VEB_cnt-1;
        $fclose(outfile);
      end
      if((VEB > 1.5) &&  (VEB_retc!=1))
      begin
        outfile=$fopen(errFileName,"a");
        $strobe("qpvg5         VEB     leaving   OCA ( 1.500 V ..  ) at %7.4r  %M", $abstime );
        $fwrite(outfile,"qpvg5         VEB     leaving   OCA ( 1.500 V ..  ) at %7.4r  %M\n", $abstime );
        VEB_retc=1;
        VEB_cnt=VEB_cnt-1;
        $fclose(outfile);
      end
   end
   else
   begin
      if(VEB_cnt==0)
      begin
        outfile=$fopen(errFileName,"a");
        $strobe("qpvg5         VEB     error limit ( %d ) reached at %7.4r  %M", maxEv, $abstime );
        $fwrite(outfile,"qpvg5         VEB     error limit ( %d ) reached at %7.4r  %M\n", maxEv, $abstime );
        VEB_cnt=VEB_cnt-1;
        $fclose(outfile);
      end
   end

//      VBC
   VBC = V_B_C;
   if((VBC_cnt>0) || ( maxEv_flg==0 ))   begin
      if( (VBC < -0.1) && (VBC_retc!=-1))
      begin
        outfile=$fopen(errFileName,"a");
        $strobe("qpvg5         VBC     leaving   OCA (  .. -0.100 V ) at %7.4r  %M", $abstime );
        $fwrite(outfile,"qpvg5         VBC     leaving   OCA (  .. -0.100 V ) at %7.4r  %M\n", $abstime );
        VBC_retc=-1;
        VBC_cnt=VBC_cnt-1;
        $fclose(outfile);
      end
      if((VBC >= -0.1) &&  (VBC <= 5.5) && (VBC_retc!=0))
      begin
        outfile=$fopen(errFileName,"a");
        $strobe("qpvg5         VBC     entering SOCA ( -0.100 V .. 5.500 V ) at %7.4r  %M", $abstime );
        $fwrite(outfile,"qpvg5         VBC     entering SOCA ( -0.100 V .. 5.500 V ) at %7.4r  %M\n", $abstime );
        VBC_retc=0;
        VBC_cnt=VBC_cnt-1;
        $fclose(outfile);
      end
      if((VBC > 5.5) &&  (VBC_retc!=1))
      begin
        outfile=$fopen(errFileName,"a");
        $strobe("qpvg5         VBC     leaving   OCA ( 5.500 V ..  ) at %7.4r  %M", $abstime );
        $fwrite(outfile,"qpvg5         VBC     leaving   OCA ( 5.500 V ..  ) at %7.4r  %M\n", $abstime );
        VBC_retc=1;
        VBC_cnt=VBC_cnt-1;
        $fclose(outfile);
      end
   end
   else
   begin
      if(VBC_cnt==0)
      begin
        outfile=$fopen(errFileName,"a");
        $strobe("qpvg5         VBC     error limit ( %d ) reached at %7.4r  %M", maxEv, $abstime );
        $fwrite(outfile,"qpvg5         VBC     error limit ( %d ) reached at %7.4r  %M\n", maxEv, $abstime );
        VBC_cnt=VBC_cnt-1;
        $fclose(outfile);
      end
   end

end // analog
endmodule // qpvg5

// Verilog-A OC Watch for device qnv5 Parameters  VCE VEB VBC
module qnv5_ahdl(C,B,E);
parameter tstep_occ=100n;
parameter errFileName="./occ.err";
parameter maxEv = 25;
parameter maxEv_flg = 0;
inout C,B,E;
electrical C,B,E;

integer outfile;
real V_B_C;
real V_E_B;
real V_C_E;
real VCE;
integer VCE_retc;
integer VCE_cnt;
real VEB;
integer VEB_retc;
integer VEB_cnt;
real VBC;
integer VBC_retc;
integer VBC_cnt;

analog begin
   $bound_step( tstep_occ );
   @(initial_step) begin
      VCE_retc=0;
      VCE_cnt = maxEv;
      VEB_retc=0;
      VEB_cnt = maxEv;
      VBC_retc=0;
      VBC_cnt = maxEv;
   end
   V_B_C = V(B,C);
   V_E_B = V(E,B);
   V_C_E = V(C,E);

//      VCE
   VCE = V_C_E;
   if((VCE_cnt>0) || ( maxEv_flg==0 ))   begin
      if( (VCE < -5.5) && (VCE_retc!=-1))
      begin
        outfile=$fopen(errFileName,"a");
        $strobe("qnv5          VCE     leaving   OCA (  .. -5.500 V ) at %7.4r  %M", $abstime );
        $fwrite(outfile,"qnv5          VCE     leaving   OCA (  .. -5.500 V ) at %7.4r  %M\n", $abstime );
        VCE_retc=-1;
        VCE_cnt=VCE_cnt-1;
        $fclose(outfile);
      end
      if((VCE >= -5.5) &&  (VCE <= 5.5) && (VCE_retc!=0))
      begin
        outfile=$fopen(errFileName,"a");
        $strobe("qnv5          VCE     entering SOCA ( -5.500 V .. 5.500 V ) at %7.4r  %M", $abstime );
        $fwrite(outfile,"qnv5          VCE     entering SOCA ( -5.500 V .. 5.500 V ) at %7.4r  %M\n", $abstime );
        VCE_retc=0;
        VCE_cnt=VCE_cnt-1;
        $fclose(outfile);
      end
      if((VCE > 5.5) &&  (VCE_retc!=1))
      begin
        outfile=$fopen(errFileName,"a");
        $strobe("qnv5          VCE     leaving   OCA ( 5.500 V ..  ) at %7.4r  %M", $abstime );
        $fwrite(outfile,"qnv5          VCE     leaving   OCA ( 5.500 V ..  ) at %7.4r  %M\n", $abstime );
        VCE_retc=1;
        VCE_cnt=VCE_cnt-1;
        $fclose(outfile);
      end
   end
   else
   begin
      if(VCE_cnt==0)
      begin
        outfile=$fopen(errFileName,"a");
        $strobe("qnv5          VCE     error limit ( %d ) reached at %7.4r  %M", maxEv, $abstime );
        $fwrite(outfile,"qnv5          VCE     error limit ( %d ) reached at %7.4r  %M\n", maxEv, $abstime );
        VCE_cnt=VCE_cnt-1;
        $fclose(outfile);
      end
   end

//      VEB
   VEB = V_E_B;
   if((VEB_cnt>0) || ( maxEv_flg==0 ))   begin
      if( (VEB < -1.5) && (VEB_retc!=-1))
      begin
        outfile=$fopen(errFileName,"a");
        $strobe("qnv5          VEB     leaving   OCA (  .. -1.500 V ) at %7.4r  %M", $abstime );
        $fwrite(outfile,"qnv5          VEB     leaving   OCA (  .. -1.500 V ) at %7.4r  %M\n", $abstime );
        VEB_retc=-1;
        VEB_cnt=VEB_cnt-1;
        $fclose(outfile);
      end
      if((VEB >= -1.5) &&  (VEB <= 5.5) && (VEB_retc!=0))
      begin
        outfile=$fopen(errFileName,"a");
        $strobe("qnv5          VEB     entering SOCA ( -1.500 V .. 5.500 V ) at %7.4r  %M", $abstime );
        $fwrite(outfile,"qnv5          VEB     entering SOCA ( -1.500 V .. 5.500 V ) at %7.4r  %M\n", $abstime );
        VEB_retc=0;
        VEB_cnt=VEB_cnt-1;
        $fclose(outfile);
      end
      if((VEB > 5.5) &&  (VEB_retc!=1))
      begin
        outfile=$fopen(errFileName,"a");
        $strobe("qnv5          VEB     leaving   OCA ( 5.500 V ..  ) at %7.4r  %M", $abstime );
        $fwrite(outfile,"qnv5          VEB     leaving   OCA ( 5.500 V ..  ) at %7.4r  %M\n", $abstime );
        VEB_retc=1;
        VEB_cnt=VEB_cnt-1;
        $fclose(outfile);
      end
   end
   else
   begin
      if(VEB_cnt==0)
      begin
        outfile=$fopen(errFileName,"a");
        $strobe("qnv5          VEB     error limit ( %d ) reached at %7.4r  %M", maxEv, $abstime );
        $fwrite(outfile,"qnv5          VEB     error limit ( %d ) reached at %7.4r  %M\n", maxEv, $abstime );
        VEB_cnt=VEB_cnt-1;
        $fclose(outfile);
      end
   end

//      VBC
   VBC = V_B_C;
   if((VBC_cnt>0) || ( maxEv_flg==0 ))   begin
      if( (VBC < -5.5) && (VBC_retc!=-1))
      begin
        outfile=$fopen(errFileName,"a");
        $strobe("qnv5          VBC     leaving   OCA (  .. -5.500 V ) at %7.4r  %M", $abstime );
        $fwrite(outfile,"qnv5          VBC     leaving   OCA (  .. -5.500 V ) at %7.4r  %M\n", $abstime );
        VBC_retc=-1;
        VBC_cnt=VBC_cnt-1;
        $fclose(outfile);
      end
      if((VBC >= -5.5) &&  (VBC <= 0.1) && (VBC_retc!=0))
      begin
        outfile=$fopen(errFileName,"a");
        $strobe("qnv5          VBC     entering SOCA ( -5.500 V .. 0.100 V ) at %7.4r  %M", $abstime );
        $fwrite(outfile,"qnv5          VBC     entering SOCA ( -5.500 V .. 0.100 V ) at %7.4r  %M\n", $abstime );
        VBC_retc=0;
        VBC_cnt=VBC_cnt-1;
        $fclose(outfile);
      end
      if((VBC > 0.1) &&  (VBC_retc!=1))
      begin
        outfile=$fopen(errFileName,"a");
        $strobe("qnv5          VBC     leaving   OCA ( 0.100 V ..  ) at %7.4r  %M", $abstime );
        $fwrite(outfile,"qnv5          VBC     leaving   OCA ( 0.100 V ..  ) at %7.4r  %M\n", $abstime );
        VBC_retc=1;
        VBC_cnt=VBC_cnt-1;
        $fclose(outfile);
      end
   end
   else
   begin
      if(VBC_cnt==0)
      begin
        outfile=$fopen(errFileName,"a");
        $strobe("qnv5          VBC     error limit ( %d ) reached at %7.4r  %M", maxEv, $abstime );
        $fwrite(outfile,"qnv5          VBC     error limit ( %d ) reached at %7.4r  %M\n", maxEv, $abstime );
        VBC_cnt=VBC_cnt-1;
        $fclose(outfile);
      end
   end

end // analog
endmodule // qnv5

// Verilog-A OC Watch for device qpv5 Parameters  VCE VEB VBC
module qpv5_ahdl(C,B,E);
parameter tstep_occ=100n;
parameter errFileName="./occ.err";
parameter maxEv = 25;
parameter maxEv_flg = 0;
inout C,B,E;
electrical C,B,E;

integer outfile;
real V_B_C;
real V_E_B;
real V_C_E;
real VCE;
integer VCE_retc;
integer VCE_cnt;
real VEB;
integer VEB_retc;
integer VEB_cnt;
real VBC;
integer VBC_retc;
integer VBC_cnt;

analog begin
   $bound_step( tstep_occ );
   @(initial_step) begin
      VCE_retc=0;
      VCE_cnt = maxEv;
      VEB_retc=0;
      VEB_cnt = maxEv;
      VBC_retc=0;
      VBC_cnt = maxEv;
   end
   V_B_C = V(B,C);
   V_E_B = V(E,B);
   V_C_E = V(C,E);

//      VCE
   VCE = V_C_E;
   if((VCE_cnt>0) || ( maxEv_flg==0 ))   begin
      if( (VCE < -5.5) && (VCE_retc!=-1))
      begin
        outfile=$fopen(errFileName,"a");
        $strobe("qpv5          VCE     leaving   OCA (  .. -5.500 V ) at %7.4r  %M", $abstime );
        $fwrite(outfile,"qpv5          VCE     leaving   OCA (  .. -5.500 V ) at %7.4r  %M\n", $abstime );
        VCE_retc=-1;
        VCE_cnt=VCE_cnt-1;
        $fclose(outfile);
      end
      if((VCE >= -5.5) &&  (VCE <= 5.5) && (VCE_retc!=0))
      begin
        outfile=$fopen(errFileName,"a");
        $strobe("qpv5          VCE     entering SOCA ( -5.500 V .. 5.500 V ) at %7.4r  %M", $abstime );
        $fwrite(outfile,"qpv5          VCE     entering SOCA ( -5.500 V .. 5.500 V ) at %7.4r  %M\n", $abstime );
        VCE_retc=0;
        VCE_cnt=VCE_cnt-1;
        $fclose(outfile);
      end
      if((VCE > 5.5) &&  (VCE_retc!=1))
      begin
        outfile=$fopen(errFileName,"a");
        $strobe("qpv5          VCE     leaving   OCA ( 5.500 V ..  ) at %7.4r  %M", $abstime );
        $fwrite(outfile,"qpv5          VCE     leaving   OCA ( 5.500 V ..  ) at %7.4r  %M\n", $abstime );
        VCE_retc=1;
        VCE_cnt=VCE_cnt-1;
        $fclose(outfile);
      end
   end
   else
   begin
      if(VCE_cnt==0)
      begin
        outfile=$fopen(errFileName,"a");
        $strobe("qpv5          VCE     error limit ( %d ) reached at %7.4r  %M", maxEv, $abstime );
        $fwrite(outfile,"qpv5          VCE     error limit ( %d ) reached at %7.4r  %M\n", maxEv, $abstime );
        VCE_cnt=VCE_cnt-1;
        $fclose(outfile);
      end
   end

//      VEB
   VEB = V_E_B;
   if((VEB_cnt>0) || ( maxEv_flg==0 ))   begin
      if( (VEB < -5.5) && (VEB_retc!=-1))
      begin
        outfile=$fopen(errFileName,"a");
        $strobe("qpv5          VEB     leaving   OCA (  .. -5.500 V ) at %7.4r  %M", $abstime );
        $fwrite(outfile,"qpv5          VEB     leaving   OCA (  .. -5.500 V ) at %7.4r  %M\n", $abstime );
        VEB_retc=-1;
        VEB_cnt=VEB_cnt-1;
        $fclose(outfile);
      end
      if((VEB >= -5.5) &&  (VEB <= 1.5) && (VEB_retc!=0))
      begin
        outfile=$fopen(errFileName,"a");
        $strobe("qpv5          VEB     entering SOCA ( -5.500 V .. 1.500 V ) at %7.4r  %M", $abstime );
        $fwrite(outfile,"qpv5          VEB     entering SOCA ( -5.500 V .. 1.500 V ) at %7.4r  %M\n", $abstime );
        VEB_retc=0;
        VEB_cnt=VEB_cnt-1;
        $fclose(outfile);
      end
      if((VEB > 1.5) &&  (VEB_retc!=1))
      begin
        outfile=$fopen(errFileName,"a");
        $strobe("qpv5          VEB     leaving   OCA ( 1.500 V ..  ) at %7.4r  %M", $abstime );
        $fwrite(outfile,"qpv5          VEB     leaving   OCA ( 1.500 V ..  ) at %7.4r  %M\n", $abstime );
        VEB_retc=1;
        VEB_cnt=VEB_cnt-1;
        $fclose(outfile);
      end
   end
   else
   begin
      if(VEB_cnt==0)
      begin
        outfile=$fopen(errFileName,"a");
        $strobe("qpv5          VEB     error limit ( %d ) reached at %7.4r  %M", maxEv, $abstime );
        $fwrite(outfile,"qpv5          VEB     error limit ( %d ) reached at %7.4r  %M\n", maxEv, $abstime );
        VEB_cnt=VEB_cnt-1;
        $fclose(outfile);
      end
   end

//      VBC
   VBC = V_B_C;
   if((VBC_cnt>0) || ( maxEv_flg==0 ))   begin
      if( (VBC < -0.1) && (VBC_retc!=-1))
      begin
        outfile=$fopen(errFileName,"a");
        $strobe("qpv5          VBC     leaving   OCA (  .. -0.100 V ) at %7.4r  %M", $abstime );
        $fwrite(outfile,"qpv5          VBC     leaving   OCA (  .. -0.100 V ) at %7.4r  %M\n", $abstime );
        VBC_retc=-1;
        VBC_cnt=VBC_cnt-1;
        $fclose(outfile);
      end
      if((VBC >= -0.1) &&  (VBC <= 5.5) && (VBC_retc!=0))
      begin
        outfile=$fopen(errFileName,"a");
        $strobe("qpv5          VBC     entering SOCA ( -0.100 V .. 5.500 V ) at %7.4r  %M", $abstime );
        $fwrite(outfile,"qpv5          VBC     entering SOCA ( -0.100 V .. 5.500 V ) at %7.4r  %M\n", $abstime );
        VBC_retc=0;
        VBC_cnt=VBC_cnt-1;
        $fclose(outfile);
      end
      if((VBC > 5.5) &&  (VBC_retc!=1))
      begin
        outfile=$fopen(errFileName,"a");
        $strobe("qpv5          VBC     leaving   OCA ( 5.500 V ..  ) at %7.4r  %M", $abstime );
        $fwrite(outfile,"qpv5          VBC     leaving   OCA ( 5.500 V ..  ) at %7.4r  %M\n", $abstime );
        VBC_retc=1;
        VBC_cnt=VBC_cnt-1;
        $fclose(outfile);
      end
   end
   else
   begin
      if(VBC_cnt==0)
      begin
        outfile=$fopen(errFileName,"a");
        $strobe("qpv5          VBC     error limit ( %d ) reached at %7.4r  %M", maxEv, $abstime );
        $fwrite(outfile,"qpv5          VBC     error limit ( %d ) reached at %7.4r  %M\n", maxEv, $abstime );
        VBC_cnt=VBC_cnt-1;
        $fclose(outfile);
      end
   end

end // analog
endmodule // qpv5

// Verilog-A OC Watch for device qnvha Parameters  VCE VEB VBC PMax
module qnvha_ahdl(C1,B1,E1,C,B,E);
parameter tstep_occ=100n;
parameter errFileName="./occ.err";
parameter le = 1u;
parameter maxEv = 25;
parameter maxEv_flg = 0;
inout C1,B1,E1,C,B,E;
electrical C1,B1,E1,C,B,E;

integer outfile;
real V_B_C;
real V_E_B;
real V_C_E;
real I_E;
real I_B;
real I_C;
real VCE;
integer VCE_retc;
integer VCE_cnt;
real VEB;
integer VEB_retc;
integer VEB_cnt;
real VBC;
integer VBC_retc;
integer VBC_cnt;
real PMax;
integer PMax_retc;
integer PMax_cnt;

analog begin
   $bound_step( tstep_occ );
   @(initial_step) begin
      VCE_retc=0;
      VCE_cnt = maxEv;
      VEB_retc=0;
      VEB_cnt = maxEv;
      VBC_retc=0;
      VBC_cnt = maxEv;
      PMax_retc=0;
      PMax_cnt = maxEv;
   end
   V_B_C = V(B,C);
   V_E_B = V(E,B);
   V_C_E = V(C,E);
   I_E = I(E1,E);
   I_B = I(B1,B);
   I_C = I(C1,C);

//      VCE
   VCE = V_C_E;
   if((VCE_cnt>0) || ( maxEv_flg==0 ))   begin
      if( (VCE < -5.5) && (VCE_retc!=-1))
      begin
        outfile=$fopen(errFileName,"a");
        $strobe("qnvha         VCE     leaving   OCA (  .. -5.500 V ) at %7.4r  %M", $abstime );
        $fwrite(outfile,"qnvha         VCE     leaving   OCA (  .. -5.500 V ) at %7.4r  %M\n", $abstime );
        VCE_retc=-1;
        VCE_cnt=VCE_cnt-1;
        $fclose(outfile);
      end
      if((VCE >= -5.5) &&  (VCE <= 25) && (VCE_retc!=0))
      begin
        outfile=$fopen(errFileName,"a");
        $strobe("qnvha         VCE     entering SOCA ( -5.500 V .. 25.000 V ) at %7.4r  %M", $abstime );
        $fwrite(outfile,"qnvha         VCE     entering SOCA ( -5.500 V .. 25.000 V ) at %7.4r  %M\n", $abstime );
        VCE_retc=0;
        VCE_cnt=VCE_cnt-1;
        $fclose(outfile);
      end
      if((VCE > 25) &&  (VCE_retc!=1))
      begin
        outfile=$fopen(errFileName,"a");
        $strobe("qnvha         VCE     leaving   OCA ( 25.000 V ..  ) at %7.4r  %M", $abstime );
        $fwrite(outfile,"qnvha         VCE     leaving   OCA ( 25.000 V ..  ) at %7.4r  %M\n", $abstime );
        VCE_retc=1;
        VCE_cnt=VCE_cnt-1;
        $fclose(outfile);
      end
   end
   else
   begin
      if(VCE_cnt==0)
      begin
        outfile=$fopen(errFileName,"a");
        $strobe("qnvha         VCE     error limit ( %d ) reached at %7.4r  %M", maxEv, $abstime );
        $fwrite(outfile,"qnvha         VCE     error limit ( %d ) reached at %7.4r  %M\n", maxEv, $abstime );
        VCE_cnt=VCE_cnt-1;
        $fclose(outfile);
      end
   end

//      VEB
   VEB = V_E_B;
   if((VEB_cnt>0) || ( maxEv_flg==0 ))   begin
      if( (VEB < -1.5) && (VEB_retc!=-1))
      begin
        outfile=$fopen(errFileName,"a");
        $strobe("qnvha         VEB     leaving   OCA (  .. -1.500 V ) at %7.4r  %M", $abstime );
        $fwrite(outfile,"qnvha         VEB     leaving   OCA (  .. -1.500 V ) at %7.4r  %M\n", $abstime );
        VEB_retc=-1;
        VEB_cnt=VEB_cnt-1;
        $fclose(outfile);
      end
      if((VEB >= -1.5) &&  (VEB <= 5.5) && (VEB_retc!=0))
      begin
        outfile=$fopen(errFileName,"a");
        $strobe("qnvha         VEB     entering SOCA ( -1.500 V .. 5.500 V ) at %7.4r  %M", $abstime );
        $fwrite(outfile,"qnvha         VEB     entering SOCA ( -1.500 V .. 5.500 V ) at %7.4r  %M\n", $abstime );
        VEB_retc=0;
        VEB_cnt=VEB_cnt-1;
        $fclose(outfile);
      end
      if((VEB > 5.5) &&  (VEB_retc!=1))
      begin
        outfile=$fopen(errFileName,"a");
        $strobe("qnvha         VEB     leaving   OCA ( 5.500 V ..  ) at %7.4r  %M", $abstime );
        $fwrite(outfile,"qnvha         VEB     leaving   OCA ( 5.500 V ..  ) at %7.4r  %M\n", $abstime );
        VEB_retc=1;
        VEB_cnt=VEB_cnt-1;
        $fclose(outfile);
      end
   end
   else
   begin
      if(VEB_cnt==0)
      begin
        outfile=$fopen(errFileName,"a");
        $strobe("qnvha         VEB     error limit ( %d ) reached at %7.4r  %M", maxEv, $abstime );
        $fwrite(outfile,"qnvha         VEB     error limit ( %d ) reached at %7.4r  %M\n", maxEv, $abstime );
        VEB_cnt=VEB_cnt-1;
        $fclose(outfile);
      end
   end

//      VBC
   VBC = V_B_C;
   if((VBC_cnt>0) || ( maxEv_flg==0 ))   begin
      if( (VBC < -25) && (VBC_retc!=-1))
      begin
        outfile=$fopen(errFileName,"a");
        $strobe("qnvha         VBC     leaving   OCA (  .. -25.000 V ) at %7.4r  %M", $abstime );
        $fwrite(outfile,"qnvha         VBC     leaving   OCA (  .. -25.000 V ) at %7.4r  %M\n", $abstime );
        VBC_retc=-1;
        VBC_cnt=VBC_cnt-1;
        $fclose(outfile);
      end
      if((VBC >= -25) &&  (VBC <= 0.1) && (VBC_retc!=0))
      begin
        outfile=$fopen(errFileName,"a");
        $strobe("qnvha         VBC     entering SOCA ( -25.000 V .. 0.100 V ) at %7.4r  %M", $abstime );
        $fwrite(outfile,"qnvha         VBC     entering SOCA ( -25.000 V .. 0.100 V ) at %7.4r  %M\n", $abstime );
        VBC_retc=0;
        VBC_cnt=VBC_cnt-1;
        $fclose(outfile);
      end
      if((VBC > 0.1) &&  (VBC_retc!=1))
      begin
        outfile=$fopen(errFileName,"a");
        $strobe("qnvha         VBC     leaving   OCA ( 0.100 V ..  ) at %7.4r  %M", $abstime );
        $fwrite(outfile,"qnvha         VBC     leaving   OCA ( 0.100 V ..  ) at %7.4r  %M\n", $abstime );
        VBC_retc=1;
        VBC_cnt=VBC_cnt-1;
        $fclose(outfile);
      end
   end
   else
   begin
      if(VBC_cnt==0)
      begin
        outfile=$fopen(errFileName,"a");
        $strobe("qnvha         VBC     error limit ( %d ) reached at %7.4r  %M", maxEv, $abstime );
        $fwrite(outfile,"qnvha         VBC     error limit ( %d ) reached at %7.4r  %M\n", maxEv, $abstime );
        VBC_cnt=VBC_cnt-1;
        $fclose(outfile);
      end
   end

//      PMax
   PMax = max(I_C * V_C_E - 2 * le / 1000 , 0) ;
   if((PMax_cnt>0) || ( maxEv_flg==0 ))   begin
      if( (PMax < -0.0001) && (PMax_retc!=-1))
      begin
        outfile=$fopen(errFileName,"a");
        $strobe("qnvha         PMax    leaving   OCA (  .. -0.100 mW ) at %7.4r  %M", $abstime );
        $fwrite(outfile,"qnvha         PMax    leaving   OCA (  .. -0.100 mW ) at %7.4r  %M\n", $abstime );
        PMax_retc=-1;
        PMax_cnt=PMax_cnt-1;
        $fclose(outfile);
      end
      if((PMax >= -0.0001) &&  (PMax <= 0.03) && (PMax_retc!=0))
      begin
        outfile=$fopen(errFileName,"a");
        $strobe("qnvha         PMax    entering SOCA ( -0.100 mW .. 30.000 mW ) at %7.4r  %M", $abstime );
        $fwrite(outfile,"qnvha         PMax    entering SOCA ( -0.100 mW .. 30.000 mW ) at %7.4r  %M\n", $abstime );
        PMax_retc=0;
        PMax_cnt=PMax_cnt-1;
        $fclose(outfile);
      end
      if((PMax > 0.03) &&  (PMax_retc!=1))
      begin
        outfile=$fopen(errFileName,"a");
        $strobe("qnvha         PMax    leaving   OCA ( 30.000 mW ..  ) at %7.4r  %M", $abstime );
        $fwrite(outfile,"qnvha         PMax    leaving   OCA ( 30.000 mW ..  ) at %7.4r  %M\n", $abstime );
        PMax_retc=1;
        PMax_cnt=PMax_cnt-1;
        $fclose(outfile);
      end
   end
   else
   begin
      if(PMax_cnt==0)
      begin
        outfile=$fopen(errFileName,"a");
        $strobe("qnvha         PMax    error limit ( %d ) reached at %7.4r  %M", maxEv, $abstime );
        $fwrite(outfile,"qnvha         PMax    error limit ( %d ) reached at %7.4r  %M\n", maxEv, $abstime );
        PMax_cnt=PMax_cnt-1;
        $fclose(outfile);
      end
   end

end // analog
endmodule // qnvha

// Verilog-A OC Watch for device qpvha Parameters  VCE VEB VBC PMax
module qpvha_ahdl(C1,B1,E1,C,B,E);
parameter tstep_occ=100n;
parameter errFileName="./occ.err";
parameter le = 1u;
parameter maxEv = 25;
parameter maxEv_flg = 0;
inout C1,B1,E1,C,B,E;
electrical C1,B1,E1,C,B,E;

integer outfile;
real V_B_C;
real V_E_B;
real V_C_E;
real I_E;
real I_B;
real I_C;
real VCE;
integer VCE_retc;
integer VCE_cnt;
real VEB;
integer VEB_retc;
integer VEB_cnt;
real VBC;
integer VBC_retc;
integer VBC_cnt;
real PMax;
integer PMax_retc;
integer PMax_cnt;

analog begin
   $bound_step( tstep_occ );
   @(initial_step) begin
      VCE_retc=0;
      VCE_cnt = maxEv;
      VEB_retc=0;
      VEB_cnt = maxEv;
      VBC_retc=0;
      VBC_cnt = maxEv;
      PMax_retc=0;
      PMax_cnt = maxEv;
   end
   V_B_C = V(B,C);
   V_E_B = V(E,B);
   V_C_E = V(C,E);
   I_E = I(E1,E);
   I_B = I(B1,B);
   I_C = I(C1,C);

//      VCE
   VCE = V_C_E;
   if((VCE_cnt>0) || ( maxEv_flg==0 ))   begin
      if( (VCE < -25) && (VCE_retc!=-1))
      begin
        outfile=$fopen(errFileName,"a");
        $strobe("qpvha         VCE     leaving   OCA (  .. -25.000 V ) at %7.4r  %M", $abstime );
        $fwrite(outfile,"qpvha         VCE     leaving   OCA (  .. -25.000 V ) at %7.4r  %M\n", $abstime );
        VCE_retc=-1;
        VCE_cnt=VCE_cnt-1;
        $fclose(outfile);
      end
      if((VCE >= -25) &&  (VCE <= 5.5) && (VCE_retc!=0))
      begin
        outfile=$fopen(errFileName,"a");
        $strobe("qpvha         VCE     entering SOCA ( -25.000 V .. 5.500 V ) at %7.4r  %M", $abstime );
        $fwrite(outfile,"qpvha         VCE     entering SOCA ( -25.000 V .. 5.500 V ) at %7.4r  %M\n", $abstime );
        VCE_retc=0;
        VCE_cnt=VCE_cnt-1;
        $fclose(outfile);
      end
      if((VCE > 5.5) &&  (VCE_retc!=1))
      begin
        outfile=$fopen(errFileName,"a");
        $strobe("qpvha         VCE     leaving   OCA ( 5.500 V ..  ) at %7.4r  %M", $abstime );
        $fwrite(outfile,"qpvha         VCE     leaving   OCA ( 5.500 V ..  ) at %7.4r  %M\n", $abstime );
        VCE_retc=1;
        VCE_cnt=VCE_cnt-1;
        $fclose(outfile);
      end
   end
   else
   begin
      if(VCE_cnt==0)
      begin
        outfile=$fopen(errFileName,"a");
        $strobe("qpvha         VCE     error limit ( %d ) reached at %7.4r  %M", maxEv, $abstime );
        $fwrite(outfile,"qpvha         VCE     error limit ( %d ) reached at %7.4r  %M\n", maxEv, $abstime );
        VCE_cnt=VCE_cnt-1;
        $fclose(outfile);
      end
   end

//      VEB
   VEB = V_E_B;
   if((VEB_cnt>0) || ( maxEv_flg==0 ))   begin
      if( (VEB < -5.5) && (VEB_retc!=-1))
      begin
        outfile=$fopen(errFileName,"a");
        $strobe("qpvha         VEB     leaving   OCA (  .. -5.500 V ) at %7.4r  %M", $abstime );
        $fwrite(outfile,"qpvha         VEB     leaving   OCA (  .. -5.500 V ) at %7.4r  %M\n", $abstime );
        VEB_retc=-1;
        VEB_cnt=VEB_cnt-1;
        $fclose(outfile);
      end
      if((VEB >= -5.5) &&  (VEB <= 1.5) && (VEB_retc!=0))
      begin
        outfile=$fopen(errFileName,"a");
        $strobe("qpvha         VEB     entering SOCA ( -5.500 V .. 1.500 V ) at %7.4r  %M", $abstime );
        $fwrite(outfile,"qpvha         VEB     entering SOCA ( -5.500 V .. 1.500 V ) at %7.4r  %M\n", $abstime );
        VEB_retc=0;
        VEB_cnt=VEB_cnt-1;
        $fclose(outfile);
      end
      if((VEB > 1.5) &&  (VEB_retc!=1))
      begin
        outfile=$fopen(errFileName,"a");
        $strobe("qpvha         VEB     leaving   OCA ( 1.500 V ..  ) at %7.4r  %M", $abstime );
        $fwrite(outfile,"qpvha         VEB     leaving   OCA ( 1.500 V ..  ) at %7.4r  %M\n", $abstime );
        VEB_retc=1;
        VEB_cnt=VEB_cnt-1;
        $fclose(outfile);
      end
   end
   else
   begin
      if(VEB_cnt==0)
      begin
        outfile=$fopen(errFileName,"a");
        $strobe("qpvha         VEB     error limit ( %d ) reached at %7.4r  %M", maxEv, $abstime );
        $fwrite(outfile,"qpvha         VEB     error limit ( %d ) reached at %7.4r  %M\n", maxEv, $abstime );
        VEB_cnt=VEB_cnt-1;
        $fclose(outfile);
      end
   end

//      VBC
   VBC = V_B_C;
   if((VBC_cnt>0) || ( maxEv_flg==0 ))   begin
      if( (VBC < -0.1) && (VBC_retc!=-1))
      begin
        outfile=$fopen(errFileName,"a");
        $strobe("qpvha         VBC     leaving   OCA (  .. -0.100 V ) at %7.4r  %M", $abstime );
        $fwrite(outfile,"qpvha         VBC     leaving   OCA (  .. -0.100 V ) at %7.4r  %M\n", $abstime );
        VBC_retc=-1;
        VBC_cnt=VBC_cnt-1;
        $fclose(outfile);
      end
      if((VBC >= -0.1) &&  (VBC <= 25) && (VBC_retc!=0))
      begin
        outfile=$fopen(errFileName,"a");
        $strobe("qpvha         VBC     entering SOCA ( -0.100 V .. 25.000 V ) at %7.4r  %M", $abstime );
        $fwrite(outfile,"qpvha         VBC     entering SOCA ( -0.100 V .. 25.000 V ) at %7.4r  %M\n", $abstime );
        VBC_retc=0;
        VBC_cnt=VBC_cnt-1;
        $fclose(outfile);
      end
      if((VBC > 25) &&  (VBC_retc!=1))
      begin
        outfile=$fopen(errFileName,"a");
        $strobe("qpvha         VBC     leaving   OCA ( 25.000 V ..  ) at %7.4r  %M", $abstime );
        $fwrite(outfile,"qpvha         VBC     leaving   OCA ( 25.000 V ..  ) at %7.4r  %M\n", $abstime );
        VBC_retc=1;
        VBC_cnt=VBC_cnt-1;
        $fclose(outfile);
      end
   end
   else
   begin
      if(VBC_cnt==0)
      begin
        outfile=$fopen(errFileName,"a");
        $strobe("qpvha         VBC     error limit ( %d ) reached at %7.4r  %M", maxEv, $abstime );
        $fwrite(outfile,"qpvha         VBC     error limit ( %d ) reached at %7.4r  %M\n", maxEv, $abstime );
        VBC_cnt=VBC_cnt-1;
        $fclose(outfile);
      end
   end

//      PMax
   PMax = max(I_C * V_C_E - 2 * le / 1000 , 0) ;
   if((PMax_cnt>0) || ( maxEv_flg==0 ))   begin
      if( (PMax < -0.0001) && (PMax_retc!=-1))
      begin
        outfile=$fopen(errFileName,"a");
        $strobe("qpvha         PMax    leaving   OCA (  .. -0.100 mW ) at %7.4r  %M", $abstime );
        $fwrite(outfile,"qpvha         PMax    leaving   OCA (  .. -0.100 mW ) at %7.4r  %M\n", $abstime );
        PMax_retc=-1;
        PMax_cnt=PMax_cnt-1;
        $fclose(outfile);
      end
      if((PMax >= -0.0001) &&  (PMax <= 0.03) && (PMax_retc!=0))
      begin
        outfile=$fopen(errFileName,"a");
        $strobe("qpvha         PMax    entering SOCA ( -0.100 mW .. 30.000 mW ) at %7.4r  %M", $abstime );
        $fwrite(outfile,"qpvha         PMax    entering SOCA ( -0.100 mW .. 30.000 mW ) at %7.4r  %M\n", $abstime );
        PMax_retc=0;
        PMax_cnt=PMax_cnt-1;
        $fclose(outfile);
      end
      if((PMax > 0.03) &&  (PMax_retc!=1))
      begin
        outfile=$fopen(errFileName,"a");
        $strobe("qpvha         PMax    leaving   OCA ( 30.000 mW ..  ) at %7.4r  %M", $abstime );
        $fwrite(outfile,"qpvha         PMax    leaving   OCA ( 30.000 mW ..  ) at %7.4r  %M\n", $abstime );
        PMax_retc=1;
        PMax_cnt=PMax_cnt-1;
        $fclose(outfile);
      end
   end
   else
   begin
      if(PMax_cnt==0)
      begin
        outfile=$fopen(errFileName,"a");
        $strobe("qpvha         PMax    error limit ( %d ) reached at %7.4r  %M", maxEv, $abstime );
        $fwrite(outfile,"qpvha         PMax    error limit ( %d ) reached at %7.4r  %M\n", maxEv, $abstime );
        PMax_cnt=PMax_cnt-1;
        $fclose(outfile);
      end
   end

end // analog
endmodule // qpvha

// Verilog-A OC Watch for device rdn Parameters  VAS VBS
module rdn_ahdl(A,B,S);
parameter tstep_occ=100n;
parameter errFileName="./occ.err";
parameter maxEv = 25;
parameter maxEv_flg = 0;
inout A,B,S;
electrical A,B,S;

integer outfile;
real V_B_S;
real V_A_S;
real VAS;
integer VAS_retc;
integer VAS_cnt;
real VBS;
integer VBS_retc;
integer VBS_cnt;

analog begin
   $bound_step( tstep_occ );
   @(initial_step) begin
      VAS_retc=0;
      VAS_cnt = maxEv;
      VBS_retc=0;
      VBS_cnt = maxEv;
   end
   V_B_S = V(B,S);
   V_A_S = V(A,S);

//      VAS
   VAS = V_A_S;
   if((VAS_cnt>0) || ( maxEv_flg==0 ))   begin
      if( (VAS < -0.1) && (VAS_retc!=-1))
      begin
        outfile=$fopen(errFileName,"a");
        $strobe("rdn           VAS     leaving   OCA (  .. -0.100 V ) at %7.4r  %M", $abstime );
        $fwrite(outfile,"rdn           VAS     leaving   OCA (  .. -0.100 V ) at %7.4r  %M\n", $abstime );
        VAS_retc=-1;
        VAS_cnt=VAS_cnt-1;
        $fclose(outfile);
      end
      if((VAS >= -0.1) &&  (VAS <= 1.98) && (VAS_retc!=0))
      begin
        outfile=$fopen(errFileName,"a");
        $strobe("rdn           VAS     entering SOCA ( -0.100 V .. 1.980 V ) at %7.4r  %M", $abstime );
        $fwrite(outfile,"rdn           VAS     entering SOCA ( -0.100 V .. 1.980 V ) at %7.4r  %M\n", $abstime );
        VAS_retc=0;
        VAS_cnt=VAS_cnt-1;
        $fclose(outfile);
      end
      if((VAS > 1.98) &&  (VAS_retc!=1))
      begin
        outfile=$fopen(errFileName,"a");
        $strobe("rdn           VAS     leaving   OCA ( 1.980 V ..  ) at %7.4r  %M", $abstime );
        $fwrite(outfile,"rdn           VAS     leaving   OCA ( 1.980 V ..  ) at %7.4r  %M\n", $abstime );
        VAS_retc=1;
        VAS_cnt=VAS_cnt-1;
        $fclose(outfile);
      end
   end
   else
   begin
      if(VAS_cnt==0)
      begin
        outfile=$fopen(errFileName,"a");
        $strobe("rdn           VAS     error limit ( %d ) reached at %7.4r  %M", maxEv, $abstime );
        $fwrite(outfile,"rdn           VAS     error limit ( %d ) reached at %7.4r  %M\n", maxEv, $abstime );
        VAS_cnt=VAS_cnt-1;
        $fclose(outfile);
      end
   end

//      VBS
   VBS = V_B_S;
   if((VBS_cnt>0) || ( maxEv_flg==0 ))   begin
      if( (VBS < -0.1) && (VBS_retc!=-1))
      begin
        outfile=$fopen(errFileName,"a");
        $strobe("rdn           VBS     leaving   OCA (  .. -0.100 V ) at %7.4r  %M", $abstime );
        $fwrite(outfile,"rdn           VBS     leaving   OCA (  .. -0.100 V ) at %7.4r  %M\n", $abstime );
        VBS_retc=-1;
        VBS_cnt=VBS_cnt-1;
        $fclose(outfile);
      end
      if((VBS >= -0.1) &&  (VBS <= 1.98) && (VBS_retc!=0))
      begin
        outfile=$fopen(errFileName,"a");
        $strobe("rdn           VBS     entering SOCA ( -0.100 V .. 1.980 V ) at %7.4r  %M", $abstime );
        $fwrite(outfile,"rdn           VBS     entering SOCA ( -0.100 V .. 1.980 V ) at %7.4r  %M\n", $abstime );
        VBS_retc=0;
        VBS_cnt=VBS_cnt-1;
        $fclose(outfile);
      end
      if((VBS > 1.98) &&  (VBS_retc!=1))
      begin
        outfile=$fopen(errFileName,"a");
        $strobe("rdn           VBS     leaving   OCA ( 1.980 V ..  ) at %7.4r  %M", $abstime );
        $fwrite(outfile,"rdn           VBS     leaving   OCA ( 1.980 V ..  ) at %7.4r  %M\n", $abstime );
        VBS_retc=1;
        VBS_cnt=VBS_cnt-1;
        $fclose(outfile);
      end
   end
   else
   begin
      if(VBS_cnt==0)
      begin
        outfile=$fopen(errFileName,"a");
        $strobe("rdn           VBS     error limit ( %d ) reached at %7.4r  %M", maxEv, $abstime );
        $fwrite(outfile,"rdn           VBS     error limit ( %d ) reached at %7.4r  %M\n", maxEv, $abstime );
        VBS_cnt=VBS_cnt-1;
        $fclose(outfile);
      end
   end

end // analog
endmodule // rdn

// Verilog-A OC Watch for device rdn5 Parameters  VAS VBS
module rdn5_ahdl(A,B,S);
parameter tstep_occ=100n;
parameter errFileName="./occ.err";
parameter maxEv = 25;
parameter maxEv_flg = 0;
inout A,B,S;
electrical A,B,S;

integer outfile;
real V_B_S;
real V_A_S;
real VAS;
integer VAS_retc;
integer VAS_cnt;
real VBS;
integer VBS_retc;
integer VBS_cnt;

analog begin
   $bound_step( tstep_occ );
   @(initial_step) begin
      VAS_retc=0;
      VAS_cnt = maxEv;
      VBS_retc=0;
      VBS_cnt = maxEv;
   end
   V_B_S = V(B,S);
   V_A_S = V(A,S);

//      VAS
   VAS = V_A_S;
   if((VAS_cnt>0) || ( maxEv_flg==0 ))   begin
      if( (VAS < -0.1) && (VAS_retc!=-1))
      begin
        outfile=$fopen(errFileName,"a");
        $strobe("rdn5          VAS     leaving   OCA (  .. -0.100 V ) at %7.4r  %M", $abstime );
        $fwrite(outfile,"rdn5          VAS     leaving   OCA (  .. -0.100 V ) at %7.4r  %M\n", $abstime );
        VAS_retc=-1;
        VAS_cnt=VAS_cnt-1;
        $fclose(outfile);
      end
      if((VAS >= -0.1) &&  (VAS <= 5.5) && (VAS_retc!=0))
      begin
        outfile=$fopen(errFileName,"a");
        $strobe("rdn5          VAS     entering SOCA ( -0.100 V .. 5.500 V ) at %7.4r  %M", $abstime );
        $fwrite(outfile,"rdn5          VAS     entering SOCA ( -0.100 V .. 5.500 V ) at %7.4r  %M\n", $abstime );
        VAS_retc=0;
        VAS_cnt=VAS_cnt-1;
        $fclose(outfile);
      end
      if((VAS > 5.5) &&  (VAS_retc!=1))
      begin
        outfile=$fopen(errFileName,"a");
        $strobe("rdn5          VAS     leaving   OCA ( 5.500 V ..  ) at %7.4r  %M", $abstime );
        $fwrite(outfile,"rdn5          VAS     leaving   OCA ( 5.500 V ..  ) at %7.4r  %M\n", $abstime );
        VAS_retc=1;
        VAS_cnt=VAS_cnt-1;
        $fclose(outfile);
      end
   end
   else
   begin
      if(VAS_cnt==0)
      begin
        outfile=$fopen(errFileName,"a");
        $strobe("rdn5          VAS     error limit ( %d ) reached at %7.4r  %M", maxEv, $abstime );
        $fwrite(outfile,"rdn5          VAS     error limit ( %d ) reached at %7.4r  %M\n", maxEv, $abstime );
        VAS_cnt=VAS_cnt-1;
        $fclose(outfile);
      end
   end

//      VBS
   VBS = V_B_S;
   if((VBS_cnt>0) || ( maxEv_flg==0 ))   begin
      if( (VBS < -0.1) && (VBS_retc!=-1))
      begin
        outfile=$fopen(errFileName,"a");
        $strobe("rdn5          VBS     leaving   OCA (  .. -0.100 V ) at %7.4r  %M", $abstime );
        $fwrite(outfile,"rdn5          VBS     leaving   OCA (  .. -0.100 V ) at %7.4r  %M\n", $abstime );
        VBS_retc=-1;
        VBS_cnt=VBS_cnt-1;
        $fclose(outfile);
      end
      if((VBS >= -0.1) &&  (VBS <= 5.5) && (VBS_retc!=0))
      begin
        outfile=$fopen(errFileName,"a");
        $strobe("rdn5          VBS     entering SOCA ( -0.100 V .. 5.500 V ) at %7.4r  %M", $abstime );
        $fwrite(outfile,"rdn5          VBS     entering SOCA ( -0.100 V .. 5.500 V ) at %7.4r  %M\n", $abstime );
        VBS_retc=0;
        VBS_cnt=VBS_cnt-1;
        $fclose(outfile);
      end
      if((VBS > 5.5) &&  (VBS_retc!=1))
      begin
        outfile=$fopen(errFileName,"a");
        $strobe("rdn5          VBS     leaving   OCA ( 5.500 V ..  ) at %7.4r  %M", $abstime );
        $fwrite(outfile,"rdn5          VBS     leaving   OCA ( 5.500 V ..  ) at %7.4r  %M\n", $abstime );
        VBS_retc=1;
        VBS_cnt=VBS_cnt-1;
        $fclose(outfile);
      end
   end
   else
   begin
      if(VBS_cnt==0)
      begin
        outfile=$fopen(errFileName,"a");
        $strobe("rdn5          VBS     error limit ( %d ) reached at %7.4r  %M", maxEv, $abstime );
        $fwrite(outfile,"rdn5          VBS     error limit ( %d ) reached at %7.4r  %M\n", maxEv, $abstime );
        VBS_cnt=VBS_cnt-1;
        $fclose(outfile);
      end
   end

end // analog
endmodule // rdn5

// Verilog-A OC Watch for device rdp Parameters  VAS VBS
module rdp_ahdl(A,B,S);
parameter tstep_occ=100n;
parameter errFileName="./occ.err";
parameter maxEv = 25;
parameter maxEv_flg = 0;
inout A,B,S;
electrical A,B,S;

integer outfile;
real V_B_S;
real V_A_S;
real VAS;
integer VAS_retc;
integer VAS_cnt;
real VBS;
integer VBS_retc;
integer VBS_cnt;

analog begin
   $bound_step( tstep_occ );
   @(initial_step) begin
      VAS_retc=0;
      VAS_cnt = maxEv;
      VBS_retc=0;
      VBS_cnt = maxEv;
   end
   V_B_S = V(B,S);
   V_A_S = V(A,S);

//      VAS
   VAS = V_A_S;
   if((VAS_cnt>0) || ( maxEv_flg==0 ))   begin
      if( (VAS < -1.98) && (VAS_retc!=-1))
      begin
        outfile=$fopen(errFileName,"a");
        $strobe("rdp           VAS     leaving   OCA (  .. -1.980 V ) at %7.4r  %M", $abstime );
        $fwrite(outfile,"rdp           VAS     leaving   OCA (  .. -1.980 V ) at %7.4r  %M\n", $abstime );
        VAS_retc=-1;
        VAS_cnt=VAS_cnt-1;
        $fclose(outfile);
      end
      if((VAS >= -1.98) &&  (VAS <= 0.1) && (VAS_retc!=0))
      begin
        outfile=$fopen(errFileName,"a");
        $strobe("rdp           VAS     entering SOCA ( -1.980 V .. 0.100 V ) at %7.4r  %M", $abstime );
        $fwrite(outfile,"rdp           VAS     entering SOCA ( -1.980 V .. 0.100 V ) at %7.4r  %M\n", $abstime );
        VAS_retc=0;
        VAS_cnt=VAS_cnt-1;
        $fclose(outfile);
      end
      if((VAS > 0.1) &&  (VAS_retc!=1))
      begin
        outfile=$fopen(errFileName,"a");
        $strobe("rdp           VAS     leaving   OCA ( 0.100 V ..  ) at %7.4r  %M", $abstime );
        $fwrite(outfile,"rdp           VAS     leaving   OCA ( 0.100 V ..  ) at %7.4r  %M\n", $abstime );
        VAS_retc=1;
        VAS_cnt=VAS_cnt-1;
        $fclose(outfile);
      end
   end
   else
   begin
      if(VAS_cnt==0)
      begin
        outfile=$fopen(errFileName,"a");
        $strobe("rdp           VAS     error limit ( %d ) reached at %7.4r  %M", maxEv, $abstime );
        $fwrite(outfile,"rdp           VAS     error limit ( %d ) reached at %7.4r  %M\n", maxEv, $abstime );
        VAS_cnt=VAS_cnt-1;
        $fclose(outfile);
      end
   end

//      VBS
   VBS = V_B_S;
   if((VBS_cnt>0) || ( maxEv_flg==0 ))   begin
      if( (VBS < -1.98) && (VBS_retc!=-1))
      begin
        outfile=$fopen(errFileName,"a");
        $strobe("rdp           VBS     leaving   OCA (  .. -1.980 V ) at %7.4r  %M", $abstime );
        $fwrite(outfile,"rdp           VBS     leaving   OCA (  .. -1.980 V ) at %7.4r  %M\n", $abstime );
        VBS_retc=-1;
        VBS_cnt=VBS_cnt-1;
        $fclose(outfile);
      end
      if((VBS >= -1.98) &&  (VBS <= 0.1) && (VBS_retc!=0))
      begin
        outfile=$fopen(errFileName,"a");
        $strobe("rdp           VBS     entering SOCA ( -1.980 V .. 0.100 V ) at %7.4r  %M", $abstime );
        $fwrite(outfile,"rdp           VBS     entering SOCA ( -1.980 V .. 0.100 V ) at %7.4r  %M\n", $abstime );
        VBS_retc=0;
        VBS_cnt=VBS_cnt-1;
        $fclose(outfile);
      end
      if((VBS > 0.1) &&  (VBS_retc!=1))
      begin
        outfile=$fopen(errFileName,"a");
        $strobe("rdp           VBS     leaving   OCA ( 0.100 V ..  ) at %7.4r  %M", $abstime );
        $fwrite(outfile,"rdp           VBS     leaving   OCA ( 0.100 V ..  ) at %7.4r  %M\n", $abstime );
        VBS_retc=1;
        VBS_cnt=VBS_cnt-1;
        $fclose(outfile);
      end
   end
   else
   begin
      if(VBS_cnt==0)
      begin
        outfile=$fopen(errFileName,"a");
        $strobe("rdp           VBS     error limit ( %d ) reached at %7.4r  %M", maxEv, $abstime );
        $fwrite(outfile,"rdp           VBS     error limit ( %d ) reached at %7.4r  %M\n", maxEv, $abstime );
        VBS_cnt=VBS_cnt-1;
        $fclose(outfile);
      end
   end

end // analog
endmodule // rdp

// Verilog-A OC Watch for device rdp5 Parameters  VAS VBS
module rdp5_ahdl(A,B,S);
parameter tstep_occ=100n;
parameter errFileName="./occ.err";
parameter maxEv = 25;
parameter maxEv_flg = 0;
inout A,B,S;
electrical A,B,S;

integer outfile;
real V_B_S;
real V_A_S;
real VAS;
integer VAS_retc;
integer VAS_cnt;
real VBS;
integer VBS_retc;
integer VBS_cnt;

analog begin
   $bound_step( tstep_occ );
   @(initial_step) begin
      VAS_retc=0;
      VAS_cnt = maxEv;
      VBS_retc=0;
      VBS_cnt = maxEv;
   end
   V_B_S = V(B,S);
   V_A_S = V(A,S);

//      VAS
   VAS = V_A_S;
   if((VAS_cnt>0) || ( maxEv_flg==0 ))   begin
      if( (VAS < -5.5) && (VAS_retc!=-1))
      begin
        outfile=$fopen(errFileName,"a");
        $strobe("rdp5          VAS     leaving   OCA (  .. -5.500 V ) at %7.4r  %M", $abstime );
        $fwrite(outfile,"rdp5          VAS     leaving   OCA (  .. -5.500 V ) at %7.4r  %M\n", $abstime );
        VAS_retc=-1;
        VAS_cnt=VAS_cnt-1;
        $fclose(outfile);
      end
      if((VAS >= -5.5) &&  (VAS <= 0.1) && (VAS_retc!=0))
      begin
        outfile=$fopen(errFileName,"a");
        $strobe("rdp5          VAS     entering SOCA ( -5.500 V .. 0.100 V ) at %7.4r  %M", $abstime );
        $fwrite(outfile,"rdp5          VAS     entering SOCA ( -5.500 V .. 0.100 V ) at %7.4r  %M\n", $abstime );
        VAS_retc=0;
        VAS_cnt=VAS_cnt-1;
        $fclose(outfile);
      end
      if((VAS > 0.1) &&  (VAS_retc!=1))
      begin
        outfile=$fopen(errFileName,"a");
        $strobe("rdp5          VAS     leaving   OCA ( 0.100 V ..  ) at %7.4r  %M", $abstime );
        $fwrite(outfile,"rdp5          VAS     leaving   OCA ( 0.100 V ..  ) at %7.4r  %M\n", $abstime );
        VAS_retc=1;
        VAS_cnt=VAS_cnt-1;
        $fclose(outfile);
      end
   end
   else
   begin
      if(VAS_cnt==0)
      begin
        outfile=$fopen(errFileName,"a");
        $strobe("rdp5          VAS     error limit ( %d ) reached at %7.4r  %M", maxEv, $abstime );
        $fwrite(outfile,"rdp5          VAS     error limit ( %d ) reached at %7.4r  %M\n", maxEv, $abstime );
        VAS_cnt=VAS_cnt-1;
        $fclose(outfile);
      end
   end

//      VBS
   VBS = V_B_S;
   if((VBS_cnt>0) || ( maxEv_flg==0 ))   begin
      if( (VBS < -5.5) && (VBS_retc!=-1))
      begin
        outfile=$fopen(errFileName,"a");
        $strobe("rdp5          VBS     leaving   OCA (  .. -5.500 V ) at %7.4r  %M", $abstime );
        $fwrite(outfile,"rdp5          VBS     leaving   OCA (  .. -5.500 V ) at %7.4r  %M\n", $abstime );
        VBS_retc=-1;
        VBS_cnt=VBS_cnt-1;
        $fclose(outfile);
      end
      if((VBS >= -5.5) &&  (VBS <= 0.1) && (VBS_retc!=0))
      begin
        outfile=$fopen(errFileName,"a");
        $strobe("rdp5          VBS     entering SOCA ( -5.500 V .. 0.100 V ) at %7.4r  %M", $abstime );
        $fwrite(outfile,"rdp5          VBS     entering SOCA ( -5.500 V .. 0.100 V ) at %7.4r  %M\n", $abstime );
        VBS_retc=0;
        VBS_cnt=VBS_cnt-1;
        $fclose(outfile);
      end
      if((VBS > 0.1) &&  (VBS_retc!=1))
      begin
        outfile=$fopen(errFileName,"a");
        $strobe("rdp5          VBS     leaving   OCA ( 0.100 V ..  ) at %7.4r  %M", $abstime );
        $fwrite(outfile,"rdp5          VBS     leaving   OCA ( 0.100 V ..  ) at %7.4r  %M\n", $abstime );
        VBS_retc=1;
        VBS_cnt=VBS_cnt-1;
        $fclose(outfile);
      end
   end
   else
   begin
      if(VBS_cnt==0)
      begin
        outfile=$fopen(errFileName,"a");
        $strobe("rdp5          VBS     error limit ( %d ) reached at %7.4r  %M", maxEv, $abstime );
        $fwrite(outfile,"rdp5          VBS     error limit ( %d ) reached at %7.4r  %M\n", maxEv, $abstime );
        VBS_cnt=VBS_cnt-1;
        $fclose(outfile);
      end
   end

end // analog
endmodule // rdp5

// Verilog-A OC Watch for device rnw Parameters  VAS VBS
module rnw_ahdl(A,B,S);
parameter tstep_occ=100n;
parameter errFileName="./occ.err";
parameter maxEv = 25;
parameter maxEv_flg = 0;
inout A,B,S;
electrical A,B,S;

integer outfile;
real V_B_S;
real V_A_S;
real VAS;
integer VAS_retc;
integer VAS_cnt;
real VBS;
integer VBS_retc;
integer VBS_cnt;

analog begin
   $bound_step( tstep_occ );
   @(initial_step) begin
      VAS_retc=0;
      VAS_cnt = maxEv;
      VBS_retc=0;
      VBS_cnt = maxEv;
   end
   V_B_S = V(B,S);
   V_A_S = V(A,S);

//      VAS
   VAS = V_A_S;
   if((VAS_cnt>0) || ( maxEv_flg==0 ))   begin
      if( (VAS < -0.1) && (VAS_retc!=-1))
      begin
        outfile=$fopen(errFileName,"a");
        $strobe("rnw           VAS     leaving   OCA (  .. -0.100 V ) at %7.4r  %M", $abstime );
        $fwrite(outfile,"rnw           VAS     leaving   OCA (  .. -0.100 V ) at %7.4r  %M\n", $abstime );
        VAS_retc=-1;
        VAS_cnt=VAS_cnt-1;
        $fclose(outfile);
      end
      if((VAS >= -0.1) &&  (VAS <= 5.5) && (VAS_retc!=0))
      begin
        outfile=$fopen(errFileName,"a");
        $strobe("rnw           VAS     entering SOCA ( -0.100 V .. 5.500 V ) at %7.4r  %M", $abstime );
        $fwrite(outfile,"rnw           VAS     entering SOCA ( -0.100 V .. 5.500 V ) at %7.4r  %M\n", $abstime );
        VAS_retc=0;
        VAS_cnt=VAS_cnt-1;
        $fclose(outfile);
      end
      if((VAS > 5.5) &&  (VAS_retc!=1))
      begin
        outfile=$fopen(errFileName,"a");
        $strobe("rnw           VAS     leaving   OCA ( 5.500 V ..  ) at %7.4r  %M", $abstime );
        $fwrite(outfile,"rnw           VAS     leaving   OCA ( 5.500 V ..  ) at %7.4r  %M\n", $abstime );
        VAS_retc=1;
        VAS_cnt=VAS_cnt-1;
        $fclose(outfile);
      end
   end
   else
   begin
      if(VAS_cnt==0)
      begin
        outfile=$fopen(errFileName,"a");
        $strobe("rnw           VAS     error limit ( %d ) reached at %7.4r  %M", maxEv, $abstime );
        $fwrite(outfile,"rnw           VAS     error limit ( %d ) reached at %7.4r  %M\n", maxEv, $abstime );
        VAS_cnt=VAS_cnt-1;
        $fclose(outfile);
      end
   end

//      VBS
   VBS = V_B_S;
   if((VBS_cnt>0) || ( maxEv_flg==0 ))   begin
      if( (VBS < -0.1) && (VBS_retc!=-1))
      begin
        outfile=$fopen(errFileName,"a");
        $strobe("rnw           VBS     leaving   OCA (  .. -0.100 V ) at %7.4r  %M", $abstime );
        $fwrite(outfile,"rnw           VBS     leaving   OCA (  .. -0.100 V ) at %7.4r  %M\n", $abstime );
        VBS_retc=-1;
        VBS_cnt=VBS_cnt-1;
        $fclose(outfile);
      end
      if((VBS >= -0.1) &&  (VBS <= 5.5) && (VBS_retc!=0))
      begin
        outfile=$fopen(errFileName,"a");
        $strobe("rnw           VBS     entering SOCA ( -0.100 V .. 5.500 V ) at %7.4r  %M", $abstime );
        $fwrite(outfile,"rnw           VBS     entering SOCA ( -0.100 V .. 5.500 V ) at %7.4r  %M\n", $abstime );
        VBS_retc=0;
        VBS_cnt=VBS_cnt-1;
        $fclose(outfile);
      end
      if((VBS > 5.5) &&  (VBS_retc!=1))
      begin
        outfile=$fopen(errFileName,"a");
        $strobe("rnw           VBS     leaving   OCA ( 5.500 V ..  ) at %7.4r  %M", $abstime );
        $fwrite(outfile,"rnw           VBS     leaving   OCA ( 5.500 V ..  ) at %7.4r  %M\n", $abstime );
        VBS_retc=1;
        VBS_cnt=VBS_cnt-1;
        $fclose(outfile);
      end
   end
   else
   begin
      if(VBS_cnt==0)
      begin
        outfile=$fopen(errFileName,"a");
        $strobe("rnw           VBS     error limit ( %d ) reached at %7.4r  %M", maxEv, $abstime );
        $fwrite(outfile,"rnw           VBS     error limit ( %d ) reached at %7.4r  %M\n", maxEv, $abstime );
        VBS_cnt=VBS_cnt-1;
        $fclose(outfile);
      end
   end

end // analog
endmodule // rnw

// Verilog-A OC Watch for device rnw5 Parameters  VAS VBS
module rnw5_ahdl(A,B,S);
parameter tstep_occ=100n;
parameter errFileName="./occ.err";
parameter maxEv = 25;
parameter maxEv_flg = 0;
inout A,B,S;
electrical A,B,S;

integer outfile;
real V_B_S;
real V_A_S;
real VAS;
integer VAS_retc;
integer VAS_cnt;
real VBS;
integer VBS_retc;
integer VBS_cnt;

analog begin
   $bound_step( tstep_occ );
   @(initial_step) begin
      VAS_retc=0;
      VAS_cnt = maxEv;
      VBS_retc=0;
      VBS_cnt = maxEv;
   end
   V_B_S = V(B,S);
   V_A_S = V(A,S);

//      VAS
   VAS = V_A_S;
   if((VAS_cnt>0) || ( maxEv_flg==0 ))   begin
      if( (VAS < -0.1) && (VAS_retc!=-1))
      begin
        outfile=$fopen(errFileName,"a");
        $strobe("rnw5          VAS     leaving   OCA (  .. -0.100 V ) at %7.4r  %M", $abstime );
        $fwrite(outfile,"rnw5          VAS     leaving   OCA (  .. -0.100 V ) at %7.4r  %M\n", $abstime );
        VAS_retc=-1;
        VAS_cnt=VAS_cnt-1;
        $fclose(outfile);
      end
      if((VAS >= -0.1) &&  (VAS <= 5.5) && (VAS_retc!=0))
      begin
        outfile=$fopen(errFileName,"a");
        $strobe("rnw5          VAS     entering SOCA ( -0.100 V .. 5.500 V ) at %7.4r  %M", $abstime );
        $fwrite(outfile,"rnw5          VAS     entering SOCA ( -0.100 V .. 5.500 V ) at %7.4r  %M\n", $abstime );
        VAS_retc=0;
        VAS_cnt=VAS_cnt-1;
        $fclose(outfile);
      end
      if((VAS > 5.5) &&  (VAS_retc!=1))
      begin
        outfile=$fopen(errFileName,"a");
        $strobe("rnw5          VAS     leaving   OCA ( 5.500 V ..  ) at %7.4r  %M", $abstime );
        $fwrite(outfile,"rnw5          VAS     leaving   OCA ( 5.500 V ..  ) at %7.4r  %M\n", $abstime );
        VAS_retc=1;
        VAS_cnt=VAS_cnt-1;
        $fclose(outfile);
      end
   end
   else
   begin
      if(VAS_cnt==0)
      begin
        outfile=$fopen(errFileName,"a");
        $strobe("rnw5          VAS     error limit ( %d ) reached at %7.4r  %M", maxEv, $abstime );
        $fwrite(outfile,"rnw5          VAS     error limit ( %d ) reached at %7.4r  %M\n", maxEv, $abstime );
        VAS_cnt=VAS_cnt-1;
        $fclose(outfile);
      end
   end

//      VBS
   VBS = V_B_S;
   if((VBS_cnt>0) || ( maxEv_flg==0 ))   begin
      if( (VBS < -0.1) && (VBS_retc!=-1))
      begin
        outfile=$fopen(errFileName,"a");
        $strobe("rnw5          VBS     leaving   OCA (  .. -0.100 V ) at %7.4r  %M", $abstime );
        $fwrite(outfile,"rnw5          VBS     leaving   OCA (  .. -0.100 V ) at %7.4r  %M\n", $abstime );
        VBS_retc=-1;
        VBS_cnt=VBS_cnt-1;
        $fclose(outfile);
      end
      if((VBS >= -0.1) &&  (VBS <= 5.5) && (VBS_retc!=0))
      begin
        outfile=$fopen(errFileName,"a");
        $strobe("rnw5          VBS     entering SOCA ( -0.100 V .. 5.500 V ) at %7.4r  %M", $abstime );
        $fwrite(outfile,"rnw5          VBS     entering SOCA ( -0.100 V .. 5.500 V ) at %7.4r  %M\n", $abstime );
        VBS_retc=0;
        VBS_cnt=VBS_cnt-1;
        $fclose(outfile);
      end
      if((VBS > 5.5) &&  (VBS_retc!=1))
      begin
        outfile=$fopen(errFileName,"a");
        $strobe("rnw5          VBS     leaving   OCA ( 5.500 V ..  ) at %7.4r  %M", $abstime );
        $fwrite(outfile,"rnw5          VBS     leaving   OCA ( 5.500 V ..  ) at %7.4r  %M\n", $abstime );
        VBS_retc=1;
        VBS_cnt=VBS_cnt-1;
        $fclose(outfile);
      end
   end
   else
   begin
      if(VBS_cnt==0)
      begin
        outfile=$fopen(errFileName,"a");
        $strobe("rnw5          VBS     error limit ( %d ) reached at %7.4r  %M", maxEv, $abstime );
        $fwrite(outfile,"rnw5          VBS     error limit ( %d ) reached at %7.4r  %M\n", maxEv, $abstime );
        VBS_cnt=VBS_cnt-1;
        $fclose(outfile);
      end
   end

end // analog
endmodule // rnw5

// Verilog-A OC Watch for device rxw2ti Parameters  VAS VBS
module rxw2ti_ahdl(A,B,S);
parameter tstep_occ=100n;
parameter errFileName="./occ.err";
parameter maxEv = 25;
parameter maxEv_flg = 0;
inout A,B,S;
electrical A,B,S;

integer outfile;
real V_B_S;
real V_A_S;
real VAS;
integer VAS_retc;
integer VAS_cnt;
real VBS;
integer VBS_retc;
integer VBS_cnt;

analog begin
   $bound_step( tstep_occ );
   @(initial_step) begin
      VAS_retc=0;
      VAS_cnt = maxEv;
      VBS_retc=0;
      VBS_cnt = maxEv;
   end
   V_B_S = V(B,S);
   V_A_S = V(A,S);

//      VAS
   VAS = V_A_S;
   if((VAS_cnt>0) || ( maxEv_flg==0 ))   begin
      if( (VAS < -0.1) && (VAS_retc!=-1))
      begin
        outfile=$fopen(errFileName,"a");
        $strobe("rxw2ti        VAS     leaving   OCA (  .. -0.100 V ) at %7.4r  %M", $abstime );
        $fwrite(outfile,"rxw2ti        VAS     leaving   OCA (  .. -0.100 V ) at %7.4r  %M\n", $abstime );
        VAS_retc=-1;
        VAS_cnt=VAS_cnt-1;
        $fclose(outfile);
      end
      if((VAS >= -0.1) &&  (VAS <= 5.5) && (VAS_retc!=0))
      begin
        outfile=$fopen(errFileName,"a");
        $strobe("rxw2ti        VAS     entering SOCA ( -0.100 V .. 5.500 V ) at %7.4r  %M", $abstime );
        $fwrite(outfile,"rxw2ti        VAS     entering SOCA ( -0.100 V .. 5.500 V ) at %7.4r  %M\n", $abstime );
        VAS_retc=0;
        VAS_cnt=VAS_cnt-1;
        $fclose(outfile);
      end
      if((VAS > 5.5) &&  (VAS_retc!=1))
      begin
        outfile=$fopen(errFileName,"a");
        $strobe("rxw2ti        VAS     leaving   OCA ( 5.500 V ..  ) at %7.4r  %M", $abstime );
        $fwrite(outfile,"rxw2ti        VAS     leaving   OCA ( 5.500 V ..  ) at %7.4r  %M\n", $abstime );
        VAS_retc=1;
        VAS_cnt=VAS_cnt-1;
        $fclose(outfile);
      end
   end
   else
   begin
      if(VAS_cnt==0)
      begin
        outfile=$fopen(errFileName,"a");
        $strobe("rxw2ti        VAS     error limit ( %d ) reached at %7.4r  %M", maxEv, $abstime );
        $fwrite(outfile,"rxw2ti        VAS     error limit ( %d ) reached at %7.4r  %M\n", maxEv, $abstime );
        VAS_cnt=VAS_cnt-1;
        $fclose(outfile);
      end
   end

//      VBS
   VBS = V_B_S;
   if((VBS_cnt>0) || ( maxEv_flg==0 ))   begin
      if( (VBS < -0.1) && (VBS_retc!=-1))
      begin
        outfile=$fopen(errFileName,"a");
        $strobe("rxw2ti        VBS     leaving   OCA (  .. -0.100 V ) at %7.4r  %M", $abstime );
        $fwrite(outfile,"rxw2ti        VBS     leaving   OCA (  .. -0.100 V ) at %7.4r  %M\n", $abstime );
        VBS_retc=-1;
        VBS_cnt=VBS_cnt-1;
        $fclose(outfile);
      end
      if((VBS >= -0.1) &&  (VBS <= 5.5) && (VBS_retc!=0))
      begin
        outfile=$fopen(errFileName,"a");
        $strobe("rxw2ti        VBS     entering SOCA ( -0.100 V .. 5.500 V ) at %7.4r  %M", $abstime );
        $fwrite(outfile,"rxw2ti        VBS     entering SOCA ( -0.100 V .. 5.500 V ) at %7.4r  %M\n", $abstime );
        VBS_retc=0;
        VBS_cnt=VBS_cnt-1;
        $fclose(outfile);
      end
      if((VBS > 5.5) &&  (VBS_retc!=1))
      begin
        outfile=$fopen(errFileName,"a");
        $strobe("rxw2ti        VBS     leaving   OCA ( 5.500 V ..  ) at %7.4r  %M", $abstime );
        $fwrite(outfile,"rxw2ti        VBS     leaving   OCA ( 5.500 V ..  ) at %7.4r  %M\n", $abstime );
        VBS_retc=1;
        VBS_cnt=VBS_cnt-1;
        $fclose(outfile);
      end
   end
   else
   begin
      if(VBS_cnt==0)
      begin
        outfile=$fopen(errFileName,"a");
        $strobe("rxw2ti        VBS     error limit ( %d ) reached at %7.4r  %M", maxEv, $abstime );
        $fwrite(outfile,"rxw2ti        VBS     error limit ( %d ) reached at %7.4r  %M\n", maxEv, $abstime );
        VBS_cnt=VBS_cnt-1;
        $fclose(outfile);
      end
   end

end // analog
endmodule // rxw2ti

// Verilog-A OC Watch for device rm1 Parameters  VA VB JMax_AC JMax_DC
module rm1_ahdl(A1,B1,A,B);
parameter tstep_occ=100n;
parameter errFileName="./occ.err";
parameter w = 1u;
parameter maxEv = 25;
parameter maxEv_flg = 0;
inout A1,B1,A,B;
electrical A1,B1,A,B;

integer outfile;
real V_B;
real V_A;
real I_B;
real I_A;
real VA;
integer VA_retc;
integer VA_cnt;
real VB;
integer VB_retc;
integer VB_cnt;
real JMax_AC;
integer JMax_AC_retc;
integer JMax_AC_cnt;
real JMax_DC;
integer JMax_DC_retc;
integer JMax_DC_cnt;

analog begin
   $bound_step( tstep_occ );
   @(initial_step) begin
      VA_retc=0;
      VA_cnt = maxEv;
      VB_retc=0;
      VB_cnt = maxEv;
      JMax_AC_retc=0;
      JMax_AC_cnt = maxEv;
      JMax_DC_retc=0;
      JMax_DC_cnt = maxEv;
   end
   V_B = V(B);
   V_A = V(A);
   I_B = I(B1,B);
   I_A = I(A1,A);

//      VA
   VA = V_A;
   if((VA_cnt>0) || ( maxEv_flg==0 ))   begin
      if( (VA < -200) && (VA_retc!=-1))
      begin
        outfile=$fopen(errFileName,"a");
        $strobe("rm1           VA      leaving   OCA (  .. -200.000 V ) at %7.4r  %M", $abstime );
        $fwrite(outfile,"rm1           VA      leaving   OCA (  .. -200.000 V ) at %7.4r  %M\n", $abstime );
        VA_retc=-1;
        VA_cnt=VA_cnt-1;
        $fclose(outfile);
      end
      if((VA >= -200) &&  (VA <= 200) && (VA_retc!=0))
      begin
        outfile=$fopen(errFileName,"a");
        $strobe("rm1           VA      entering SOCA ( -200.000 V .. 200.000 V ) at %7.4r  %M", $abstime );
        $fwrite(outfile,"rm1           VA      entering SOCA ( -200.000 V .. 200.000 V ) at %7.4r  %M\n", $abstime );
        VA_retc=0;
        VA_cnt=VA_cnt-1;
        $fclose(outfile);
      end
      if((VA > 200) &&  (VA_retc!=1))
      begin
        outfile=$fopen(errFileName,"a");
        $strobe("rm1           VA      leaving   OCA ( 200.000 V ..  ) at %7.4r  %M", $abstime );
        $fwrite(outfile,"rm1           VA      leaving   OCA ( 200.000 V ..  ) at %7.4r  %M\n", $abstime );
        VA_retc=1;
        VA_cnt=VA_cnt-1;
        $fclose(outfile);
      end
   end
   else
   begin
      if(VA_cnt==0)
      begin
        outfile=$fopen(errFileName,"a");
        $strobe("rm1           VA      error limit ( %d ) reached at %7.4r  %M", maxEv, $abstime );
        $fwrite(outfile,"rm1           VA      error limit ( %d ) reached at %7.4r  %M\n", maxEv, $abstime );
        VA_cnt=VA_cnt-1;
        $fclose(outfile);
      end
   end

//      VB
   VB = V_B;
   if((VB_cnt>0) || ( maxEv_flg==0 ))   begin
      if( (VB < -200) && (VB_retc!=-1))
      begin
        outfile=$fopen(errFileName,"a");
        $strobe("rm1           VB      leaving   OCA (  .. -200.000 V ) at %7.4r  %M", $abstime );
        $fwrite(outfile,"rm1           VB      leaving   OCA (  .. -200.000 V ) at %7.4r  %M\n", $abstime );
        VB_retc=-1;
        VB_cnt=VB_cnt-1;
        $fclose(outfile);
      end
      if((VB >= -200) &&  (VB <= 200) && (VB_retc!=0))
      begin
        outfile=$fopen(errFileName,"a");
        $strobe("rm1           VB      entering SOCA ( -200.000 V .. 200.000 V ) at %7.4r  %M", $abstime );
        $fwrite(outfile,"rm1           VB      entering SOCA ( -200.000 V .. 200.000 V ) at %7.4r  %M\n", $abstime );
        VB_retc=0;
        VB_cnt=VB_cnt-1;
        $fclose(outfile);
      end
      if((VB > 200) &&  (VB_retc!=1))
      begin
        outfile=$fopen(errFileName,"a");
        $strobe("rm1           VB      leaving   OCA ( 200.000 V ..  ) at %7.4r  %M", $abstime );
        $fwrite(outfile,"rm1           VB      leaving   OCA ( 200.000 V ..  ) at %7.4r  %M\n", $abstime );
        VB_retc=1;
        VB_cnt=VB_cnt-1;
        $fclose(outfile);
      end
   end
   else
   begin
      if(VB_cnt==0)
      begin
        outfile=$fopen(errFileName,"a");
        $strobe("rm1           VB      error limit ( %d ) reached at %7.4r  %M", maxEv, $abstime );
        $fwrite(outfile,"rm1           VB      error limit ( %d ) reached at %7.4r  %M\n", maxEv, $abstime );
        VB_cnt=VB_cnt-1;
        $fclose(outfile);
      end
   end

//      JMax_AC
   if(w > 4.4e-07)
   begin
      JMax_AC = I_A / w;
      if((JMax_AC_cnt>0) || ( maxEv_flg==0 ))      begin
         if( (JMax_AC < -4500) && (JMax_AC_retc!=-1))
         begin
           outfile=$fopen(errFileName,"a");
           $strobe("rm1           JMax_AC leaving   OCA (  .. -4.500 mA/um ) at %7.4r  %M", $abstime );
           $fwrite(outfile,"rm1           JMax_AC leaving   OCA (  .. -4.500 mA/um ) at %7.4r  %M\n", $abstime );
           JMax_AC_retc=-1;
           JMax_AC_cnt=JMax_AC_cnt-1;
           $fclose(outfile);
         end
         if((JMax_AC >= -4500) &&  (JMax_AC <= 4500) && (JMax_AC_retc!=0))
         begin
           outfile=$fopen(errFileName,"a");
           $strobe("rm1           JMax_AC entering SOCA ( -4.500 mA/um .. 4.500 mA/um ) at %7.4r  %M", $abstime );
           $fwrite(outfile,"rm1           JMax_AC entering SOCA ( -4.500 mA/um .. 4.500 mA/um ) at %7.4r  %M\n", $abstime );
           JMax_AC_retc=0;
           JMax_AC_cnt=JMax_AC_cnt-1;
           $fclose(outfile);
         end
         if((JMax_AC > 4500) &&  (JMax_AC_retc!=1))
         begin
           outfile=$fopen(errFileName,"a");
           $strobe("rm1           JMax_AC leaving   OCA ( 4.500 mA/um ..  ) at %7.4r  %M", $abstime );
           $fwrite(outfile,"rm1           JMax_AC leaving   OCA ( 4.500 mA/um ..  ) at %7.4r  %M\n", $abstime );
           JMax_AC_retc=1;
           JMax_AC_cnt=JMax_AC_cnt-1;
           $fclose(outfile);
         end
      end
      else
      begin
         if(JMax_AC_cnt==0)
         begin
           outfile=$fopen(errFileName,"a");
           $strobe("rm1           JMax_AC error limit ( %d ) reached at %7.4r  %M", maxEv, $abstime );
           $fwrite(outfile,"rm1           JMax_AC error limit ( %d ) reached at %7.4r  %M\n", maxEv, $abstime );
           JMax_AC_cnt=JMax_AC_cnt-1;
           $fclose(outfile);
         end
      end
   end
   else
   begin
      JMax_AC = I_A / w;
      if((JMax_AC_cnt>0) || ( maxEv_flg==0 ))      begin
         if( (JMax_AC < -2200) && (JMax_AC_retc!=-1))
         begin
           outfile=$fopen(errFileName,"a");
           $strobe("rm1           JMax_AC leaving   OCA (  .. -2.200 mA/um ) at %7.4r  %M", $abstime );
           $fwrite(outfile,"rm1           JMax_AC leaving   OCA (  .. -2.200 mA/um ) at %7.4r  %M\n", $abstime );
           JMax_AC_retc=-1;
           JMax_AC_cnt=JMax_AC_cnt-1;
           $fclose(outfile);
         end
         if((JMax_AC >= -2200) &&  (JMax_AC <= 2200) && (JMax_AC_retc!=0))
         begin
           outfile=$fopen(errFileName,"a");
           $strobe("rm1           JMax_AC entering SOCA ( -2.200 mA/um .. 2.200 mA/um ) at %7.4r  %M", $abstime );
           $fwrite(outfile,"rm1           JMax_AC entering SOCA ( -2.200 mA/um .. 2.200 mA/um ) at %7.4r  %M\n", $abstime );
           JMax_AC_retc=0;
           JMax_AC_cnt=JMax_AC_cnt-1;
           $fclose(outfile);
         end
         if((JMax_AC > 2200) &&  (JMax_AC_retc!=1))
         begin
           outfile=$fopen(errFileName,"a");
           $strobe("rm1           JMax_AC leaving   OCA ( 2.200 mA/um ..  ) at %7.4r  %M", $abstime );
           $fwrite(outfile,"rm1           JMax_AC leaving   OCA ( 2.200 mA/um ..  ) at %7.4r  %M\n", $abstime );
           JMax_AC_retc=1;
           JMax_AC_cnt=JMax_AC_cnt-1;
           $fclose(outfile);
         end
      end
      else
      begin
         if(JMax_AC_cnt==0)
         begin
           outfile=$fopen(errFileName,"a");
           $strobe("rm1           JMax_AC error limit ( %d ) reached at %7.4r  %M", maxEv, $abstime );
           $fwrite(outfile,"rm1           JMax_AC error limit ( %d ) reached at %7.4r  %M\n", maxEv, $abstime );
           JMax_AC_cnt=JMax_AC_cnt-1;
           $fclose(outfile);
         end
      end
   end

//      JMax_DC
   if(w > 4.4e-07)
   begin
      JMax_DC = I_A / w;
      if((JMax_DC_cnt>0) || ( maxEv_flg==0 ))      begin
         if( (JMax_DC < -1000) && (JMax_DC_retc!=-1))
         begin
           outfile=$fopen(errFileName,"a");
           $strobe("rm1           JMax_DC leaving   OCA (  .. -1.000 mA/um ) at %7.4r  %M", $abstime );
           $fwrite(outfile,"rm1           JMax_DC leaving   OCA (  .. -1.000 mA/um ) at %7.4r  %M\n", $abstime );
           JMax_DC_retc=-1;
           JMax_DC_cnt=JMax_DC_cnt-1;
           $fclose(outfile);
         end
         if((JMax_DC >= -1000) &&  (JMax_DC <= 1000) && (JMax_DC_retc!=0))
         begin
           outfile=$fopen(errFileName,"a");
           $strobe("rm1           JMax_DC entering SOCA ( -1.000 mA/um .. 1.000 mA/um ) at %7.4r  %M", $abstime );
           $fwrite(outfile,"rm1           JMax_DC entering SOCA ( -1.000 mA/um .. 1.000 mA/um ) at %7.4r  %M\n", $abstime );
           JMax_DC_retc=0;
           JMax_DC_cnt=JMax_DC_cnt-1;
           $fclose(outfile);
         end
         if((JMax_DC > 1000) &&  (JMax_DC_retc!=1))
         begin
           outfile=$fopen(errFileName,"a");
           $strobe("rm1           JMax_DC leaving   OCA ( 1.000 mA/um ..  ) at %7.4r  %M", $abstime );
           $fwrite(outfile,"rm1           JMax_DC leaving   OCA ( 1.000 mA/um ..  ) at %7.4r  %M\n", $abstime );
           JMax_DC_retc=1;
           JMax_DC_cnt=JMax_DC_cnt-1;
           $fclose(outfile);
         end
      end
      else
      begin
         if(JMax_DC_cnt==0)
         begin
           outfile=$fopen(errFileName,"a");
           $strobe("rm1           JMax_DC error limit ( %d ) reached at %7.4r  %M", maxEv, $abstime );
           $fwrite(outfile,"rm1           JMax_DC error limit ( %d ) reached at %7.4r  %M\n", maxEv, $abstime );
           JMax_DC_cnt=JMax_DC_cnt-1;
           $fclose(outfile);
         end
      end
   end
   else
   begin
      JMax_DC = I_A / w;
      if((JMax_DC_cnt>0) || ( maxEv_flg==0 ))      begin
         if( (JMax_DC < -500) && (JMax_DC_retc!=-1))
         begin
           outfile=$fopen(errFileName,"a");
           $strobe("rm1           JMax_DC leaving   OCA (  .. -0.500 mA/um ) at %7.4r  %M", $abstime );
           $fwrite(outfile,"rm1           JMax_DC leaving   OCA (  .. -0.500 mA/um ) at %7.4r  %M\n", $abstime );
           JMax_DC_retc=-1;
           JMax_DC_cnt=JMax_DC_cnt-1;
           $fclose(outfile);
         end
         if((JMax_DC >= -500) &&  (JMax_DC <= 500) && (JMax_DC_retc!=0))
         begin
           outfile=$fopen(errFileName,"a");
           $strobe("rm1           JMax_DC entering SOCA ( -0.500 mA/um .. 0.500 mA/um ) at %7.4r  %M", $abstime );
           $fwrite(outfile,"rm1           JMax_DC entering SOCA ( -0.500 mA/um .. 0.500 mA/um ) at %7.4r  %M\n", $abstime );
           JMax_DC_retc=0;
           JMax_DC_cnt=JMax_DC_cnt-1;
           $fclose(outfile);
         end
         if((JMax_DC > 500) &&  (JMax_DC_retc!=1))
         begin
           outfile=$fopen(errFileName,"a");
           $strobe("rm1           JMax_DC leaving   OCA ( 0.500 mA/um ..  ) at %7.4r  %M", $abstime );
           $fwrite(outfile,"rm1           JMax_DC leaving   OCA ( 0.500 mA/um ..  ) at %7.4r  %M\n", $abstime );
           JMax_DC_retc=1;
           JMax_DC_cnt=JMax_DC_cnt-1;
           $fclose(outfile);
         end
      end
      else
      begin
         if(JMax_DC_cnt==0)
         begin
           outfile=$fopen(errFileName,"a");
           $strobe("rm1           JMax_DC error limit ( %d ) reached at %7.4r  %M", maxEv, $abstime );
           $fwrite(outfile,"rm1           JMax_DC error limit ( %d ) reached at %7.4r  %M\n", maxEv, $abstime );
           JMax_DC_cnt=JMax_DC_cnt-1;
           $fclose(outfile);
         end
      end
   end

end // analog
endmodule // rm1

// Verilog-A OC Watch for device rm2 Parameters  VA VB JMax_AC JMax_DC
module rm2_ahdl(A1,B1,A,B);
parameter tstep_occ=100n;
parameter errFileName="./occ.err";
parameter w = 1u;
parameter maxEv = 25;
parameter maxEv_flg = 0;
inout A1,B1,A,B;
electrical A1,B1,A,B;

integer outfile;
real V_B;
real V_A;
real I_B;
real I_A;
real VA;
integer VA_retc;
integer VA_cnt;
real VB;
integer VB_retc;
integer VB_cnt;
real JMax_AC;
integer JMax_AC_retc;
integer JMax_AC_cnt;
real JMax_DC;
integer JMax_DC_retc;
integer JMax_DC_cnt;

analog begin
   $bound_step( tstep_occ );
   @(initial_step) begin
      VA_retc=0;
      VA_cnt = maxEv;
      VB_retc=0;
      VB_cnt = maxEv;
      JMax_AC_retc=0;
      JMax_AC_cnt = maxEv;
      JMax_DC_retc=0;
      JMax_DC_cnt = maxEv;
   end
   V_B = V(B);
   V_A = V(A);
   I_B = I(B1,B);
   I_A = I(A1,A);

//      VA
   VA = V_A;
   if((VA_cnt>0) || ( maxEv_flg==0 ))   begin
      if( (VA < -200) && (VA_retc!=-1))
      begin
        outfile=$fopen(errFileName,"a");
        $strobe("rm2           VA      leaving   OCA (  .. -200.000 V ) at %7.4r  %M", $abstime );
        $fwrite(outfile,"rm2           VA      leaving   OCA (  .. -200.000 V ) at %7.4r  %M\n", $abstime );
        VA_retc=-1;
        VA_cnt=VA_cnt-1;
        $fclose(outfile);
      end
      if((VA >= -200) &&  (VA <= 200) && (VA_retc!=0))
      begin
        outfile=$fopen(errFileName,"a");
        $strobe("rm2           VA      entering SOCA ( -200.000 V .. 200.000 V ) at %7.4r  %M", $abstime );
        $fwrite(outfile,"rm2           VA      entering SOCA ( -200.000 V .. 200.000 V ) at %7.4r  %M\n", $abstime );
        VA_retc=0;
        VA_cnt=VA_cnt-1;
        $fclose(outfile);
      end
      if((VA > 200) &&  (VA_retc!=1))
      begin
        outfile=$fopen(errFileName,"a");
        $strobe("rm2           VA      leaving   OCA ( 200.000 V ..  ) at %7.4r  %M", $abstime );
        $fwrite(outfile,"rm2           VA      leaving   OCA ( 200.000 V ..  ) at %7.4r  %M\n", $abstime );
        VA_retc=1;
        VA_cnt=VA_cnt-1;
        $fclose(outfile);
      end
   end
   else
   begin
      if(VA_cnt==0)
      begin
        outfile=$fopen(errFileName,"a");
        $strobe("rm2           VA      error limit ( %d ) reached at %7.4r  %M", maxEv, $abstime );
        $fwrite(outfile,"rm2           VA      error limit ( %d ) reached at %7.4r  %M\n", maxEv, $abstime );
        VA_cnt=VA_cnt-1;
        $fclose(outfile);
      end
   end

//      VB
   VB = V_B;
   if((VB_cnt>0) || ( maxEv_flg==0 ))   begin
      if( (VB < -200) && (VB_retc!=-1))
      begin
        outfile=$fopen(errFileName,"a");
        $strobe("rm2           VB      leaving   OCA (  .. -200.000 V ) at %7.4r  %M", $abstime );
        $fwrite(outfile,"rm2           VB      leaving   OCA (  .. -200.000 V ) at %7.4r  %M\n", $abstime );
        VB_retc=-1;
        VB_cnt=VB_cnt-1;
        $fclose(outfile);
      end
      if((VB >= -200) &&  (VB <= 200) && (VB_retc!=0))
      begin
        outfile=$fopen(errFileName,"a");
        $strobe("rm2           VB      entering SOCA ( -200.000 V .. 200.000 V ) at %7.4r  %M", $abstime );
        $fwrite(outfile,"rm2           VB      entering SOCA ( -200.000 V .. 200.000 V ) at %7.4r  %M\n", $abstime );
        VB_retc=0;
        VB_cnt=VB_cnt-1;
        $fclose(outfile);
      end
      if((VB > 200) &&  (VB_retc!=1))
      begin
        outfile=$fopen(errFileName,"a");
        $strobe("rm2           VB      leaving   OCA ( 200.000 V ..  ) at %7.4r  %M", $abstime );
        $fwrite(outfile,"rm2           VB      leaving   OCA ( 200.000 V ..  ) at %7.4r  %M\n", $abstime );
        VB_retc=1;
        VB_cnt=VB_cnt-1;
        $fclose(outfile);
      end
   end
   else
   begin
      if(VB_cnt==0)
      begin
        outfile=$fopen(errFileName,"a");
        $strobe("rm2           VB      error limit ( %d ) reached at %7.4r  %M", maxEv, $abstime );
        $fwrite(outfile,"rm2           VB      error limit ( %d ) reached at %7.4r  %M\n", maxEv, $abstime );
        VB_cnt=VB_cnt-1;
        $fclose(outfile);
      end
   end

//      JMax_AC
   if(w > 4.4e-07)
   begin
      JMax_AC = I_A / w;
      if((JMax_AC_cnt>0) || ( maxEv_flg==0 ))      begin
         if( (JMax_AC < -4500) && (JMax_AC_retc!=-1))
         begin
           outfile=$fopen(errFileName,"a");
           $strobe("rm2           JMax_AC leaving   OCA (  .. -4.500 mA/um ) at %7.4r  %M", $abstime );
           $fwrite(outfile,"rm2           JMax_AC leaving   OCA (  .. -4.500 mA/um ) at %7.4r  %M\n", $abstime );
           JMax_AC_retc=-1;
           JMax_AC_cnt=JMax_AC_cnt-1;
           $fclose(outfile);
         end
         if((JMax_AC >= -4500) &&  (JMax_AC <= 4500) && (JMax_AC_retc!=0))
         begin
           outfile=$fopen(errFileName,"a");
           $strobe("rm2           JMax_AC entering SOCA ( -4.500 mA/um .. 4.500 mA/um ) at %7.4r  %M", $abstime );
           $fwrite(outfile,"rm2           JMax_AC entering SOCA ( -4.500 mA/um .. 4.500 mA/um ) at %7.4r  %M\n", $abstime );
           JMax_AC_retc=0;
           JMax_AC_cnt=JMax_AC_cnt-1;
           $fclose(outfile);
         end
         if((JMax_AC > 4500) &&  (JMax_AC_retc!=1))
         begin
           outfile=$fopen(errFileName,"a");
           $strobe("rm2           JMax_AC leaving   OCA ( 4.500 mA/um ..  ) at %7.4r  %M", $abstime );
           $fwrite(outfile,"rm2           JMax_AC leaving   OCA ( 4.500 mA/um ..  ) at %7.4r  %M\n", $abstime );
           JMax_AC_retc=1;
           JMax_AC_cnt=JMax_AC_cnt-1;
           $fclose(outfile);
         end
      end
      else
      begin
         if(JMax_AC_cnt==0)
         begin
           outfile=$fopen(errFileName,"a");
           $strobe("rm2           JMax_AC error limit ( %d ) reached at %7.4r  %M", maxEv, $abstime );
           $fwrite(outfile,"rm2           JMax_AC error limit ( %d ) reached at %7.4r  %M\n", maxEv, $abstime );
           JMax_AC_cnt=JMax_AC_cnt-1;
           $fclose(outfile);
         end
      end
   end
   else
   begin
      JMax_AC = I_A / w;
      if((JMax_AC_cnt>0) || ( maxEv_flg==0 ))      begin
         if( (JMax_AC < -2200) && (JMax_AC_retc!=-1))
         begin
           outfile=$fopen(errFileName,"a");
           $strobe("rm2           JMax_AC leaving   OCA (  .. -2.200 mA/um ) at %7.4r  %M", $abstime );
           $fwrite(outfile,"rm2           JMax_AC leaving   OCA (  .. -2.200 mA/um ) at %7.4r  %M\n", $abstime );
           JMax_AC_retc=-1;
           JMax_AC_cnt=JMax_AC_cnt-1;
           $fclose(outfile);
         end
         if((JMax_AC >= -2200) &&  (JMax_AC <= 2200) && (JMax_AC_retc!=0))
         begin
           outfile=$fopen(errFileName,"a");
           $strobe("rm2           JMax_AC entering SOCA ( -2.200 mA/um .. 2.200 mA/um ) at %7.4r  %M", $abstime );
           $fwrite(outfile,"rm2           JMax_AC entering SOCA ( -2.200 mA/um .. 2.200 mA/um ) at %7.4r  %M\n", $abstime );
           JMax_AC_retc=0;
           JMax_AC_cnt=JMax_AC_cnt-1;
           $fclose(outfile);
         end
         if((JMax_AC > 2200) &&  (JMax_AC_retc!=1))
         begin
           outfile=$fopen(errFileName,"a");
           $strobe("rm2           JMax_AC leaving   OCA ( 2.200 mA/um ..  ) at %7.4r  %M", $abstime );
           $fwrite(outfile,"rm2           JMax_AC leaving   OCA ( 2.200 mA/um ..  ) at %7.4r  %M\n", $abstime );
           JMax_AC_retc=1;
           JMax_AC_cnt=JMax_AC_cnt-1;
           $fclose(outfile);
         end
      end
      else
      begin
         if(JMax_AC_cnt==0)
         begin
           outfile=$fopen(errFileName,"a");
           $strobe("rm2           JMax_AC error limit ( %d ) reached at %7.4r  %M", maxEv, $abstime );
           $fwrite(outfile,"rm2           JMax_AC error limit ( %d ) reached at %7.4r  %M\n", maxEv, $abstime );
           JMax_AC_cnt=JMax_AC_cnt-1;
           $fclose(outfile);
         end
      end
   end

//      JMax_DC
   if(w > 4.4e-07)
   begin
      JMax_DC = I_A / w;
      if((JMax_DC_cnt>0) || ( maxEv_flg==0 ))      begin
         if( (JMax_DC < -1000) && (JMax_DC_retc!=-1))
         begin
           outfile=$fopen(errFileName,"a");
           $strobe("rm2           JMax_DC leaving   OCA (  .. -1.000 mA/um ) at %7.4r  %M", $abstime );
           $fwrite(outfile,"rm2           JMax_DC leaving   OCA (  .. -1.000 mA/um ) at %7.4r  %M\n", $abstime );
           JMax_DC_retc=-1;
           JMax_DC_cnt=JMax_DC_cnt-1;
           $fclose(outfile);
         end
         if((JMax_DC >= -1000) &&  (JMax_DC <= 1000) && (JMax_DC_retc!=0))
         begin
           outfile=$fopen(errFileName,"a");
           $strobe("rm2           JMax_DC entering SOCA ( -1.000 mA/um .. 1.000 mA/um ) at %7.4r  %M", $abstime );
           $fwrite(outfile,"rm2           JMax_DC entering SOCA ( -1.000 mA/um .. 1.000 mA/um ) at %7.4r  %M\n", $abstime );
           JMax_DC_retc=0;
           JMax_DC_cnt=JMax_DC_cnt-1;
           $fclose(outfile);
         end
         if((JMax_DC > 1000) &&  (JMax_DC_retc!=1))
         begin
           outfile=$fopen(errFileName,"a");
           $strobe("rm2           JMax_DC leaving   OCA ( 1.000 mA/um ..  ) at %7.4r  %M", $abstime );
           $fwrite(outfile,"rm2           JMax_DC leaving   OCA ( 1.000 mA/um ..  ) at %7.4r  %M\n", $abstime );
           JMax_DC_retc=1;
           JMax_DC_cnt=JMax_DC_cnt-1;
           $fclose(outfile);
         end
      end
      else
      begin
         if(JMax_DC_cnt==0)
         begin
           outfile=$fopen(errFileName,"a");
           $strobe("rm2           JMax_DC error limit ( %d ) reached at %7.4r  %M", maxEv, $abstime );
           $fwrite(outfile,"rm2           JMax_DC error limit ( %d ) reached at %7.4r  %M\n", maxEv, $abstime );
           JMax_DC_cnt=JMax_DC_cnt-1;
           $fclose(outfile);
         end
      end
   end
   else
   begin
      JMax_DC = I_A / w;
      if((JMax_DC_cnt>0) || ( maxEv_flg==0 ))      begin
         if( (JMax_DC < -500) && (JMax_DC_retc!=-1))
         begin
           outfile=$fopen(errFileName,"a");
           $strobe("rm2           JMax_DC leaving   OCA (  .. -0.500 mA/um ) at %7.4r  %M", $abstime );
           $fwrite(outfile,"rm2           JMax_DC leaving   OCA (  .. -0.500 mA/um ) at %7.4r  %M\n", $abstime );
           JMax_DC_retc=-1;
           JMax_DC_cnt=JMax_DC_cnt-1;
           $fclose(outfile);
         end
         if((JMax_DC >= -500) &&  (JMax_DC <= 500) && (JMax_DC_retc!=0))
         begin
           outfile=$fopen(errFileName,"a");
           $strobe("rm2           JMax_DC entering SOCA ( -0.500 mA/um .. 0.500 mA/um ) at %7.4r  %M", $abstime );
           $fwrite(outfile,"rm2           JMax_DC entering SOCA ( -0.500 mA/um .. 0.500 mA/um ) at %7.4r  %M\n", $abstime );
           JMax_DC_retc=0;
           JMax_DC_cnt=JMax_DC_cnt-1;
           $fclose(outfile);
         end
         if((JMax_DC > 500) &&  (JMax_DC_retc!=1))
         begin
           outfile=$fopen(errFileName,"a");
           $strobe("rm2           JMax_DC leaving   OCA ( 0.500 mA/um ..  ) at %7.4r  %M", $abstime );
           $fwrite(outfile,"rm2           JMax_DC leaving   OCA ( 0.500 mA/um ..  ) at %7.4r  %M\n", $abstime );
           JMax_DC_retc=1;
           JMax_DC_cnt=JMax_DC_cnt-1;
           $fclose(outfile);
         end
      end
      else
      begin
         if(JMax_DC_cnt==0)
         begin
           outfile=$fopen(errFileName,"a");
           $strobe("rm2           JMax_DC error limit ( %d ) reached at %7.4r  %M", maxEv, $abstime );
           $fwrite(outfile,"rm2           JMax_DC error limit ( %d ) reached at %7.4r  %M\n", maxEv, $abstime );
           JMax_DC_cnt=JMax_DC_cnt-1;
           $fclose(outfile);
         end
      end
   end

end // analog
endmodule // rm2

// Verilog-A OC Watch for device rm3 Parameters  VA VB JMax_AC JMax_DC
module rm3_ahdl(A1,B1,A,B);
parameter tstep_occ=100n;
parameter errFileName="./occ.err";
parameter w = 1u;
parameter maxEv = 25;
parameter maxEv_flg = 0;
inout A1,B1,A,B;
electrical A1,B1,A,B;

integer outfile;
real V_B;
real V_A;
real I_B;
real I_A;
real VA;
integer VA_retc;
integer VA_cnt;
real VB;
integer VB_retc;
integer VB_cnt;
real JMax_AC;
integer JMax_AC_retc;
integer JMax_AC_cnt;
real JMax_DC;
integer JMax_DC_retc;
integer JMax_DC_cnt;

analog begin
   $bound_step( tstep_occ );
   @(initial_step) begin
      VA_retc=0;
      VA_cnt = maxEv;
      VB_retc=0;
      VB_cnt = maxEv;
      JMax_AC_retc=0;
      JMax_AC_cnt = maxEv;
      JMax_DC_retc=0;
      JMax_DC_cnt = maxEv;
   end
   V_B = V(B);
   V_A = V(A);
   I_B = I(B1,B);
   I_A = I(A1,A);

//      VA
   VA = V_A;
   if((VA_cnt>0) || ( maxEv_flg==0 ))   begin
      if( (VA < -200) && (VA_retc!=-1))
      begin
        outfile=$fopen(errFileName,"a");
        $strobe("rm3           VA      leaving   OCA (  .. -200.000 V ) at %7.4r  %M", $abstime );
        $fwrite(outfile,"rm3           VA      leaving   OCA (  .. -200.000 V ) at %7.4r  %M\n", $abstime );
        VA_retc=-1;
        VA_cnt=VA_cnt-1;
        $fclose(outfile);
      end
      if((VA >= -200) &&  (VA <= 200) && (VA_retc!=0))
      begin
        outfile=$fopen(errFileName,"a");
        $strobe("rm3           VA      entering SOCA ( -200.000 V .. 200.000 V ) at %7.4r  %M", $abstime );
        $fwrite(outfile,"rm3           VA      entering SOCA ( -200.000 V .. 200.000 V ) at %7.4r  %M\n", $abstime );
        VA_retc=0;
        VA_cnt=VA_cnt-1;
        $fclose(outfile);
      end
      if((VA > 200) &&  (VA_retc!=1))
      begin
        outfile=$fopen(errFileName,"a");
        $strobe("rm3           VA      leaving   OCA ( 200.000 V ..  ) at %7.4r  %M", $abstime );
        $fwrite(outfile,"rm3           VA      leaving   OCA ( 200.000 V ..  ) at %7.4r  %M\n", $abstime );
        VA_retc=1;
        VA_cnt=VA_cnt-1;
        $fclose(outfile);
      end
   end
   else
   begin
      if(VA_cnt==0)
      begin
        outfile=$fopen(errFileName,"a");
        $strobe("rm3           VA      error limit ( %d ) reached at %7.4r  %M", maxEv, $abstime );
        $fwrite(outfile,"rm3           VA      error limit ( %d ) reached at %7.4r  %M\n", maxEv, $abstime );
        VA_cnt=VA_cnt-1;
        $fclose(outfile);
      end
   end

//      VB
   VB = V_B;
   if((VB_cnt>0) || ( maxEv_flg==0 ))   begin
      if( (VB < -200) && (VB_retc!=-1))
      begin
        outfile=$fopen(errFileName,"a");
        $strobe("rm3           VB      leaving   OCA (  .. -200.000 V ) at %7.4r  %M", $abstime );
        $fwrite(outfile,"rm3           VB      leaving   OCA (  .. -200.000 V ) at %7.4r  %M\n", $abstime );
        VB_retc=-1;
        VB_cnt=VB_cnt-1;
        $fclose(outfile);
      end
      if((VB >= -200) &&  (VB <= 200) && (VB_retc!=0))
      begin
        outfile=$fopen(errFileName,"a");
        $strobe("rm3           VB      entering SOCA ( -200.000 V .. 200.000 V ) at %7.4r  %M", $abstime );
        $fwrite(outfile,"rm3           VB      entering SOCA ( -200.000 V .. 200.000 V ) at %7.4r  %M\n", $abstime );
        VB_retc=0;
        VB_cnt=VB_cnt-1;
        $fclose(outfile);
      end
      if((VB > 200) &&  (VB_retc!=1))
      begin
        outfile=$fopen(errFileName,"a");
        $strobe("rm3           VB      leaving   OCA ( 200.000 V ..  ) at %7.4r  %M", $abstime );
        $fwrite(outfile,"rm3           VB      leaving   OCA ( 200.000 V ..  ) at %7.4r  %M\n", $abstime );
        VB_retc=1;
        VB_cnt=VB_cnt-1;
        $fclose(outfile);
      end
   end
   else
   begin
      if(VB_cnt==0)
      begin
        outfile=$fopen(errFileName,"a");
        $strobe("rm3           VB      error limit ( %d ) reached at %7.4r  %M", maxEv, $abstime );
        $fwrite(outfile,"rm3           VB      error limit ( %d ) reached at %7.4r  %M\n", maxEv, $abstime );
        VB_cnt=VB_cnt-1;
        $fclose(outfile);
      end
   end

//      JMax_AC
   if(w > 4.4e-07)
   begin
      JMax_AC = I_A / w;
      if((JMax_AC_cnt>0) || ( maxEv_flg==0 ))      begin
         if( (JMax_AC < -4500) && (JMax_AC_retc!=-1))
         begin
           outfile=$fopen(errFileName,"a");
           $strobe("rm3           JMax_AC leaving   OCA (  .. -4.500 mA/um ) at %7.4r  %M", $abstime );
           $fwrite(outfile,"rm3           JMax_AC leaving   OCA (  .. -4.500 mA/um ) at %7.4r  %M\n", $abstime );
           JMax_AC_retc=-1;
           JMax_AC_cnt=JMax_AC_cnt-1;
           $fclose(outfile);
         end
         if((JMax_AC >= -4500) &&  (JMax_AC <= 4500) && (JMax_AC_retc!=0))
         begin
           outfile=$fopen(errFileName,"a");
           $strobe("rm3           JMax_AC entering SOCA ( -4.500 mA/um .. 4.500 mA/um ) at %7.4r  %M", $abstime );
           $fwrite(outfile,"rm3           JMax_AC entering SOCA ( -4.500 mA/um .. 4.500 mA/um ) at %7.4r  %M\n", $abstime );
           JMax_AC_retc=0;
           JMax_AC_cnt=JMax_AC_cnt-1;
           $fclose(outfile);
         end
         if((JMax_AC > 4500) &&  (JMax_AC_retc!=1))
         begin
           outfile=$fopen(errFileName,"a");
           $strobe("rm3           JMax_AC leaving   OCA ( 4.500 mA/um ..  ) at %7.4r  %M", $abstime );
           $fwrite(outfile,"rm3           JMax_AC leaving   OCA ( 4.500 mA/um ..  ) at %7.4r  %M\n", $abstime );
           JMax_AC_retc=1;
           JMax_AC_cnt=JMax_AC_cnt-1;
           $fclose(outfile);
         end
      end
      else
      begin
         if(JMax_AC_cnt==0)
         begin
           outfile=$fopen(errFileName,"a");
           $strobe("rm3           JMax_AC error limit ( %d ) reached at %7.4r  %M", maxEv, $abstime );
           $fwrite(outfile,"rm3           JMax_AC error limit ( %d ) reached at %7.4r  %M\n", maxEv, $abstime );
           JMax_AC_cnt=JMax_AC_cnt-1;
           $fclose(outfile);
         end
      end
   end
   else
   begin
      JMax_AC = I_A / w;
      if((JMax_AC_cnt>0) || ( maxEv_flg==0 ))      begin
         if( (JMax_AC < -2200) && (JMax_AC_retc!=-1))
         begin
           outfile=$fopen(errFileName,"a");
           $strobe("rm3           JMax_AC leaving   OCA (  .. -2.200 mA/um ) at %7.4r  %M", $abstime );
           $fwrite(outfile,"rm3           JMax_AC leaving   OCA (  .. -2.200 mA/um ) at %7.4r  %M\n", $abstime );
           JMax_AC_retc=-1;
           JMax_AC_cnt=JMax_AC_cnt-1;
           $fclose(outfile);
         end
         if((JMax_AC >= -2200) &&  (JMax_AC <= 2200) && (JMax_AC_retc!=0))
         begin
           outfile=$fopen(errFileName,"a");
           $strobe("rm3           JMax_AC entering SOCA ( -2.200 mA/um .. 2.200 mA/um ) at %7.4r  %M", $abstime );
           $fwrite(outfile,"rm3           JMax_AC entering SOCA ( -2.200 mA/um .. 2.200 mA/um ) at %7.4r  %M\n", $abstime );
           JMax_AC_retc=0;
           JMax_AC_cnt=JMax_AC_cnt-1;
           $fclose(outfile);
         end
         if((JMax_AC > 2200) &&  (JMax_AC_retc!=1))
         begin
           outfile=$fopen(errFileName,"a");
           $strobe("rm3           JMax_AC leaving   OCA ( 2.200 mA/um ..  ) at %7.4r  %M", $abstime );
           $fwrite(outfile,"rm3           JMax_AC leaving   OCA ( 2.200 mA/um ..  ) at %7.4r  %M\n", $abstime );
           JMax_AC_retc=1;
           JMax_AC_cnt=JMax_AC_cnt-1;
           $fclose(outfile);
         end
      end
      else
      begin
         if(JMax_AC_cnt==0)
         begin
           outfile=$fopen(errFileName,"a");
           $strobe("rm3           JMax_AC error limit ( %d ) reached at %7.4r  %M", maxEv, $abstime );
           $fwrite(outfile,"rm3           JMax_AC error limit ( %d ) reached at %7.4r  %M\n", maxEv, $abstime );
           JMax_AC_cnt=JMax_AC_cnt-1;
           $fclose(outfile);
         end
      end
   end

//      JMax_DC
   if(w > 4.4e-07)
   begin
      JMax_DC = I_A / w;
      if((JMax_DC_cnt>0) || ( maxEv_flg==0 ))      begin
         if( (JMax_DC < -1000) && (JMax_DC_retc!=-1))
         begin
           outfile=$fopen(errFileName,"a");
           $strobe("rm3           JMax_DC leaving   OCA (  .. -1.000 mA/um ) at %7.4r  %M", $abstime );
           $fwrite(outfile,"rm3           JMax_DC leaving   OCA (  .. -1.000 mA/um ) at %7.4r  %M\n", $abstime );
           JMax_DC_retc=-1;
           JMax_DC_cnt=JMax_DC_cnt-1;
           $fclose(outfile);
         end
         if((JMax_DC >= -1000) &&  (JMax_DC <= 1000) && (JMax_DC_retc!=0))
         begin
           outfile=$fopen(errFileName,"a");
           $strobe("rm3           JMax_DC entering SOCA ( -1.000 mA/um .. 1.000 mA/um ) at %7.4r  %M", $abstime );
           $fwrite(outfile,"rm3           JMax_DC entering SOCA ( -1.000 mA/um .. 1.000 mA/um ) at %7.4r  %M\n", $abstime );
           JMax_DC_retc=0;
           JMax_DC_cnt=JMax_DC_cnt-1;
           $fclose(outfile);
         end
         if((JMax_DC > 1000) &&  (JMax_DC_retc!=1))
         begin
           outfile=$fopen(errFileName,"a");
           $strobe("rm3           JMax_DC leaving   OCA ( 1.000 mA/um ..  ) at %7.4r  %M", $abstime );
           $fwrite(outfile,"rm3           JMax_DC leaving   OCA ( 1.000 mA/um ..  ) at %7.4r  %M\n", $abstime );
           JMax_DC_retc=1;
           JMax_DC_cnt=JMax_DC_cnt-1;
           $fclose(outfile);
         end
      end
      else
      begin
         if(JMax_DC_cnt==0)
         begin
           outfile=$fopen(errFileName,"a");
           $strobe("rm3           JMax_DC error limit ( %d ) reached at %7.4r  %M", maxEv, $abstime );
           $fwrite(outfile,"rm3           JMax_DC error limit ( %d ) reached at %7.4r  %M\n", maxEv, $abstime );
           JMax_DC_cnt=JMax_DC_cnt-1;
           $fclose(outfile);
         end
      end
   end
   else
   begin
      JMax_DC = I_A / w;
      if((JMax_DC_cnt>0) || ( maxEv_flg==0 ))      begin
         if( (JMax_DC < -500) && (JMax_DC_retc!=-1))
         begin
           outfile=$fopen(errFileName,"a");
           $strobe("rm3           JMax_DC leaving   OCA (  .. -0.500 mA/um ) at %7.4r  %M", $abstime );
           $fwrite(outfile,"rm3           JMax_DC leaving   OCA (  .. -0.500 mA/um ) at %7.4r  %M\n", $abstime );
           JMax_DC_retc=-1;
           JMax_DC_cnt=JMax_DC_cnt-1;
           $fclose(outfile);
         end
         if((JMax_DC >= -500) &&  (JMax_DC <= 500) && (JMax_DC_retc!=0))
         begin
           outfile=$fopen(errFileName,"a");
           $strobe("rm3           JMax_DC entering SOCA ( -0.500 mA/um .. 0.500 mA/um ) at %7.4r  %M", $abstime );
           $fwrite(outfile,"rm3           JMax_DC entering SOCA ( -0.500 mA/um .. 0.500 mA/um ) at %7.4r  %M\n", $abstime );
           JMax_DC_retc=0;
           JMax_DC_cnt=JMax_DC_cnt-1;
           $fclose(outfile);
         end
         if((JMax_DC > 500) &&  (JMax_DC_retc!=1))
         begin
           outfile=$fopen(errFileName,"a");
           $strobe("rm3           JMax_DC leaving   OCA ( 0.500 mA/um ..  ) at %7.4r  %M", $abstime );
           $fwrite(outfile,"rm3           JMax_DC leaving   OCA ( 0.500 mA/um ..  ) at %7.4r  %M\n", $abstime );
           JMax_DC_retc=1;
           JMax_DC_cnt=JMax_DC_cnt-1;
           $fclose(outfile);
         end
      end
      else
      begin
         if(JMax_DC_cnt==0)
         begin
           outfile=$fopen(errFileName,"a");
           $strobe("rm3           JMax_DC error limit ( %d ) reached at %7.4r  %M", maxEv, $abstime );
           $fwrite(outfile,"rm3           JMax_DC error limit ( %d ) reached at %7.4r  %M\n", maxEv, $abstime );
           JMax_DC_cnt=JMax_DC_cnt-1;
           $fclose(outfile);
         end
      end
   end

end // analog
endmodule // rm3

// Verilog-A OC Watch for device rm4 Parameters  VA VB JMax_AC JMax_DC
module rm4_ahdl(A1,B1,A,B);
parameter tstep_occ=100n;
parameter errFileName="./occ.err";
parameter w = 1u;
parameter maxEv = 25;
parameter maxEv_flg = 0;
inout A1,B1,A,B;
electrical A1,B1,A,B;

integer outfile;
real V_B;
real V_A;
real I_B;
real I_A;
real VA;
integer VA_retc;
integer VA_cnt;
real VB;
integer VB_retc;
integer VB_cnt;
real JMax_AC;
integer JMax_AC_retc;
integer JMax_AC_cnt;
real JMax_DC;
integer JMax_DC_retc;
integer JMax_DC_cnt;

analog begin
   $bound_step( tstep_occ );
   @(initial_step) begin
      VA_retc=0;
      VA_cnt = maxEv;
      VB_retc=0;
      VB_cnt = maxEv;
      JMax_AC_retc=0;
      JMax_AC_cnt = maxEv;
      JMax_DC_retc=0;
      JMax_DC_cnt = maxEv;
   end
   V_B = V(B);
   V_A = V(A);
   I_B = I(B1,B);
   I_A = I(A1,A);

//      VA
   VA = V_A;
   if((VA_cnt>0) || ( maxEv_flg==0 ))   begin
      if( (VA < -200) && (VA_retc!=-1))
      begin
        outfile=$fopen(errFileName,"a");
        $strobe("rm4           VA      leaving   OCA (  .. -200.000 V ) at %7.4r  %M", $abstime );
        $fwrite(outfile,"rm4           VA      leaving   OCA (  .. -200.000 V ) at %7.4r  %M\n", $abstime );
        VA_retc=-1;
        VA_cnt=VA_cnt-1;
        $fclose(outfile);
      end
      if((VA >= -200) &&  (VA <= 200) && (VA_retc!=0))
      begin
        outfile=$fopen(errFileName,"a");
        $strobe("rm4           VA      entering SOCA ( -200.000 V .. 200.000 V ) at %7.4r  %M", $abstime );
        $fwrite(outfile,"rm4           VA      entering SOCA ( -200.000 V .. 200.000 V ) at %7.4r  %M\n", $abstime );
        VA_retc=0;
        VA_cnt=VA_cnt-1;
        $fclose(outfile);
      end
      if((VA > 200) &&  (VA_retc!=1))
      begin
        outfile=$fopen(errFileName,"a");
        $strobe("rm4           VA      leaving   OCA ( 200.000 V ..  ) at %7.4r  %M", $abstime );
        $fwrite(outfile,"rm4           VA      leaving   OCA ( 200.000 V ..  ) at %7.4r  %M\n", $abstime );
        VA_retc=1;
        VA_cnt=VA_cnt-1;
        $fclose(outfile);
      end
   end
   else
   begin
      if(VA_cnt==0)
      begin
        outfile=$fopen(errFileName,"a");
        $strobe("rm4           VA      error limit ( %d ) reached at %7.4r  %M", maxEv, $abstime );
        $fwrite(outfile,"rm4           VA      error limit ( %d ) reached at %7.4r  %M\n", maxEv, $abstime );
        VA_cnt=VA_cnt-1;
        $fclose(outfile);
      end
   end

//      VB
   VB = V_B;
   if((VB_cnt>0) || ( maxEv_flg==0 ))   begin
      if( (VB < -200) && (VB_retc!=-1))
      begin
        outfile=$fopen(errFileName,"a");
        $strobe("rm4           VB      leaving   OCA (  .. -200.000 V ) at %7.4r  %M", $abstime );
        $fwrite(outfile,"rm4           VB      leaving   OCA (  .. -200.000 V ) at %7.4r  %M\n", $abstime );
        VB_retc=-1;
        VB_cnt=VB_cnt-1;
        $fclose(outfile);
      end
      if((VB >= -200) &&  (VB <= 200) && (VB_retc!=0))
      begin
        outfile=$fopen(errFileName,"a");
        $strobe("rm4           VB      entering SOCA ( -200.000 V .. 200.000 V ) at %7.4r  %M", $abstime );
        $fwrite(outfile,"rm4           VB      entering SOCA ( -200.000 V .. 200.000 V ) at %7.4r  %M\n", $abstime );
        VB_retc=0;
        VB_cnt=VB_cnt-1;
        $fclose(outfile);
      end
      if((VB > 200) &&  (VB_retc!=1))
      begin
        outfile=$fopen(errFileName,"a");
        $strobe("rm4           VB      leaving   OCA ( 200.000 V ..  ) at %7.4r  %M", $abstime );
        $fwrite(outfile,"rm4           VB      leaving   OCA ( 200.000 V ..  ) at %7.4r  %M\n", $abstime );
        VB_retc=1;
        VB_cnt=VB_cnt-1;
        $fclose(outfile);
      end
   end
   else
   begin
      if(VB_cnt==0)
      begin
        outfile=$fopen(errFileName,"a");
        $strobe("rm4           VB      error limit ( %d ) reached at %7.4r  %M", maxEv, $abstime );
        $fwrite(outfile,"rm4           VB      error limit ( %d ) reached at %7.4r  %M\n", maxEv, $abstime );
        VB_cnt=VB_cnt-1;
        $fclose(outfile);
      end
   end

//      JMax_AC
   if(w > 4.4e-07)
   begin
      JMax_AC = I_A / w;
      if((JMax_AC_cnt>0) || ( maxEv_flg==0 ))      begin
         if( (JMax_AC < -4500) && (JMax_AC_retc!=-1))
         begin
           outfile=$fopen(errFileName,"a");
           $strobe("rm4           JMax_AC leaving   OCA (  .. -4.500 mA/um ) at %7.4r  %M", $abstime );
           $fwrite(outfile,"rm4           JMax_AC leaving   OCA (  .. -4.500 mA/um ) at %7.4r  %M\n", $abstime );
           JMax_AC_retc=-1;
           JMax_AC_cnt=JMax_AC_cnt-1;
           $fclose(outfile);
         end
         if((JMax_AC >= -4500) &&  (JMax_AC <= 4500) && (JMax_AC_retc!=0))
         begin
           outfile=$fopen(errFileName,"a");
           $strobe("rm4           JMax_AC entering SOCA ( -4.500 mA/um .. 4.500 mA/um ) at %7.4r  %M", $abstime );
           $fwrite(outfile,"rm4           JMax_AC entering SOCA ( -4.500 mA/um .. 4.500 mA/um ) at %7.4r  %M\n", $abstime );
           JMax_AC_retc=0;
           JMax_AC_cnt=JMax_AC_cnt-1;
           $fclose(outfile);
         end
         if((JMax_AC > 4500) &&  (JMax_AC_retc!=1))
         begin
           outfile=$fopen(errFileName,"a");
           $strobe("rm4           JMax_AC leaving   OCA ( 4.500 mA/um ..  ) at %7.4r  %M", $abstime );
           $fwrite(outfile,"rm4           JMax_AC leaving   OCA ( 4.500 mA/um ..  ) at %7.4r  %M\n", $abstime );
           JMax_AC_retc=1;
           JMax_AC_cnt=JMax_AC_cnt-1;
           $fclose(outfile);
         end
      end
      else
      begin
         if(JMax_AC_cnt==0)
         begin
           outfile=$fopen(errFileName,"a");
           $strobe("rm4           JMax_AC error limit ( %d ) reached at %7.4r  %M", maxEv, $abstime );
           $fwrite(outfile,"rm4           JMax_AC error limit ( %d ) reached at %7.4r  %M\n", maxEv, $abstime );
           JMax_AC_cnt=JMax_AC_cnt-1;
           $fclose(outfile);
         end
      end
   end
   else
   begin
      JMax_AC = I_A / w;
      if((JMax_AC_cnt>0) || ( maxEv_flg==0 ))      begin
         if( (JMax_AC < -2200) && (JMax_AC_retc!=-1))
         begin
           outfile=$fopen(errFileName,"a");
           $strobe("rm4           JMax_AC leaving   OCA (  .. -2.200 mA/um ) at %7.4r  %M", $abstime );
           $fwrite(outfile,"rm4           JMax_AC leaving   OCA (  .. -2.200 mA/um ) at %7.4r  %M\n", $abstime );
           JMax_AC_retc=-1;
           JMax_AC_cnt=JMax_AC_cnt-1;
           $fclose(outfile);
         end
         if((JMax_AC >= -2200) &&  (JMax_AC <= 2200) && (JMax_AC_retc!=0))
         begin
           outfile=$fopen(errFileName,"a");
           $strobe("rm4           JMax_AC entering SOCA ( -2.200 mA/um .. 2.200 mA/um ) at %7.4r  %M", $abstime );
           $fwrite(outfile,"rm4           JMax_AC entering SOCA ( -2.200 mA/um .. 2.200 mA/um ) at %7.4r  %M\n", $abstime );
           JMax_AC_retc=0;
           JMax_AC_cnt=JMax_AC_cnt-1;
           $fclose(outfile);
         end
         if((JMax_AC > 2200) &&  (JMax_AC_retc!=1))
         begin
           outfile=$fopen(errFileName,"a");
           $strobe("rm4           JMax_AC leaving   OCA ( 2.200 mA/um ..  ) at %7.4r  %M", $abstime );
           $fwrite(outfile,"rm4           JMax_AC leaving   OCA ( 2.200 mA/um ..  ) at %7.4r  %M\n", $abstime );
           JMax_AC_retc=1;
           JMax_AC_cnt=JMax_AC_cnt-1;
           $fclose(outfile);
         end
      end
      else
      begin
         if(JMax_AC_cnt==0)
         begin
           outfile=$fopen(errFileName,"a");
           $strobe("rm4           JMax_AC error limit ( %d ) reached at %7.4r  %M", maxEv, $abstime );
           $fwrite(outfile,"rm4           JMax_AC error limit ( %d ) reached at %7.4r  %M\n", maxEv, $abstime );
           JMax_AC_cnt=JMax_AC_cnt-1;
           $fclose(outfile);
         end
      end
   end

//      JMax_DC
   if(w > 4.4e-07)
   begin
      JMax_DC = I_A / w;
      if((JMax_DC_cnt>0) || ( maxEv_flg==0 ))      begin
         if( (JMax_DC < -1000) && (JMax_DC_retc!=-1))
         begin
           outfile=$fopen(errFileName,"a");
           $strobe("rm4           JMax_DC leaving   OCA (  .. -1.000 mA/um ) at %7.4r  %M", $abstime );
           $fwrite(outfile,"rm4           JMax_DC leaving   OCA (  .. -1.000 mA/um ) at %7.4r  %M\n", $abstime );
           JMax_DC_retc=-1;
           JMax_DC_cnt=JMax_DC_cnt-1;
           $fclose(outfile);
         end
         if((JMax_DC >= -1000) &&  (JMax_DC <= 1000) && (JMax_DC_retc!=0))
         begin
           outfile=$fopen(errFileName,"a");
           $strobe("rm4           JMax_DC entering SOCA ( -1.000 mA/um .. 1.000 mA/um ) at %7.4r  %M", $abstime );
           $fwrite(outfile,"rm4           JMax_DC entering SOCA ( -1.000 mA/um .. 1.000 mA/um ) at %7.4r  %M\n", $abstime );
           JMax_DC_retc=0;
           JMax_DC_cnt=JMax_DC_cnt-1;
           $fclose(outfile);
         end
         if((JMax_DC > 1000) &&  (JMax_DC_retc!=1))
         begin
           outfile=$fopen(errFileName,"a");
           $strobe("rm4           JMax_DC leaving   OCA ( 1.000 mA/um ..  ) at %7.4r  %M", $abstime );
           $fwrite(outfile,"rm4           JMax_DC leaving   OCA ( 1.000 mA/um ..  ) at %7.4r  %M\n", $abstime );
           JMax_DC_retc=1;
           JMax_DC_cnt=JMax_DC_cnt-1;
           $fclose(outfile);
         end
      end
      else
      begin
         if(JMax_DC_cnt==0)
         begin
           outfile=$fopen(errFileName,"a");
           $strobe("rm4           JMax_DC error limit ( %d ) reached at %7.4r  %M", maxEv, $abstime );
           $fwrite(outfile,"rm4           JMax_DC error limit ( %d ) reached at %7.4r  %M\n", maxEv, $abstime );
           JMax_DC_cnt=JMax_DC_cnt-1;
           $fclose(outfile);
         end
      end
   end
   else
   begin
      JMax_DC = I_A / w;
      if((JMax_DC_cnt>0) || ( maxEv_flg==0 ))      begin
         if( (JMax_DC < -500) && (JMax_DC_retc!=-1))
         begin
           outfile=$fopen(errFileName,"a");
           $strobe("rm4           JMax_DC leaving   OCA (  .. -0.500 mA/um ) at %7.4r  %M", $abstime );
           $fwrite(outfile,"rm4           JMax_DC leaving   OCA (  .. -0.500 mA/um ) at %7.4r  %M\n", $abstime );
           JMax_DC_retc=-1;
           JMax_DC_cnt=JMax_DC_cnt-1;
           $fclose(outfile);
         end
         if((JMax_DC >= -500) &&  (JMax_DC <= 500) && (JMax_DC_retc!=0))
         begin
           outfile=$fopen(errFileName,"a");
           $strobe("rm4           JMax_DC entering SOCA ( -0.500 mA/um .. 0.500 mA/um ) at %7.4r  %M", $abstime );
           $fwrite(outfile,"rm4           JMax_DC entering SOCA ( -0.500 mA/um .. 0.500 mA/um ) at %7.4r  %M\n", $abstime );
           JMax_DC_retc=0;
           JMax_DC_cnt=JMax_DC_cnt-1;
           $fclose(outfile);
         end
         if((JMax_DC > 500) &&  (JMax_DC_retc!=1))
         begin
           outfile=$fopen(errFileName,"a");
           $strobe("rm4           JMax_DC leaving   OCA ( 0.500 mA/um ..  ) at %7.4r  %M", $abstime );
           $fwrite(outfile,"rm4           JMax_DC leaving   OCA ( 0.500 mA/um ..  ) at %7.4r  %M\n", $abstime );
           JMax_DC_retc=1;
           JMax_DC_cnt=JMax_DC_cnt-1;
           $fclose(outfile);
         end
      end
      else
      begin
         if(JMax_DC_cnt==0)
         begin
           outfile=$fopen(errFileName,"a");
           $strobe("rm4           JMax_DC error limit ( %d ) reached at %7.4r  %M", maxEv, $abstime );
           $fwrite(outfile,"rm4           JMax_DC error limit ( %d ) reached at %7.4r  %M\n", maxEv, $abstime );
           JMax_DC_cnt=JMax_DC_cnt-1;
           $fclose(outfile);
         end
      end
   end

end // analog
endmodule // rm4

// Verilog-A OC Watch for device rm5 Parameters  VA VB JMax_AC JMax_DC
module rm5_ahdl(A1,B1,A,B);
parameter tstep_occ=100n;
parameter errFileName="./occ.err";
parameter w = 1u;
parameter maxEv = 25;
parameter maxEv_flg = 0;
inout A1,B1,A,B;
electrical A1,B1,A,B;

integer outfile;
real V_B;
real V_A;
real I_B;
real I_A;
real VA;
integer VA_retc;
integer VA_cnt;
real VB;
integer VB_retc;
integer VB_cnt;
real JMax_AC;
integer JMax_AC_retc;
integer JMax_AC_cnt;
real JMax_DC;
integer JMax_DC_retc;
integer JMax_DC_cnt;

analog begin
   $bound_step( tstep_occ );
   @(initial_step) begin
      VA_retc=0;
      VA_cnt = maxEv;
      VB_retc=0;
      VB_cnt = maxEv;
      JMax_AC_retc=0;
      JMax_AC_cnt = maxEv;
      JMax_DC_retc=0;
      JMax_DC_cnt = maxEv;
   end
   V_B = V(B);
   V_A = V(A);
   I_B = I(B1,B);
   I_A = I(A1,A);

//      VA
   VA = V_A;
   if((VA_cnt>0) || ( maxEv_flg==0 ))   begin
      if( (VA < -200) && (VA_retc!=-1))
      begin
        outfile=$fopen(errFileName,"a");
        $strobe("rm5           VA      leaving   OCA (  .. -200.000 V ) at %7.4r  %M", $abstime );
        $fwrite(outfile,"rm5           VA      leaving   OCA (  .. -200.000 V ) at %7.4r  %M\n", $abstime );
        VA_retc=-1;
        VA_cnt=VA_cnt-1;
        $fclose(outfile);
      end
      if((VA >= -200) &&  (VA <= 200) && (VA_retc!=0))
      begin
        outfile=$fopen(errFileName,"a");
        $strobe("rm5           VA      entering SOCA ( -200.000 V .. 200.000 V ) at %7.4r  %M", $abstime );
        $fwrite(outfile,"rm5           VA      entering SOCA ( -200.000 V .. 200.000 V ) at %7.4r  %M\n", $abstime );
        VA_retc=0;
        VA_cnt=VA_cnt-1;
        $fclose(outfile);
      end
      if((VA > 200) &&  (VA_retc!=1))
      begin
        outfile=$fopen(errFileName,"a");
        $strobe("rm5           VA      leaving   OCA ( 200.000 V ..  ) at %7.4r  %M", $abstime );
        $fwrite(outfile,"rm5           VA      leaving   OCA ( 200.000 V ..  ) at %7.4r  %M\n", $abstime );
        VA_retc=1;
        VA_cnt=VA_cnt-1;
        $fclose(outfile);
      end
   end
   else
   begin
      if(VA_cnt==0)
      begin
        outfile=$fopen(errFileName,"a");
        $strobe("rm5           VA      error limit ( %d ) reached at %7.4r  %M", maxEv, $abstime );
        $fwrite(outfile,"rm5           VA      error limit ( %d ) reached at %7.4r  %M\n", maxEv, $abstime );
        VA_cnt=VA_cnt-1;
        $fclose(outfile);
      end
   end

//      VB
   VB = V_B;
   if((VB_cnt>0) || ( maxEv_flg==0 ))   begin
      if( (VB < -200) && (VB_retc!=-1))
      begin
        outfile=$fopen(errFileName,"a");
        $strobe("rm5           VB      leaving   OCA (  .. -200.000 V ) at %7.4r  %M", $abstime );
        $fwrite(outfile,"rm5           VB      leaving   OCA (  .. -200.000 V ) at %7.4r  %M\n", $abstime );
        VB_retc=-1;
        VB_cnt=VB_cnt-1;
        $fclose(outfile);
      end
      if((VB >= -200) &&  (VB <= 200) && (VB_retc!=0))
      begin
        outfile=$fopen(errFileName,"a");
        $strobe("rm5           VB      entering SOCA ( -200.000 V .. 200.000 V ) at %7.4r  %M", $abstime );
        $fwrite(outfile,"rm5           VB      entering SOCA ( -200.000 V .. 200.000 V ) at %7.4r  %M\n", $abstime );
        VB_retc=0;
        VB_cnt=VB_cnt-1;
        $fclose(outfile);
      end
      if((VB > 200) &&  (VB_retc!=1))
      begin
        outfile=$fopen(errFileName,"a");
        $strobe("rm5           VB      leaving   OCA ( 200.000 V ..  ) at %7.4r  %M", $abstime );
        $fwrite(outfile,"rm5           VB      leaving   OCA ( 200.000 V ..  ) at %7.4r  %M\n", $abstime );
        VB_retc=1;
        VB_cnt=VB_cnt-1;
        $fclose(outfile);
      end
   end
   else
   begin
      if(VB_cnt==0)
      begin
        outfile=$fopen(errFileName,"a");
        $strobe("rm5           VB      error limit ( %d ) reached at %7.4r  %M", maxEv, $abstime );
        $fwrite(outfile,"rm5           VB      error limit ( %d ) reached at %7.4r  %M\n", maxEv, $abstime );
        VB_cnt=VB_cnt-1;
        $fclose(outfile);
      end
   end

//      JMax_AC
   if(w > 4.4e-07)
   begin
      JMax_AC = I_A / w;
      if((JMax_AC_cnt>0) || ( maxEv_flg==0 ))      begin
         if( (JMax_AC < -4500) && (JMax_AC_retc!=-1))
         begin
           outfile=$fopen(errFileName,"a");
           $strobe("rm5           JMax_AC leaving   OCA (  .. -4.500 mA/um ) at %7.4r  %M", $abstime );
           $fwrite(outfile,"rm5           JMax_AC leaving   OCA (  .. -4.500 mA/um ) at %7.4r  %M\n", $abstime );
           JMax_AC_retc=-1;
           JMax_AC_cnt=JMax_AC_cnt-1;
           $fclose(outfile);
         end
         if((JMax_AC >= -4500) &&  (JMax_AC <= 4500) && (JMax_AC_retc!=0))
         begin
           outfile=$fopen(errFileName,"a");
           $strobe("rm5           JMax_AC entering SOCA ( -4.500 mA/um .. 4.500 mA/um ) at %7.4r  %M", $abstime );
           $fwrite(outfile,"rm5           JMax_AC entering SOCA ( -4.500 mA/um .. 4.500 mA/um ) at %7.4r  %M\n", $abstime );
           JMax_AC_retc=0;
           JMax_AC_cnt=JMax_AC_cnt-1;
           $fclose(outfile);
         end
         if((JMax_AC > 4500) &&  (JMax_AC_retc!=1))
         begin
           outfile=$fopen(errFileName,"a");
           $strobe("rm5           JMax_AC leaving   OCA ( 4.500 mA/um ..  ) at %7.4r  %M", $abstime );
           $fwrite(outfile,"rm5           JMax_AC leaving   OCA ( 4.500 mA/um ..  ) at %7.4r  %M\n", $abstime );
           JMax_AC_retc=1;
           JMax_AC_cnt=JMax_AC_cnt-1;
           $fclose(outfile);
         end
      end
      else
      begin
         if(JMax_AC_cnt==0)
         begin
           outfile=$fopen(errFileName,"a");
           $strobe("rm5           JMax_AC error limit ( %d ) reached at %7.4r  %M", maxEv, $abstime );
           $fwrite(outfile,"rm5           JMax_AC error limit ( %d ) reached at %7.4r  %M\n", maxEv, $abstime );
           JMax_AC_cnt=JMax_AC_cnt-1;
           $fclose(outfile);
         end
      end
   end
   else
   begin
      JMax_AC = I_A / w;
      if((JMax_AC_cnt>0) || ( maxEv_flg==0 ))      begin
         if( (JMax_AC < -2200) && (JMax_AC_retc!=-1))
         begin
           outfile=$fopen(errFileName,"a");
           $strobe("rm5           JMax_AC leaving   OCA (  .. -2.200 mA/um ) at %7.4r  %M", $abstime );
           $fwrite(outfile,"rm5           JMax_AC leaving   OCA (  .. -2.200 mA/um ) at %7.4r  %M\n", $abstime );
           JMax_AC_retc=-1;
           JMax_AC_cnt=JMax_AC_cnt-1;
           $fclose(outfile);
         end
         if((JMax_AC >= -2200) &&  (JMax_AC <= 2200) && (JMax_AC_retc!=0))
         begin
           outfile=$fopen(errFileName,"a");
           $strobe("rm5           JMax_AC entering SOCA ( -2.200 mA/um .. 2.200 mA/um ) at %7.4r  %M", $abstime );
           $fwrite(outfile,"rm5           JMax_AC entering SOCA ( -2.200 mA/um .. 2.200 mA/um ) at %7.4r  %M\n", $abstime );
           JMax_AC_retc=0;
           JMax_AC_cnt=JMax_AC_cnt-1;
           $fclose(outfile);
         end
         if((JMax_AC > 2200) &&  (JMax_AC_retc!=1))
         begin
           outfile=$fopen(errFileName,"a");
           $strobe("rm5           JMax_AC leaving   OCA ( 2.200 mA/um ..  ) at %7.4r  %M", $abstime );
           $fwrite(outfile,"rm5           JMax_AC leaving   OCA ( 2.200 mA/um ..  ) at %7.4r  %M\n", $abstime );
           JMax_AC_retc=1;
           JMax_AC_cnt=JMax_AC_cnt-1;
           $fclose(outfile);
         end
      end
      else
      begin
         if(JMax_AC_cnt==0)
         begin
           outfile=$fopen(errFileName,"a");
           $strobe("rm5           JMax_AC error limit ( %d ) reached at %7.4r  %M", maxEv, $abstime );
           $fwrite(outfile,"rm5           JMax_AC error limit ( %d ) reached at %7.4r  %M\n", maxEv, $abstime );
           JMax_AC_cnt=JMax_AC_cnt-1;
           $fclose(outfile);
         end
      end
   end

//      JMax_DC
   if(w > 4.4e-07)
   begin
      JMax_DC = I_A / w;
      if((JMax_DC_cnt>0) || ( maxEv_flg==0 ))      begin
         if( (JMax_DC < -1000) && (JMax_DC_retc!=-1))
         begin
           outfile=$fopen(errFileName,"a");
           $strobe("rm5           JMax_DC leaving   OCA (  .. -1.000 mA/um ) at %7.4r  %M", $abstime );
           $fwrite(outfile,"rm5           JMax_DC leaving   OCA (  .. -1.000 mA/um ) at %7.4r  %M\n", $abstime );
           JMax_DC_retc=-1;
           JMax_DC_cnt=JMax_DC_cnt-1;
           $fclose(outfile);
         end
         if((JMax_DC >= -1000) &&  (JMax_DC <= 1000) && (JMax_DC_retc!=0))
         begin
           outfile=$fopen(errFileName,"a");
           $strobe("rm5           JMax_DC entering SOCA ( -1.000 mA/um .. 1.000 mA/um ) at %7.4r  %M", $abstime );
           $fwrite(outfile,"rm5           JMax_DC entering SOCA ( -1.000 mA/um .. 1.000 mA/um ) at %7.4r  %M\n", $abstime );
           JMax_DC_retc=0;
           JMax_DC_cnt=JMax_DC_cnt-1;
           $fclose(outfile);
         end
         if((JMax_DC > 1000) &&  (JMax_DC_retc!=1))
         begin
           outfile=$fopen(errFileName,"a");
           $strobe("rm5           JMax_DC leaving   OCA ( 1.000 mA/um ..  ) at %7.4r  %M", $abstime );
           $fwrite(outfile,"rm5           JMax_DC leaving   OCA ( 1.000 mA/um ..  ) at %7.4r  %M\n", $abstime );
           JMax_DC_retc=1;
           JMax_DC_cnt=JMax_DC_cnt-1;
           $fclose(outfile);
         end
      end
      else
      begin
         if(JMax_DC_cnt==0)
         begin
           outfile=$fopen(errFileName,"a");
           $strobe("rm5           JMax_DC error limit ( %d ) reached at %7.4r  %M", maxEv, $abstime );
           $fwrite(outfile,"rm5           JMax_DC error limit ( %d ) reached at %7.4r  %M\n", maxEv, $abstime );
           JMax_DC_cnt=JMax_DC_cnt-1;
           $fclose(outfile);
         end
      end
   end
   else
   begin
      JMax_DC = I_A / w;
      if((JMax_DC_cnt>0) || ( maxEv_flg==0 ))      begin
         if( (JMax_DC < -500) && (JMax_DC_retc!=-1))
         begin
           outfile=$fopen(errFileName,"a");
           $strobe("rm5           JMax_DC leaving   OCA (  .. -0.500 mA/um ) at %7.4r  %M", $abstime );
           $fwrite(outfile,"rm5           JMax_DC leaving   OCA (  .. -0.500 mA/um ) at %7.4r  %M\n", $abstime );
           JMax_DC_retc=-1;
           JMax_DC_cnt=JMax_DC_cnt-1;
           $fclose(outfile);
         end
         if((JMax_DC >= -500) &&  (JMax_DC <= 500) && (JMax_DC_retc!=0))
         begin
           outfile=$fopen(errFileName,"a");
           $strobe("rm5           JMax_DC entering SOCA ( -0.500 mA/um .. 0.500 mA/um ) at %7.4r  %M", $abstime );
           $fwrite(outfile,"rm5           JMax_DC entering SOCA ( -0.500 mA/um .. 0.500 mA/um ) at %7.4r  %M\n", $abstime );
           JMax_DC_retc=0;
           JMax_DC_cnt=JMax_DC_cnt-1;
           $fclose(outfile);
         end
         if((JMax_DC > 500) &&  (JMax_DC_retc!=1))
         begin
           outfile=$fopen(errFileName,"a");
           $strobe("rm5           JMax_DC leaving   OCA ( 0.500 mA/um ..  ) at %7.4r  %M", $abstime );
           $fwrite(outfile,"rm5           JMax_DC leaving   OCA ( 0.500 mA/um ..  ) at %7.4r  %M\n", $abstime );
           JMax_DC_retc=1;
           JMax_DC_cnt=JMax_DC_cnt-1;
           $fclose(outfile);
         end
      end
      else
      begin
         if(JMax_DC_cnt==0)
         begin
           outfile=$fopen(errFileName,"a");
           $strobe("rm5           JMax_DC error limit ( %d ) reached at %7.4r  %M", maxEv, $abstime );
           $fwrite(outfile,"rm5           JMax_DC error limit ( %d ) reached at %7.4r  %M\n", maxEv, $abstime );
           JMax_DC_cnt=JMax_DC_cnt-1;
           $fclose(outfile);
         end
      end
   end

end // analog
endmodule // rm5

// Verilog-A OC Watch for device rmtp Parameters  VA VB JMax_AC JMax_DC
module rmtp_ahdl(A1,B1,A,B);
parameter tstep_occ=100n;
parameter errFileName="./occ.err";
parameter w = 1u;
parameter maxEv = 25;
parameter maxEv_flg = 0;
inout A1,B1,A,B;
electrical A1,B1,A,B;

integer outfile;
real V_B;
real V_A;
real I_B;
real I_A;
real VA;
integer VA_retc;
integer VA_cnt;
real VB;
integer VB_retc;
integer VB_cnt;
real JMax_AC;
integer JMax_AC_retc;
integer JMax_AC_cnt;
real JMax_DC;
integer JMax_DC_retc;
integer JMax_DC_cnt;

analog begin
   $bound_step( tstep_occ );
   @(initial_step) begin
      VA_retc=0;
      VA_cnt = maxEv;
      VB_retc=0;
      VB_cnt = maxEv;
      JMax_AC_retc=0;
      JMax_AC_cnt = maxEv;
      JMax_DC_retc=0;
      JMax_DC_cnt = maxEv;
   end
   V_B = V(B);
   V_A = V(A);
   I_B = I(B1,B);
   I_A = I(A1,A);

//      VA
   VA = V_A;
   if((VA_cnt>0) || ( maxEv_flg==0 ))   begin
      if( (VA < -200) && (VA_retc!=-1))
      begin
        outfile=$fopen(errFileName,"a");
        $strobe("rmtp          VA      leaving   OCA (  .. -200.000 V ) at %7.4r  %M", $abstime );
        $fwrite(outfile,"rmtp          VA      leaving   OCA (  .. -200.000 V ) at %7.4r  %M\n", $abstime );
        VA_retc=-1;
        VA_cnt=VA_cnt-1;
        $fclose(outfile);
      end
      if((VA >= -200) &&  (VA <= 200) && (VA_retc!=0))
      begin
        outfile=$fopen(errFileName,"a");
        $strobe("rmtp          VA      entering SOCA ( -200.000 V .. 200.000 V ) at %7.4r  %M", $abstime );
        $fwrite(outfile,"rmtp          VA      entering SOCA ( -200.000 V .. 200.000 V ) at %7.4r  %M\n", $abstime );
        VA_retc=0;
        VA_cnt=VA_cnt-1;
        $fclose(outfile);
      end
      if((VA > 200) &&  (VA_retc!=1))
      begin
        outfile=$fopen(errFileName,"a");
        $strobe("rmtp          VA      leaving   OCA ( 200.000 V ..  ) at %7.4r  %M", $abstime );
        $fwrite(outfile,"rmtp          VA      leaving   OCA ( 200.000 V ..  ) at %7.4r  %M\n", $abstime );
        VA_retc=1;
        VA_cnt=VA_cnt-1;
        $fclose(outfile);
      end
   end
   else
   begin
      if(VA_cnt==0)
      begin
        outfile=$fopen(errFileName,"a");
        $strobe("rmtp          VA      error limit ( %d ) reached at %7.4r  %M", maxEv, $abstime );
        $fwrite(outfile,"rmtp          VA      error limit ( %d ) reached at %7.4r  %M\n", maxEv, $abstime );
        VA_cnt=VA_cnt-1;
        $fclose(outfile);
      end
   end

//      VB
   VB = V_B;
   if((VB_cnt>0) || ( maxEv_flg==0 ))   begin
      if( (VB < -200) && (VB_retc!=-1))
      begin
        outfile=$fopen(errFileName,"a");
        $strobe("rmtp          VB      leaving   OCA (  .. -200.000 V ) at %7.4r  %M", $abstime );
        $fwrite(outfile,"rmtp          VB      leaving   OCA (  .. -200.000 V ) at %7.4r  %M\n", $abstime );
        VB_retc=-1;
        VB_cnt=VB_cnt-1;
        $fclose(outfile);
      end
      if((VB >= -200) &&  (VB <= 200) && (VB_retc!=0))
      begin
        outfile=$fopen(errFileName,"a");
        $strobe("rmtp          VB      entering SOCA ( -200.000 V .. 200.000 V ) at %7.4r  %M", $abstime );
        $fwrite(outfile,"rmtp          VB      entering SOCA ( -200.000 V .. 200.000 V ) at %7.4r  %M\n", $abstime );
        VB_retc=0;
        VB_cnt=VB_cnt-1;
        $fclose(outfile);
      end
      if((VB > 200) &&  (VB_retc!=1))
      begin
        outfile=$fopen(errFileName,"a");
        $strobe("rmtp          VB      leaving   OCA ( 200.000 V ..  ) at %7.4r  %M", $abstime );
        $fwrite(outfile,"rmtp          VB      leaving   OCA ( 200.000 V ..  ) at %7.4r  %M\n", $abstime );
        VB_retc=1;
        VB_cnt=VB_cnt-1;
        $fclose(outfile);
      end
   end
   else
   begin
      if(VB_cnt==0)
      begin
        outfile=$fopen(errFileName,"a");
        $strobe("rmtp          VB      error limit ( %d ) reached at %7.4r  %M", maxEv, $abstime );
        $fwrite(outfile,"rmtp          VB      error limit ( %d ) reached at %7.4r  %M\n", maxEv, $abstime );
        VB_cnt=VB_cnt-1;
        $fclose(outfile);
      end
   end

//      JMax_AC
   JMax_AC = I_A / w;
   if((JMax_AC_cnt>0) || ( maxEv_flg==0 ))   begin
      if( (JMax_AC < -7200) && (JMax_AC_retc!=-1))
      begin
        outfile=$fopen(errFileName,"a");
        $strobe("rmtp          JMax_AC leaving   OCA (  .. -7.200 mA/um ) at %7.4r  %M", $abstime );
        $fwrite(outfile,"rmtp          JMax_AC leaving   OCA (  .. -7.200 mA/um ) at %7.4r  %M\n", $abstime );
        JMax_AC_retc=-1;
        JMax_AC_cnt=JMax_AC_cnt-1;
        $fclose(outfile);
      end
      if((JMax_AC >= -7200) &&  (JMax_AC <= 7200) && (JMax_AC_retc!=0))
      begin
        outfile=$fopen(errFileName,"a");
        $strobe("rmtp          JMax_AC entering SOCA ( -7.200 mA/um .. 7.200 mA/um ) at %7.4r  %M", $abstime );
        $fwrite(outfile,"rmtp          JMax_AC entering SOCA ( -7.200 mA/um .. 7.200 mA/um ) at %7.4r  %M\n", $abstime );
        JMax_AC_retc=0;
        JMax_AC_cnt=JMax_AC_cnt-1;
        $fclose(outfile);
      end
      if((JMax_AC > 7200) &&  (JMax_AC_retc!=1))
      begin
        outfile=$fopen(errFileName,"a");
        $strobe("rmtp          JMax_AC leaving   OCA ( 7.200 mA/um ..  ) at %7.4r  %M", $abstime );
        $fwrite(outfile,"rmtp          JMax_AC leaving   OCA ( 7.200 mA/um ..  ) at %7.4r  %M\n", $abstime );
        JMax_AC_retc=1;
        JMax_AC_cnt=JMax_AC_cnt-1;
        $fclose(outfile);
      end
   end
   else
   begin
      if(JMax_AC_cnt==0)
      begin
        outfile=$fopen(errFileName,"a");
        $strobe("rmtp          JMax_AC error limit ( %d ) reached at %7.4r  %M", maxEv, $abstime );
        $fwrite(outfile,"rmtp          JMax_AC error limit ( %d ) reached at %7.4r  %M\n", maxEv, $abstime );
        JMax_AC_cnt=JMax_AC_cnt-1;
        $fclose(outfile);
      end
   end

//      JMax_DC
   JMax_DC = I_A / w;
   if((JMax_DC_cnt>0) || ( maxEv_flg==0 ))   begin
      if( (JMax_DC < -1600) && (JMax_DC_retc!=-1))
      begin
        outfile=$fopen(errFileName,"a");
        $strobe("rmtp          JMax_DC leaving   OCA (  .. -1.600 mA/um ) at %7.4r  %M", $abstime );
        $fwrite(outfile,"rmtp          JMax_DC leaving   OCA (  .. -1.600 mA/um ) at %7.4r  %M\n", $abstime );
        JMax_DC_retc=-1;
        JMax_DC_cnt=JMax_DC_cnt-1;
        $fclose(outfile);
      end
      if((JMax_DC >= -1600) &&  (JMax_DC <= 1600) && (JMax_DC_retc!=0))
      begin
        outfile=$fopen(errFileName,"a");
        $strobe("rmtp          JMax_DC entering SOCA ( -1.600 mA/um .. 1.600 mA/um ) at %7.4r  %M", $abstime );
        $fwrite(outfile,"rmtp          JMax_DC entering SOCA ( -1.600 mA/um .. 1.600 mA/um ) at %7.4r  %M\n", $abstime );
        JMax_DC_retc=0;
        JMax_DC_cnt=JMax_DC_cnt-1;
        $fclose(outfile);
      end
      if((JMax_DC > 1600) &&  (JMax_DC_retc!=1))
      begin
        outfile=$fopen(errFileName,"a");
        $strobe("rmtp          JMax_DC leaving   OCA ( 1.600 mA/um ..  ) at %7.4r  %M", $abstime );
        $fwrite(outfile,"rmtp          JMax_DC leaving   OCA ( 1.600 mA/um ..  ) at %7.4r  %M\n", $abstime );
        JMax_DC_retc=1;
        JMax_DC_cnt=JMax_DC_cnt-1;
        $fclose(outfile);
      end
   end
   else
   begin
      if(JMax_DC_cnt==0)
      begin
        outfile=$fopen(errFileName,"a");
        $strobe("rmtp          JMax_DC error limit ( %d ) reached at %7.4r  %M", maxEv, $abstime );
        $fwrite(outfile,"rmtp          JMax_DC error limit ( %d ) reached at %7.4r  %M\n", maxEv, $abstime );
        JMax_DC_cnt=JMax_DC_cnt-1;
        $fclose(outfile);
      end
   end

end // analog
endmodule // rmtp

// Verilog-A OC Watch for device rmtpl Parameters  VA VB JMax_AC JMax_DC
module rmtpl_ahdl(A1,B1,A,B);
parameter tstep_occ=100n;
parameter errFileName="./occ.err";
parameter w = 1u;
parameter maxEv = 25;
parameter maxEv_flg = 0;
inout A1,B1,A,B;
electrical A1,B1,A,B;

integer outfile;
real V_B;
real V_A;
real I_B;
real I_A;
real VA;
integer VA_retc;
integer VA_cnt;
real VB;
integer VB_retc;
integer VB_cnt;
real JMax_AC;
integer JMax_AC_retc;
integer JMax_AC_cnt;
real JMax_DC;
integer JMax_DC_retc;
integer JMax_DC_cnt;

analog begin
   $bound_step( tstep_occ );
   @(initial_step) begin
      VA_retc=0;
      VA_cnt = maxEv;
      VB_retc=0;
      VB_cnt = maxEv;
      JMax_AC_retc=0;
      JMax_AC_cnt = maxEv;
      JMax_DC_retc=0;
      JMax_DC_cnt = maxEv;
   end
   V_B = V(B);
   V_A = V(A);
   I_B = I(B1,B);
   I_A = I(A1,A);

//      VA
   VA = V_A;
   if((VA_cnt>0) || ( maxEv_flg==0 ))   begin
      if( (VA < -200) && (VA_retc!=-1))
      begin
        outfile=$fopen(errFileName,"a");
        $strobe("rmtpl         VA      leaving   OCA (  .. -200.000 V ) at %7.4r  %M", $abstime );
        $fwrite(outfile,"rmtpl         VA      leaving   OCA (  .. -200.000 V ) at %7.4r  %M\n", $abstime );
        VA_retc=-1;
        VA_cnt=VA_cnt-1;
        $fclose(outfile);
      end
      if((VA >= -200) &&  (VA <= 200) && (VA_retc!=0))
      begin
        outfile=$fopen(errFileName,"a");
        $strobe("rmtpl         VA      entering SOCA ( -200.000 V .. 200.000 V ) at %7.4r  %M", $abstime );
        $fwrite(outfile,"rmtpl         VA      entering SOCA ( -200.000 V .. 200.000 V ) at %7.4r  %M\n", $abstime );
        VA_retc=0;
        VA_cnt=VA_cnt-1;
        $fclose(outfile);
      end
      if((VA > 200) &&  (VA_retc!=1))
      begin
        outfile=$fopen(errFileName,"a");
        $strobe("rmtpl         VA      leaving   OCA ( 200.000 V ..  ) at %7.4r  %M", $abstime );
        $fwrite(outfile,"rmtpl         VA      leaving   OCA ( 200.000 V ..  ) at %7.4r  %M\n", $abstime );
        VA_retc=1;
        VA_cnt=VA_cnt-1;
        $fclose(outfile);
      end
   end
   else
   begin
      if(VA_cnt==0)
      begin
        outfile=$fopen(errFileName,"a");
        $strobe("rmtpl         VA      error limit ( %d ) reached at %7.4r  %M", maxEv, $abstime );
        $fwrite(outfile,"rmtpl         VA      error limit ( %d ) reached at %7.4r  %M\n", maxEv, $abstime );
        VA_cnt=VA_cnt-1;
        $fclose(outfile);
      end
   end

//      VB
   VB = V_B;
   if((VB_cnt>0) || ( maxEv_flg==0 ))   begin
      if( (VB < -200) && (VB_retc!=-1))
      begin
        outfile=$fopen(errFileName,"a");
        $strobe("rmtpl         VB      leaving   OCA (  .. -200.000 V ) at %7.4r  %M", $abstime );
        $fwrite(outfile,"rmtpl         VB      leaving   OCA (  .. -200.000 V ) at %7.4r  %M\n", $abstime );
        VB_retc=-1;
        VB_cnt=VB_cnt-1;
        $fclose(outfile);
      end
      if((VB >= -200) &&  (VB <= 200) && (VB_retc!=0))
      begin
        outfile=$fopen(errFileName,"a");
        $strobe("rmtpl         VB      entering SOCA ( -200.000 V .. 200.000 V ) at %7.4r  %M", $abstime );
        $fwrite(outfile,"rmtpl         VB      entering SOCA ( -200.000 V .. 200.000 V ) at %7.4r  %M\n", $abstime );
        VB_retc=0;
        VB_cnt=VB_cnt-1;
        $fclose(outfile);
      end
      if((VB > 200) &&  (VB_retc!=1))
      begin
        outfile=$fopen(errFileName,"a");
        $strobe("rmtpl         VB      leaving   OCA ( 200.000 V ..  ) at %7.4r  %M", $abstime );
        $fwrite(outfile,"rmtpl         VB      leaving   OCA ( 200.000 V ..  ) at %7.4r  %M\n", $abstime );
        VB_retc=1;
        VB_cnt=VB_cnt-1;
        $fclose(outfile);
      end
   end
   else
   begin
      if(VB_cnt==0)
      begin
        outfile=$fopen(errFileName,"a");
        $strobe("rmtpl         VB      error limit ( %d ) reached at %7.4r  %M", maxEv, $abstime );
        $fwrite(outfile,"rmtpl         VB      error limit ( %d ) reached at %7.4r  %M\n", maxEv, $abstime );
        VB_cnt=VB_cnt-1;
        $fclose(outfile);
      end
   end

//      JMax_AC
   JMax_AC = I_A / w;
   if((JMax_AC_cnt>0) || ( maxEv_flg==0 ))   begin
      if( (JMax_AC < -10000) && (JMax_AC_retc!=-1))
      begin
        outfile=$fopen(errFileName,"a");
        $strobe("rmtpl         JMax_AC leaving   OCA (  .. -10.000 mA/um ) at %7.4r  %M", $abstime );
        $fwrite(outfile,"rmtpl         JMax_AC leaving   OCA (  .. -10.000 mA/um ) at %7.4r  %M\n", $abstime );
        JMax_AC_retc=-1;
        JMax_AC_cnt=JMax_AC_cnt-1;
        $fclose(outfile);
      end
      if((JMax_AC >= -10000) &&  (JMax_AC <= 10000) && (JMax_AC_retc!=0))
      begin
        outfile=$fopen(errFileName,"a");
        $strobe("rmtpl         JMax_AC entering SOCA ( -10.000 mA/um .. 10.000 mA/um ) at %7.4r  %M", $abstime );
        $fwrite(outfile,"rmtpl         JMax_AC entering SOCA ( -10.000 mA/um .. 10.000 mA/um ) at %7.4r  %M\n", $abstime );
        JMax_AC_retc=0;
        JMax_AC_cnt=JMax_AC_cnt-1;
        $fclose(outfile);
      end
      if((JMax_AC > 10000) &&  (JMax_AC_retc!=1))
      begin
        outfile=$fopen(errFileName,"a");
        $strobe("rmtpl         JMax_AC leaving   OCA ( 10.000 mA/um ..  ) at %7.4r  %M", $abstime );
        $fwrite(outfile,"rmtpl         JMax_AC leaving   OCA ( 10.000 mA/um ..  ) at %7.4r  %M\n", $abstime );
        JMax_AC_retc=1;
        JMax_AC_cnt=JMax_AC_cnt-1;
        $fclose(outfile);
      end
   end
   else
   begin
      if(JMax_AC_cnt==0)
      begin
        outfile=$fopen(errFileName,"a");
        $strobe("rmtpl         JMax_AC error limit ( %d ) reached at %7.4r  %M", maxEv, $abstime );
        $fwrite(outfile,"rmtpl         JMax_AC error limit ( %d ) reached at %7.4r  %M\n", maxEv, $abstime );
        JMax_AC_cnt=JMax_AC_cnt-1;
        $fclose(outfile);
      end
   end

//      JMax_DC
   JMax_DC = I_A / w;
   if((JMax_DC_cnt>0) || ( maxEv_flg==0 ))   begin
      if( (JMax_DC < -6000) && (JMax_DC_retc!=-1))
      begin
        outfile=$fopen(errFileName,"a");
        $strobe("rmtpl         JMax_DC leaving   OCA (  .. -6.000 mA/um ) at %7.4r  %M", $abstime );
        $fwrite(outfile,"rmtpl         JMax_DC leaving   OCA (  .. -6.000 mA/um ) at %7.4r  %M\n", $abstime );
        JMax_DC_retc=-1;
        JMax_DC_cnt=JMax_DC_cnt-1;
        $fclose(outfile);
      end
      if((JMax_DC >= -6000) &&  (JMax_DC <= 6000) && (JMax_DC_retc!=0))
      begin
        outfile=$fopen(errFileName,"a");
        $strobe("rmtpl         JMax_DC entering SOCA ( -6.000 mA/um .. 6.000 mA/um ) at %7.4r  %M", $abstime );
        $fwrite(outfile,"rmtpl         JMax_DC entering SOCA ( -6.000 mA/um .. 6.000 mA/um ) at %7.4r  %M\n", $abstime );
        JMax_DC_retc=0;
        JMax_DC_cnt=JMax_DC_cnt-1;
        $fclose(outfile);
      end
      if((JMax_DC > 6000) &&  (JMax_DC_retc!=1))
      begin
        outfile=$fopen(errFileName,"a");
        $strobe("rmtpl         JMax_DC leaving   OCA ( 6.000 mA/um ..  ) at %7.4r  %M", $abstime );
        $fwrite(outfile,"rmtpl         JMax_DC leaving   OCA ( 6.000 mA/um ..  ) at %7.4r  %M\n", $abstime );
        JMax_DC_retc=1;
        JMax_DC_cnt=JMax_DC_cnt-1;
        $fclose(outfile);
      end
   end
   else
   begin
      if(JMax_DC_cnt==0)
      begin
        outfile=$fopen(errFileName,"a");
        $strobe("rmtpl         JMax_DC error limit ( %d ) reached at %7.4r  %M", maxEv, $abstime );
        $fwrite(outfile,"rmtpl         JMax_DC error limit ( %d ) reached at %7.4r  %M\n", maxEv, $abstime );
        JMax_DC_cnt=JMax_DC_cnt-1;
        $fclose(outfile);
      end
   end

end // analog
endmodule // rmtpl

// Verilog-A OC Watch for device rmrdl Parameters  VA VB JDL
module rmrdl_ahdl(A1,B1,A,B);
parameter tstep_occ=100n;
parameter errFileName="./occ.err";
parameter w = 1u;
parameter maxEv = 25;
parameter maxEv_flg = 0;
inout A1,B1,A,B;
electrical A1,B1,A,B;

integer outfile;
real V_B;
real V_A;
real I_B;
real I_A;
real VA;
integer VA_retc;
integer VA_cnt;
real VB;
integer VB_retc;
integer VB_cnt;
real JDL;
integer JDL_retc;
integer JDL_cnt;

analog begin
   $bound_step( tstep_occ );
   @(initial_step) begin
      VA_retc=0;
      VA_cnt = maxEv;
      VB_retc=0;
      VB_cnt = maxEv;
      JDL_retc=0;
      JDL_cnt = maxEv;
   end
   V_B = V(B);
   V_A = V(A);
   I_B = I(B1,B);
   I_A = I(A1,A);

//      VA
   VA = V_A;
   if((VA_cnt>0) || ( maxEv_flg==0 ))   begin
      if( (VA < -200) && (VA_retc!=-1))
      begin
        outfile=$fopen(errFileName,"a");
        $strobe("rmrdl         VA      leaving   OCA (  .. -200.000 V ) at %7.4r  %M", $abstime );
        $fwrite(outfile,"rmrdl         VA      leaving   OCA (  .. -200.000 V ) at %7.4r  %M\n", $abstime );
        VA_retc=-1;
        VA_cnt=VA_cnt-1;
        $fclose(outfile);
      end
      if((VA >= -200) &&  (VA <= 200) && (VA_retc!=0))
      begin
        outfile=$fopen(errFileName,"a");
        $strobe("rmrdl         VA      entering SOCA ( -200.000 V .. 200.000 V ) at %7.4r  %M", $abstime );
        $fwrite(outfile,"rmrdl         VA      entering SOCA ( -200.000 V .. 200.000 V ) at %7.4r  %M\n", $abstime );
        VA_retc=0;
        VA_cnt=VA_cnt-1;
        $fclose(outfile);
      end
      if((VA > 200) &&  (VA_retc!=1))
      begin
        outfile=$fopen(errFileName,"a");
        $strobe("rmrdl         VA      leaving   OCA ( 200.000 V ..  ) at %7.4r  %M", $abstime );
        $fwrite(outfile,"rmrdl         VA      leaving   OCA ( 200.000 V ..  ) at %7.4r  %M\n", $abstime );
        VA_retc=1;
        VA_cnt=VA_cnt-1;
        $fclose(outfile);
      end
   end
   else
   begin
      if(VA_cnt==0)
      begin
        outfile=$fopen(errFileName,"a");
        $strobe("rmrdl         VA      error limit ( %d ) reached at %7.4r  %M", maxEv, $abstime );
        $fwrite(outfile,"rmrdl         VA      error limit ( %d ) reached at %7.4r  %M\n", maxEv, $abstime );
        VA_cnt=VA_cnt-1;
        $fclose(outfile);
      end
   end

//      VB
   VB = V_B;
   if((VB_cnt>0) || ( maxEv_flg==0 ))   begin
      if( (VB < -200) && (VB_retc!=-1))
      begin
        outfile=$fopen(errFileName,"a");
        $strobe("rmrdl         VB      leaving   OCA (  .. -200.000 V ) at %7.4r  %M", $abstime );
        $fwrite(outfile,"rmrdl         VB      leaving   OCA (  .. -200.000 V ) at %7.4r  %M\n", $abstime );
        VB_retc=-1;
        VB_cnt=VB_cnt-1;
        $fclose(outfile);
      end
      if((VB >= -200) &&  (VB <= 200) && (VB_retc!=0))
      begin
        outfile=$fopen(errFileName,"a");
        $strobe("rmrdl         VB      entering SOCA ( -200.000 V .. 200.000 V ) at %7.4r  %M", $abstime );
        $fwrite(outfile,"rmrdl         VB      entering SOCA ( -200.000 V .. 200.000 V ) at %7.4r  %M\n", $abstime );
        VB_retc=0;
        VB_cnt=VB_cnt-1;
        $fclose(outfile);
      end
      if((VB > 200) &&  (VB_retc!=1))
      begin
        outfile=$fopen(errFileName,"a");
        $strobe("rmrdl         VB      leaving   OCA ( 200.000 V ..  ) at %7.4r  %M", $abstime );
        $fwrite(outfile,"rmrdl         VB      leaving   OCA ( 200.000 V ..  ) at %7.4r  %M\n", $abstime );
        VB_retc=1;
        VB_cnt=VB_cnt-1;
        $fclose(outfile);
      end
   end
   else
   begin
      if(VB_cnt==0)
      begin
        outfile=$fopen(errFileName,"a");
        $strobe("rmrdl         VB      error limit ( %d ) reached at %7.4r  %M", maxEv, $abstime );
        $fwrite(outfile,"rmrdl         VB      error limit ( %d ) reached at %7.4r  %M\n", maxEv, $abstime );
        VB_cnt=VB_cnt-1;
        $fclose(outfile);
      end
   end

//      JDL
   JDL = I_A / w;
   if((JDL_cnt>0) || ( maxEv_flg==0 ))   begin
      if( (JDL < -25000) && (JDL_retc!=-1))
      begin
        outfile=$fopen(errFileName,"a");
        $strobe("rmrdl         JDL     leaving   OCA (  .. -25.000 mA/um ) at %7.4r  %M", $abstime );
        $fwrite(outfile,"rmrdl         JDL     leaving   OCA (  .. -25.000 mA/um ) at %7.4r  %M\n", $abstime );
        JDL_retc=-1;
        JDL_cnt=JDL_cnt-1;
        $fclose(outfile);
      end
      if((JDL >= -25000) &&  (JDL <= 25000) && (JDL_retc!=0))
      begin
        outfile=$fopen(errFileName,"a");
        $strobe("rmrdl         JDL     entering SOCA ( -25.000 mA/um .. 25.000 mA/um ) at %7.4r  %M", $abstime );
        $fwrite(outfile,"rmrdl         JDL     entering SOCA ( -25.000 mA/um .. 25.000 mA/um ) at %7.4r  %M\n", $abstime );
        JDL_retc=0;
        JDL_cnt=JDL_cnt-1;
        $fclose(outfile);
      end
      if((JDL > 25000) &&  (JDL_retc!=1))
      begin
        outfile=$fopen(errFileName,"a");
        $strobe("rmrdl         JDL     leaving   OCA ( 25.000 mA/um ..  ) at %7.4r  %M", $abstime );
        $fwrite(outfile,"rmrdl         JDL     leaving   OCA ( 25.000 mA/um ..  ) at %7.4r  %M\n", $abstime );
        JDL_retc=1;
        JDL_cnt=JDL_cnt-1;
        $fclose(outfile);
      end
   end
   else
   begin
      if(JDL_cnt==0)
      begin
        outfile=$fopen(errFileName,"a");
        $strobe("rmrdl         JDL     error limit ( %d ) reached at %7.4r  %M", maxEv, $abstime );
        $fwrite(outfile,"rmrdl         JDL     error limit ( %d ) reached at %7.4r  %M\n", maxEv, $abstime );
        JDL_cnt=JDL_cnt-1;
        $fclose(outfile);
      end
   end

end // analog
endmodule // rmrdl

// Verilog-A OC Watch for device rnp1 Parameters  VA VB JDL
module rnp1_ahdl(A1,B1,A,B);
parameter tstep_occ=100n;
parameter errFileName="./occ.err";
parameter w = 1u;
parameter maxEv = 25;
parameter maxEv_flg = 0;
inout A1,B1,A,B;
electrical A1,B1,A,B;

integer outfile;
real V_B;
real V_A;
real I_B;
real I_A;
real VA;
integer VA_retc;
integer VA_cnt;
real VB;
integer VB_retc;
integer VB_cnt;
real JDL;
integer JDL_retc;
integer JDL_cnt;

analog begin
   $bound_step( tstep_occ );
   @(initial_step) begin
      VA_retc=0;
      VA_cnt = maxEv;
      VB_retc=0;
      VB_cnt = maxEv;
      JDL_retc=0;
      JDL_cnt = maxEv;
   end
   V_B = V(B);
   V_A = V(A);
   I_B = I(B1,B);
   I_A = I(A1,A);

//      VA
   VA = V_A;
   if((VA_cnt>0) || ( maxEv_flg==0 ))   begin
      if( (VA < -60) && (VA_retc!=-1))
      begin
        outfile=$fopen(errFileName,"a");
        $strobe("rnp1          VA      leaving   OCA (  .. -60.000 V ) at %7.4r  %M", $abstime );
        $fwrite(outfile,"rnp1          VA      leaving   OCA (  .. -60.000 V ) at %7.4r  %M\n", $abstime );
        VA_retc=-1;
        VA_cnt=VA_cnt-1;
        $fclose(outfile);
      end
      if((VA >= -60) &&  (VA <= 60) && (VA_retc!=0))
      begin
        outfile=$fopen(errFileName,"a");
        $strobe("rnp1          VA      entering SOCA ( -60.000 V .. 60.000 V ) at %7.4r  %M", $abstime );
        $fwrite(outfile,"rnp1          VA      entering SOCA ( -60.000 V .. 60.000 V ) at %7.4r  %M\n", $abstime );
        VA_retc=0;
        VA_cnt=VA_cnt-1;
        $fclose(outfile);
      end
      if((VA > 60) &&  (VA_retc!=1))
      begin
        outfile=$fopen(errFileName,"a");
        $strobe("rnp1          VA      leaving   OCA ( 60.000 V ..  ) at %7.4r  %M", $abstime );
        $fwrite(outfile,"rnp1          VA      leaving   OCA ( 60.000 V ..  ) at %7.4r  %M\n", $abstime );
        VA_retc=1;
        VA_cnt=VA_cnt-1;
        $fclose(outfile);
      end
   end
   else
   begin
      if(VA_cnt==0)
      begin
        outfile=$fopen(errFileName,"a");
        $strobe("rnp1          VA      error limit ( %d ) reached at %7.4r  %M", maxEv, $abstime );
        $fwrite(outfile,"rnp1          VA      error limit ( %d ) reached at %7.4r  %M\n", maxEv, $abstime );
        VA_cnt=VA_cnt-1;
        $fclose(outfile);
      end
   end

//      VB
   VB = V_B;
   if((VB_cnt>0) || ( maxEv_flg==0 ))   begin
      if( (VB < -60) && (VB_retc!=-1))
      begin
        outfile=$fopen(errFileName,"a");
        $strobe("rnp1          VB      leaving   OCA (  .. -60.000 V ) at %7.4r  %M", $abstime );
        $fwrite(outfile,"rnp1          VB      leaving   OCA (  .. -60.000 V ) at %7.4r  %M\n", $abstime );
        VB_retc=-1;
        VB_cnt=VB_cnt-1;
        $fclose(outfile);
      end
      if((VB >= -60) &&  (VB <= 60) && (VB_retc!=0))
      begin
        outfile=$fopen(errFileName,"a");
        $strobe("rnp1          VB      entering SOCA ( -60.000 V .. 60.000 V ) at %7.4r  %M", $abstime );
        $fwrite(outfile,"rnp1          VB      entering SOCA ( -60.000 V .. 60.000 V ) at %7.4r  %M\n", $abstime );
        VB_retc=0;
        VB_cnt=VB_cnt-1;
        $fclose(outfile);
      end
      if((VB > 60) &&  (VB_retc!=1))
      begin
        outfile=$fopen(errFileName,"a");
        $strobe("rnp1          VB      leaving   OCA ( 60.000 V ..  ) at %7.4r  %M", $abstime );
        $fwrite(outfile,"rnp1          VB      leaving   OCA ( 60.000 V ..  ) at %7.4r  %M\n", $abstime );
        VB_retc=1;
        VB_cnt=VB_cnt-1;
        $fclose(outfile);
      end
   end
   else
   begin
      if(VB_cnt==0)
      begin
        outfile=$fopen(errFileName,"a");
        $strobe("rnp1          VB      error limit ( %d ) reached at %7.4r  %M", maxEv, $abstime );
        $fwrite(outfile,"rnp1          VB      error limit ( %d ) reached at %7.4r  %M\n", maxEv, $abstime );
        VB_cnt=VB_cnt-1;
        $fclose(outfile);
      end
   end

//      JDL
   JDL = I_A / w;
   if((JDL_cnt>0) || ( maxEv_flg==0 ))   begin
      if( (JDL < -450) && (JDL_retc!=-1))
      begin
        outfile=$fopen(errFileName,"a");
        $strobe("rnp1          JDL     leaving   OCA (  .. -0.450 mA/um ) at %7.4r  %M", $abstime );
        $fwrite(outfile,"rnp1          JDL     leaving   OCA (  .. -0.450 mA/um ) at %7.4r  %M\n", $abstime );
        JDL_retc=-1;
        JDL_cnt=JDL_cnt-1;
        $fclose(outfile);
      end
      if((JDL >= -450) &&  (JDL <= 450) && (JDL_retc!=0))
      begin
        outfile=$fopen(errFileName,"a");
        $strobe("rnp1          JDL     entering SOCA ( -0.450 mA/um .. 0.450 mA/um ) at %7.4r  %M", $abstime );
        $fwrite(outfile,"rnp1          JDL     entering SOCA ( -0.450 mA/um .. 0.450 mA/um ) at %7.4r  %M\n", $abstime );
        JDL_retc=0;
        JDL_cnt=JDL_cnt-1;
        $fclose(outfile);
      end
      if((JDL > 450) &&  (JDL_retc!=1))
      begin
        outfile=$fopen(errFileName,"a");
        $strobe("rnp1          JDL     leaving   OCA ( 0.450 mA/um ..  ) at %7.4r  %M", $abstime );
        $fwrite(outfile,"rnp1          JDL     leaving   OCA ( 0.450 mA/um ..  ) at %7.4r  %M\n", $abstime );
        JDL_retc=1;
        JDL_cnt=JDL_cnt-1;
        $fclose(outfile);
      end
   end
   else
   begin
      if(JDL_cnt==0)
      begin
        outfile=$fopen(errFileName,"a");
        $strobe("rnp1          JDL     error limit ( %d ) reached at %7.4r  %M", maxEv, $abstime );
        $fwrite(outfile,"rnp1          JDL     error limit ( %d ) reached at %7.4r  %M\n", maxEv, $abstime );
        JDL_cnt=JDL_cnt-1;
        $fclose(outfile);
      end
   end

end // analog
endmodule // rnp1

// Verilog-A OC Watch for device rpp1 Parameters  VA VB JDL
module rpp1_ahdl(A1,B1,A,B);
parameter tstep_occ=100n;
parameter errFileName="./occ.err";
parameter w = 1u;
parameter maxEv = 25;
parameter maxEv_flg = 0;
inout A1,B1,A,B;
electrical A1,B1,A,B;

integer outfile;
real V_B;
real V_A;
real I_B;
real I_A;
real VA;
integer VA_retc;
integer VA_cnt;
real VB;
integer VB_retc;
integer VB_cnt;
real JDL;
integer JDL_retc;
integer JDL_cnt;

analog begin
   $bound_step( tstep_occ );
   @(initial_step) begin
      VA_retc=0;
      VA_cnt = maxEv;
      VB_retc=0;
      VB_cnt = maxEv;
      JDL_retc=0;
      JDL_cnt = maxEv;
   end
   V_B = V(B);
   V_A = V(A);
   I_B = I(B1,B);
   I_A = I(A1,A);

//      VA
   VA = V_A;
   if((VA_cnt>0) || ( maxEv_flg==0 ))   begin
      if( (VA < -60) && (VA_retc!=-1))
      begin
        outfile=$fopen(errFileName,"a");
        $strobe("rpp1          VA      leaving   OCA (  .. -60.000 V ) at %7.4r  %M", $abstime );
        $fwrite(outfile,"rpp1          VA      leaving   OCA (  .. -60.000 V ) at %7.4r  %M\n", $abstime );
        VA_retc=-1;
        VA_cnt=VA_cnt-1;
        $fclose(outfile);
      end
      if((VA >= -60) &&  (VA <= 60) && (VA_retc!=0))
      begin
        outfile=$fopen(errFileName,"a");
        $strobe("rpp1          VA      entering SOCA ( -60.000 V .. 60.000 V ) at %7.4r  %M", $abstime );
        $fwrite(outfile,"rpp1          VA      entering SOCA ( -60.000 V .. 60.000 V ) at %7.4r  %M\n", $abstime );
        VA_retc=0;
        VA_cnt=VA_cnt-1;
        $fclose(outfile);
      end
      if((VA > 60) &&  (VA_retc!=1))
      begin
        outfile=$fopen(errFileName,"a");
        $strobe("rpp1          VA      leaving   OCA ( 60.000 V ..  ) at %7.4r  %M", $abstime );
        $fwrite(outfile,"rpp1          VA      leaving   OCA ( 60.000 V ..  ) at %7.4r  %M\n", $abstime );
        VA_retc=1;
        VA_cnt=VA_cnt-1;
        $fclose(outfile);
      end
   end
   else
   begin
      if(VA_cnt==0)
      begin
        outfile=$fopen(errFileName,"a");
        $strobe("rpp1          VA      error limit ( %d ) reached at %7.4r  %M", maxEv, $abstime );
        $fwrite(outfile,"rpp1          VA      error limit ( %d ) reached at %7.4r  %M\n", maxEv, $abstime );
        VA_cnt=VA_cnt-1;
        $fclose(outfile);
      end
   end

//      VB
   VB = V_B;
   if((VB_cnt>0) || ( maxEv_flg==0 ))   begin
      if( (VB < -60) && (VB_retc!=-1))
      begin
        outfile=$fopen(errFileName,"a");
        $strobe("rpp1          VB      leaving   OCA (  .. -60.000 V ) at %7.4r  %M", $abstime );
        $fwrite(outfile,"rpp1          VB      leaving   OCA (  .. -60.000 V ) at %7.4r  %M\n", $abstime );
        VB_retc=-1;
        VB_cnt=VB_cnt-1;
        $fclose(outfile);
      end
      if((VB >= -60) &&  (VB <= 60) && (VB_retc!=0))
      begin
        outfile=$fopen(errFileName,"a");
        $strobe("rpp1          VB      entering SOCA ( -60.000 V .. 60.000 V ) at %7.4r  %M", $abstime );
        $fwrite(outfile,"rpp1          VB      entering SOCA ( -60.000 V .. 60.000 V ) at %7.4r  %M\n", $abstime );
        VB_retc=0;
        VB_cnt=VB_cnt-1;
        $fclose(outfile);
      end
      if((VB > 60) &&  (VB_retc!=1))
      begin
        outfile=$fopen(errFileName,"a");
        $strobe("rpp1          VB      leaving   OCA ( 60.000 V ..  ) at %7.4r  %M", $abstime );
        $fwrite(outfile,"rpp1          VB      leaving   OCA ( 60.000 V ..  ) at %7.4r  %M\n", $abstime );
        VB_retc=1;
        VB_cnt=VB_cnt-1;
        $fclose(outfile);
      end
   end
   else
   begin
      if(VB_cnt==0)
      begin
        outfile=$fopen(errFileName,"a");
        $strobe("rpp1          VB      error limit ( %d ) reached at %7.4r  %M", maxEv, $abstime );
        $fwrite(outfile,"rpp1          VB      error limit ( %d ) reached at %7.4r  %M\n", maxEv, $abstime );
        VB_cnt=VB_cnt-1;
        $fclose(outfile);
      end
   end

//      JDL
   JDL = I_A / w;
   if((JDL_cnt>0) || ( maxEv_flg==0 ))   begin
      if( (JDL < -450) && (JDL_retc!=-1))
      begin
        outfile=$fopen(errFileName,"a");
        $strobe("rpp1          JDL     leaving   OCA (  .. -0.450 mA/um ) at %7.4r  %M", $abstime );
        $fwrite(outfile,"rpp1          JDL     leaving   OCA (  .. -0.450 mA/um ) at %7.4r  %M\n", $abstime );
        JDL_retc=-1;
        JDL_cnt=JDL_cnt-1;
        $fclose(outfile);
      end
      if((JDL >= -450) &&  (JDL <= 450) && (JDL_retc!=0))
      begin
        outfile=$fopen(errFileName,"a");
        $strobe("rpp1          JDL     entering SOCA ( -0.450 mA/um .. 0.450 mA/um ) at %7.4r  %M", $abstime );
        $fwrite(outfile,"rpp1          JDL     entering SOCA ( -0.450 mA/um .. 0.450 mA/um ) at %7.4r  %M\n", $abstime );
        JDL_retc=0;
        JDL_cnt=JDL_cnt-1;
        $fclose(outfile);
      end
      if((JDL > 450) &&  (JDL_retc!=1))
      begin
        outfile=$fopen(errFileName,"a");
        $strobe("rpp1          JDL     leaving   OCA ( 0.450 mA/um ..  ) at %7.4r  %M", $abstime );
        $fwrite(outfile,"rpp1          JDL     leaving   OCA ( 0.450 mA/um ..  ) at %7.4r  %M\n", $abstime );
        JDL_retc=1;
        JDL_cnt=JDL_cnt-1;
        $fclose(outfile);
      end
   end
   else
   begin
      if(JDL_cnt==0)
      begin
        outfile=$fopen(errFileName,"a");
        $strobe("rpp1          JDL     error limit ( %d ) reached at %7.4r  %M", maxEv, $abstime );
        $fwrite(outfile,"rpp1          JDL     error limit ( %d ) reached at %7.4r  %M\n", maxEv, $abstime );
        JDL_cnt=JDL_cnt-1;
        $fclose(outfile);
      end
   end

end // analog
endmodule // rpp1

// Verilog-A OC Watch for device rpp1s Parameters  VA VB JDL
module rpp1s_ahdl(A1,B1,A,B);
parameter tstep_occ=100n;
parameter errFileName="./occ.err";
parameter w = 1u;
parameter maxEv = 25;
parameter maxEv_flg = 0;
inout A1,B1,A,B;
electrical A1,B1,A,B;

integer outfile;
real V_B;
real V_A;
real I_B;
real I_A;
real VA;
integer VA_retc;
integer VA_cnt;
real VB;
integer VB_retc;
integer VB_cnt;
real JDL;
integer JDL_retc;
integer JDL_cnt;

analog begin
   $bound_step( tstep_occ );
   @(initial_step) begin
      VA_retc=0;
      VA_cnt = maxEv;
      VB_retc=0;
      VB_cnt = maxEv;
      JDL_retc=0;
      JDL_cnt = maxEv;
   end
   V_B = V(B);
   V_A = V(A);
   I_B = I(B1,B);
   I_A = I(A1,A);

//      VA
   VA = V_A;
   if((VA_cnt>0) || ( maxEv_flg==0 ))   begin
      if( (VA < -60) && (VA_retc!=-1))
      begin
        outfile=$fopen(errFileName,"a");
        $strobe("rpp1s         VA      leaving   OCA (  .. -60.000 V ) at %7.4r  %M", $abstime );
        $fwrite(outfile,"rpp1s         VA      leaving   OCA (  .. -60.000 V ) at %7.4r  %M\n", $abstime );
        VA_retc=-1;
        VA_cnt=VA_cnt-1;
        $fclose(outfile);
      end
      if((VA >= -60) &&  (VA <= 60) && (VA_retc!=0))
      begin
        outfile=$fopen(errFileName,"a");
        $strobe("rpp1s         VA      entering SOCA ( -60.000 V .. 60.000 V ) at %7.4r  %M", $abstime );
        $fwrite(outfile,"rpp1s         VA      entering SOCA ( -60.000 V .. 60.000 V ) at %7.4r  %M\n", $abstime );
        VA_retc=0;
        VA_cnt=VA_cnt-1;
        $fclose(outfile);
      end
      if((VA > 60) &&  (VA_retc!=1))
      begin
        outfile=$fopen(errFileName,"a");
        $strobe("rpp1s         VA      leaving   OCA ( 60.000 V ..  ) at %7.4r  %M", $abstime );
        $fwrite(outfile,"rpp1s         VA      leaving   OCA ( 60.000 V ..  ) at %7.4r  %M\n", $abstime );
        VA_retc=1;
        VA_cnt=VA_cnt-1;
        $fclose(outfile);
      end
   end
   else
   begin
      if(VA_cnt==0)
      begin
        outfile=$fopen(errFileName,"a");
        $strobe("rpp1s         VA      error limit ( %d ) reached at %7.4r  %M", maxEv, $abstime );
        $fwrite(outfile,"rpp1s         VA      error limit ( %d ) reached at %7.4r  %M\n", maxEv, $abstime );
        VA_cnt=VA_cnt-1;
        $fclose(outfile);
      end
   end

//      VB
   VB = V_B;
   if((VB_cnt>0) || ( maxEv_flg==0 ))   begin
      if( (VB < -60) && (VB_retc!=-1))
      begin
        outfile=$fopen(errFileName,"a");
        $strobe("rpp1s         VB      leaving   OCA (  .. -60.000 V ) at %7.4r  %M", $abstime );
        $fwrite(outfile,"rpp1s         VB      leaving   OCA (  .. -60.000 V ) at %7.4r  %M\n", $abstime );
        VB_retc=-1;
        VB_cnt=VB_cnt-1;
        $fclose(outfile);
      end
      if((VB >= -60) &&  (VB <= 60) && (VB_retc!=0))
      begin
        outfile=$fopen(errFileName,"a");
        $strobe("rpp1s         VB      entering SOCA ( -60.000 V .. 60.000 V ) at %7.4r  %M", $abstime );
        $fwrite(outfile,"rpp1s         VB      entering SOCA ( -60.000 V .. 60.000 V ) at %7.4r  %M\n", $abstime );
        VB_retc=0;
        VB_cnt=VB_cnt-1;
        $fclose(outfile);
      end
      if((VB > 60) &&  (VB_retc!=1))
      begin
        outfile=$fopen(errFileName,"a");
        $strobe("rpp1s         VB      leaving   OCA ( 60.000 V ..  ) at %7.4r  %M", $abstime );
        $fwrite(outfile,"rpp1s         VB      leaving   OCA ( 60.000 V ..  ) at %7.4r  %M\n", $abstime );
        VB_retc=1;
        VB_cnt=VB_cnt-1;
        $fclose(outfile);
      end
   end
   else
   begin
      if(VB_cnt==0)
      begin
        outfile=$fopen(errFileName,"a");
        $strobe("rpp1s         VB      error limit ( %d ) reached at %7.4r  %M", maxEv, $abstime );
        $fwrite(outfile,"rpp1s         VB      error limit ( %d ) reached at %7.4r  %M\n", maxEv, $abstime );
        VB_cnt=VB_cnt-1;
        $fclose(outfile);
      end
   end

//      JDL
   JDL = I_A / w;
   if((JDL_cnt>0) || ( maxEv_flg==0 ))   begin
      if( (JDL < -1000) && (JDL_retc!=-1))
      begin
        outfile=$fopen(errFileName,"a");
        $strobe("rpp1s         JDL     leaving   OCA (  .. -1.000 mA/um ) at %7.4r  %M", $abstime );
        $fwrite(outfile,"rpp1s         JDL     leaving   OCA (  .. -1.000 mA/um ) at %7.4r  %M\n", $abstime );
        JDL_retc=-1;
        JDL_cnt=JDL_cnt-1;
        $fclose(outfile);
      end
      if((JDL >= -1000) &&  (JDL <= 1000) && (JDL_retc!=0))
      begin
        outfile=$fopen(errFileName,"a");
        $strobe("rpp1s         JDL     entering SOCA ( -1.000 mA/um .. 1.000 mA/um ) at %7.4r  %M", $abstime );
        $fwrite(outfile,"rpp1s         JDL     entering SOCA ( -1.000 mA/um .. 1.000 mA/um ) at %7.4r  %M\n", $abstime );
        JDL_retc=0;
        JDL_cnt=JDL_cnt-1;
        $fclose(outfile);
      end
      if((JDL > 1000) &&  (JDL_retc!=1))
      begin
        outfile=$fopen(errFileName,"a");
        $strobe("rpp1s         JDL     leaving   OCA ( 1.000 mA/um ..  ) at %7.4r  %M", $abstime );
        $fwrite(outfile,"rpp1s         JDL     leaving   OCA ( 1.000 mA/um ..  ) at %7.4r  %M\n", $abstime );
        JDL_retc=1;
        JDL_cnt=JDL_cnt-1;
        $fclose(outfile);
      end
   end
   else
   begin
      if(JDL_cnt==0)
      begin
        outfile=$fopen(errFileName,"a");
        $strobe("rpp1s         JDL     error limit ( %d ) reached at %7.4r  %M", maxEv, $abstime );
        $fwrite(outfile,"rpp1s         JDL     error limit ( %d ) reached at %7.4r  %M\n", maxEv, $abstime );
        JDL_cnt=JDL_cnt-1;
        $fclose(outfile);
      end
   end

end // analog
endmodule // rpp1s

// Verilog-A OC Watch for device rnp1_3 Parameters  VAS VBS JDL
module rnp1_3_ahdl(A1,B1,S1,A,B,S);
parameter tstep_occ=100n;
parameter errFileName="./occ.err";
parameter w = 1u;
parameter maxEv = 25;
parameter maxEv_flg = 0;
inout A1,B1,S1,A,B,S;
electrical A1,B1,S1,A,B,S;

integer outfile;
real V_B_S;
real V_A_S;
real I_S;
real I_B;
real I_A;
real VAS;
integer VAS_retc;
integer VAS_cnt;
real VBS;
integer VBS_retc;
integer VBS_cnt;
real JDL;
integer JDL_retc;
integer JDL_cnt;

analog begin
   $bound_step( tstep_occ );
   @(initial_step) begin
      VAS_retc=0;
      VAS_cnt = maxEv;
      VBS_retc=0;
      VBS_cnt = maxEv;
      JDL_retc=0;
      JDL_cnt = maxEv;
   end
   V_B_S = V(B,S);
   V_A_S = V(A,S);
   I_S = I(S1,S);
   I_B = I(B1,B);
   I_A = I(A1,A);

//      VAS
   VAS = V_A_S;
   if((VAS_cnt>0) || ( maxEv_flg==0 ))   begin
      if( (VAS < -60) && (VAS_retc!=-1))
      begin
        outfile=$fopen(errFileName,"a");
        $strobe("rnp1_3        VAS     leaving   OCA (  .. -60.000 V ) at %7.4r  %M", $abstime );
        $fwrite(outfile,"rnp1_3        VAS     leaving   OCA (  .. -60.000 V ) at %7.4r  %M\n", $abstime );
        VAS_retc=-1;
        VAS_cnt=VAS_cnt-1;
        $fclose(outfile);
      end
      if((VAS >= -60) &&  (VAS <= 60) && (VAS_retc!=0))
      begin
        outfile=$fopen(errFileName,"a");
        $strobe("rnp1_3        VAS     entering SOCA ( -60.000 V .. 60.000 V ) at %7.4r  %M", $abstime );
        $fwrite(outfile,"rnp1_3        VAS     entering SOCA ( -60.000 V .. 60.000 V ) at %7.4r  %M\n", $abstime );
        VAS_retc=0;
        VAS_cnt=VAS_cnt-1;
        $fclose(outfile);
      end
      if((VAS > 60) &&  (VAS_retc!=1))
      begin
        outfile=$fopen(errFileName,"a");
        $strobe("rnp1_3        VAS     leaving   OCA ( 60.000 V ..  ) at %7.4r  %M", $abstime );
        $fwrite(outfile,"rnp1_3        VAS     leaving   OCA ( 60.000 V ..  ) at %7.4r  %M\n", $abstime );
        VAS_retc=1;
        VAS_cnt=VAS_cnt-1;
        $fclose(outfile);
      end
   end
   else
   begin
      if(VAS_cnt==0)
      begin
        outfile=$fopen(errFileName,"a");
        $strobe("rnp1_3        VAS     error limit ( %d ) reached at %7.4r  %M", maxEv, $abstime );
        $fwrite(outfile,"rnp1_3        VAS     error limit ( %d ) reached at %7.4r  %M\n", maxEv, $abstime );
        VAS_cnt=VAS_cnt-1;
        $fclose(outfile);
      end
   end

//      VBS
   VBS = V_B_S;
   if((VBS_cnt>0) || ( maxEv_flg==0 ))   begin
      if( (VBS < -60) && (VBS_retc!=-1))
      begin
        outfile=$fopen(errFileName,"a");
        $strobe("rnp1_3        VBS     leaving   OCA (  .. -60.000 V ) at %7.4r  %M", $abstime );
        $fwrite(outfile,"rnp1_3        VBS     leaving   OCA (  .. -60.000 V ) at %7.4r  %M\n", $abstime );
        VBS_retc=-1;
        VBS_cnt=VBS_cnt-1;
        $fclose(outfile);
      end
      if((VBS >= -60) &&  (VBS <= 60) && (VBS_retc!=0))
      begin
        outfile=$fopen(errFileName,"a");
        $strobe("rnp1_3        VBS     entering SOCA ( -60.000 V .. 60.000 V ) at %7.4r  %M", $abstime );
        $fwrite(outfile,"rnp1_3        VBS     entering SOCA ( -60.000 V .. 60.000 V ) at %7.4r  %M\n", $abstime );
        VBS_retc=0;
        VBS_cnt=VBS_cnt-1;
        $fclose(outfile);
      end
      if((VBS > 60) &&  (VBS_retc!=1))
      begin
        outfile=$fopen(errFileName,"a");
        $strobe("rnp1_3        VBS     leaving   OCA ( 60.000 V ..  ) at %7.4r  %M", $abstime );
        $fwrite(outfile,"rnp1_3        VBS     leaving   OCA ( 60.000 V ..  ) at %7.4r  %M\n", $abstime );
        VBS_retc=1;
        VBS_cnt=VBS_cnt-1;
        $fclose(outfile);
      end
   end
   else
   begin
      if(VBS_cnt==0)
      begin
        outfile=$fopen(errFileName,"a");
        $strobe("rnp1_3        VBS     error limit ( %d ) reached at %7.4r  %M", maxEv, $abstime );
        $fwrite(outfile,"rnp1_3        VBS     error limit ( %d ) reached at %7.4r  %M\n", maxEv, $abstime );
        VBS_cnt=VBS_cnt-1;
        $fclose(outfile);
      end
   end

//      JDL
   JDL = I_A / w;
   if((JDL_cnt>0) || ( maxEv_flg==0 ))   begin
      if( (JDL < -450) && (JDL_retc!=-1))
      begin
        outfile=$fopen(errFileName,"a");
        $strobe("rnp1_3        JDL     leaving   OCA (  .. -0.450 mA/um ) at %7.4r  %M", $abstime );
        $fwrite(outfile,"rnp1_3        JDL     leaving   OCA (  .. -0.450 mA/um ) at %7.4r  %M\n", $abstime );
        JDL_retc=-1;
        JDL_cnt=JDL_cnt-1;
        $fclose(outfile);
      end
      if((JDL >= -450) &&  (JDL <= 450) && (JDL_retc!=0))
      begin
        outfile=$fopen(errFileName,"a");
        $strobe("rnp1_3        JDL     entering SOCA ( -0.450 mA/um .. 0.450 mA/um ) at %7.4r  %M", $abstime );
        $fwrite(outfile,"rnp1_3        JDL     entering SOCA ( -0.450 mA/um .. 0.450 mA/um ) at %7.4r  %M\n", $abstime );
        JDL_retc=0;
        JDL_cnt=JDL_cnt-1;
        $fclose(outfile);
      end
      if((JDL > 450) &&  (JDL_retc!=1))
      begin
        outfile=$fopen(errFileName,"a");
        $strobe("rnp1_3        JDL     leaving   OCA ( 0.450 mA/um ..  ) at %7.4r  %M", $abstime );
        $fwrite(outfile,"rnp1_3        JDL     leaving   OCA ( 0.450 mA/um ..  ) at %7.4r  %M\n", $abstime );
        JDL_retc=1;
        JDL_cnt=JDL_cnt-1;
        $fclose(outfile);
      end
   end
   else
   begin
      if(JDL_cnt==0)
      begin
        outfile=$fopen(errFileName,"a");
        $strobe("rnp1_3        JDL     error limit ( %d ) reached at %7.4r  %M", maxEv, $abstime );
        $fwrite(outfile,"rnp1_3        JDL     error limit ( %d ) reached at %7.4r  %M\n", maxEv, $abstime );
        JDL_cnt=JDL_cnt-1;
        $fclose(outfile);
      end
   end

end // analog
endmodule // rnp1_3

// Verilog-A OC Watch for device rpp1_3 Parameters  VAS VBS JDL
module rpp1_3_ahdl(A1,B1,S1,A,B,S);
parameter tstep_occ=100n;
parameter errFileName="./occ.err";
parameter w = 1u;
parameter maxEv = 25;
parameter maxEv_flg = 0;
inout A1,B1,S1,A,B,S;
electrical A1,B1,S1,A,B,S;

integer outfile;
real V_B_S;
real V_A_S;
real I_S;
real I_B;
real I_A;
real VAS;
integer VAS_retc;
integer VAS_cnt;
real VBS;
integer VBS_retc;
integer VBS_cnt;
real JDL;
integer JDL_retc;
integer JDL_cnt;

analog begin
   $bound_step( tstep_occ );
   @(initial_step) begin
      VAS_retc=0;
      VAS_cnt = maxEv;
      VBS_retc=0;
      VBS_cnt = maxEv;
      JDL_retc=0;
      JDL_cnt = maxEv;
   end
   V_B_S = V(B,S);
   V_A_S = V(A,S);
   I_S = I(S1,S);
   I_B = I(B1,B);
   I_A = I(A1,A);

//      VAS
   VAS = V_A_S;
   if((VAS_cnt>0) || ( maxEv_flg==0 ))   begin
      if( (VAS < -60) && (VAS_retc!=-1))
      begin
        outfile=$fopen(errFileName,"a");
        $strobe("rpp1_3        VAS     leaving   OCA (  .. -60.000 V ) at %7.4r  %M", $abstime );
        $fwrite(outfile,"rpp1_3        VAS     leaving   OCA (  .. -60.000 V ) at %7.4r  %M\n", $abstime );
        VAS_retc=-1;
        VAS_cnt=VAS_cnt-1;
        $fclose(outfile);
      end
      if((VAS >= -60) &&  (VAS <= 60) && (VAS_retc!=0))
      begin
        outfile=$fopen(errFileName,"a");
        $strobe("rpp1_3        VAS     entering SOCA ( -60.000 V .. 60.000 V ) at %7.4r  %M", $abstime );
        $fwrite(outfile,"rpp1_3        VAS     entering SOCA ( -60.000 V .. 60.000 V ) at %7.4r  %M\n", $abstime );
        VAS_retc=0;
        VAS_cnt=VAS_cnt-1;
        $fclose(outfile);
      end
      if((VAS > 60) &&  (VAS_retc!=1))
      begin
        outfile=$fopen(errFileName,"a");
        $strobe("rpp1_3        VAS     leaving   OCA ( 60.000 V ..  ) at %7.4r  %M", $abstime );
        $fwrite(outfile,"rpp1_3        VAS     leaving   OCA ( 60.000 V ..  ) at %7.4r  %M\n", $abstime );
        VAS_retc=1;
        VAS_cnt=VAS_cnt-1;
        $fclose(outfile);
      end
   end
   else
   begin
      if(VAS_cnt==0)
      begin
        outfile=$fopen(errFileName,"a");
        $strobe("rpp1_3        VAS     error limit ( %d ) reached at %7.4r  %M", maxEv, $abstime );
        $fwrite(outfile,"rpp1_3        VAS     error limit ( %d ) reached at %7.4r  %M\n", maxEv, $abstime );
        VAS_cnt=VAS_cnt-1;
        $fclose(outfile);
      end
   end

//      VBS
   VBS = V_B_S;
   if((VBS_cnt>0) || ( maxEv_flg==0 ))   begin
      if( (VBS < -60) && (VBS_retc!=-1))
      begin
        outfile=$fopen(errFileName,"a");
        $strobe("rpp1_3        VBS     leaving   OCA (  .. -60.000 V ) at %7.4r  %M", $abstime );
        $fwrite(outfile,"rpp1_3        VBS     leaving   OCA (  .. -60.000 V ) at %7.4r  %M\n", $abstime );
        VBS_retc=-1;
        VBS_cnt=VBS_cnt-1;
        $fclose(outfile);
      end
      if((VBS >= -60) &&  (VBS <= 60) && (VBS_retc!=0))
      begin
        outfile=$fopen(errFileName,"a");
        $strobe("rpp1_3        VBS     entering SOCA ( -60.000 V .. 60.000 V ) at %7.4r  %M", $abstime );
        $fwrite(outfile,"rpp1_3        VBS     entering SOCA ( -60.000 V .. 60.000 V ) at %7.4r  %M\n", $abstime );
        VBS_retc=0;
        VBS_cnt=VBS_cnt-1;
        $fclose(outfile);
      end
      if((VBS > 60) &&  (VBS_retc!=1))
      begin
        outfile=$fopen(errFileName,"a");
        $strobe("rpp1_3        VBS     leaving   OCA ( 60.000 V ..  ) at %7.4r  %M", $abstime );
        $fwrite(outfile,"rpp1_3        VBS     leaving   OCA ( 60.000 V ..  ) at %7.4r  %M\n", $abstime );
        VBS_retc=1;
        VBS_cnt=VBS_cnt-1;
        $fclose(outfile);
      end
   end
   else
   begin
      if(VBS_cnt==0)
      begin
        outfile=$fopen(errFileName,"a");
        $strobe("rpp1_3        VBS     error limit ( %d ) reached at %7.4r  %M", maxEv, $abstime );
        $fwrite(outfile,"rpp1_3        VBS     error limit ( %d ) reached at %7.4r  %M\n", maxEv, $abstime );
        VBS_cnt=VBS_cnt-1;
        $fclose(outfile);
      end
   end

//      JDL
   JDL = I_A / w;
   if((JDL_cnt>0) || ( maxEv_flg==0 ))   begin
      if( (JDL < -450) && (JDL_retc!=-1))
      begin
        outfile=$fopen(errFileName,"a");
        $strobe("rpp1_3        JDL     leaving   OCA (  .. -0.450 mA/um ) at %7.4r  %M", $abstime );
        $fwrite(outfile,"rpp1_3        JDL     leaving   OCA (  .. -0.450 mA/um ) at %7.4r  %M\n", $abstime );
        JDL_retc=-1;
        JDL_cnt=JDL_cnt-1;
        $fclose(outfile);
      end
      if((JDL >= -450) &&  (JDL <= 450) && (JDL_retc!=0))
      begin
        outfile=$fopen(errFileName,"a");
        $strobe("rpp1_3        JDL     entering SOCA ( -0.450 mA/um .. 0.450 mA/um ) at %7.4r  %M", $abstime );
        $fwrite(outfile,"rpp1_3        JDL     entering SOCA ( -0.450 mA/um .. 0.450 mA/um ) at %7.4r  %M\n", $abstime );
        JDL_retc=0;
        JDL_cnt=JDL_cnt-1;
        $fclose(outfile);
      end
      if((JDL > 450) &&  (JDL_retc!=1))
      begin
        outfile=$fopen(errFileName,"a");
        $strobe("rpp1_3        JDL     leaving   OCA ( 0.450 mA/um ..  ) at %7.4r  %M", $abstime );
        $fwrite(outfile,"rpp1_3        JDL     leaving   OCA ( 0.450 mA/um ..  ) at %7.4r  %M\n", $abstime );
        JDL_retc=1;
        JDL_cnt=JDL_cnt-1;
        $fclose(outfile);
      end
   end
   else
   begin
      if(JDL_cnt==0)
      begin
        outfile=$fopen(errFileName,"a");
        $strobe("rpp1_3        JDL     error limit ( %d ) reached at %7.4r  %M", maxEv, $abstime );
        $fwrite(outfile,"rpp1_3        JDL     error limit ( %d ) reached at %7.4r  %M\n", maxEv, $abstime );
        JDL_cnt=JDL_cnt-1;
        $fclose(outfile);
      end
   end

end // analog
endmodule // rpp1_3

// Verilog-A OC Watch for device rpp1s_3 Parameters  VAS VBS JDL
module rpp1s_3_ahdl(A1,B1,S1,A,B,S);
parameter tstep_occ=100n;
parameter errFileName="./occ.err";
parameter w = 1u;
parameter maxEv = 25;
parameter maxEv_flg = 0;
inout A1,B1,S1,A,B,S;
electrical A1,B1,S1,A,B,S;

integer outfile;
real V_B_S;
real V_A_S;
real I_S;
real I_B;
real I_A;
real VAS;
integer VAS_retc;
integer VAS_cnt;
real VBS;
integer VBS_retc;
integer VBS_cnt;
real JDL;
integer JDL_retc;
integer JDL_cnt;

analog begin
   $bound_step( tstep_occ );
   @(initial_step) begin
      VAS_retc=0;
      VAS_cnt = maxEv;
      VBS_retc=0;
      VBS_cnt = maxEv;
      JDL_retc=0;
      JDL_cnt = maxEv;
   end
   V_B_S = V(B,S);
   V_A_S = V(A,S);
   I_S = I(S1,S);
   I_B = I(B1,B);
   I_A = I(A1,A);

//      VAS
   VAS = V_A_S;
   if((VAS_cnt>0) || ( maxEv_flg==0 ))   begin
      if( (VAS < -60) && (VAS_retc!=-1))
      begin
        outfile=$fopen(errFileName,"a");
        $strobe("rpp1s_3       VAS     leaving   OCA (  .. -60.000 V ) at %7.4r  %M", $abstime );
        $fwrite(outfile,"rpp1s_3       VAS     leaving   OCA (  .. -60.000 V ) at %7.4r  %M\n", $abstime );
        VAS_retc=-1;
        VAS_cnt=VAS_cnt-1;
        $fclose(outfile);
      end
      if((VAS >= -60) &&  (VAS <= 60) && (VAS_retc!=0))
      begin
        outfile=$fopen(errFileName,"a");
        $strobe("rpp1s_3       VAS     entering SOCA ( -60.000 V .. 60.000 V ) at %7.4r  %M", $abstime );
        $fwrite(outfile,"rpp1s_3       VAS     entering SOCA ( -60.000 V .. 60.000 V ) at %7.4r  %M\n", $abstime );
        VAS_retc=0;
        VAS_cnt=VAS_cnt-1;
        $fclose(outfile);
      end
      if((VAS > 60) &&  (VAS_retc!=1))
      begin
        outfile=$fopen(errFileName,"a");
        $strobe("rpp1s_3       VAS     leaving   OCA ( 60.000 V ..  ) at %7.4r  %M", $abstime );
        $fwrite(outfile,"rpp1s_3       VAS     leaving   OCA ( 60.000 V ..  ) at %7.4r  %M\n", $abstime );
        VAS_retc=1;
        VAS_cnt=VAS_cnt-1;
        $fclose(outfile);
      end
   end
   else
   begin
      if(VAS_cnt==0)
      begin
        outfile=$fopen(errFileName,"a");
        $strobe("rpp1s_3       VAS     error limit ( %d ) reached at %7.4r  %M", maxEv, $abstime );
        $fwrite(outfile,"rpp1s_3       VAS     error limit ( %d ) reached at %7.4r  %M\n", maxEv, $abstime );
        VAS_cnt=VAS_cnt-1;
        $fclose(outfile);
      end
   end

//      VBS
   VBS = V_B_S;
   if((VBS_cnt>0) || ( maxEv_flg==0 ))   begin
      if( (VBS < -60) && (VBS_retc!=-1))
      begin
        outfile=$fopen(errFileName,"a");
        $strobe("rpp1s_3       VBS     leaving   OCA (  .. -60.000 V ) at %7.4r  %M", $abstime );
        $fwrite(outfile,"rpp1s_3       VBS     leaving   OCA (  .. -60.000 V ) at %7.4r  %M\n", $abstime );
        VBS_retc=-1;
        VBS_cnt=VBS_cnt-1;
        $fclose(outfile);
      end
      if((VBS >= -60) &&  (VBS <= 60) && (VBS_retc!=0))
      begin
        outfile=$fopen(errFileName,"a");
        $strobe("rpp1s_3       VBS     entering SOCA ( -60.000 V .. 60.000 V ) at %7.4r  %M", $abstime );
        $fwrite(outfile,"rpp1s_3       VBS     entering SOCA ( -60.000 V .. 60.000 V ) at %7.4r  %M\n", $abstime );
        VBS_retc=0;
        VBS_cnt=VBS_cnt-1;
        $fclose(outfile);
      end
      if((VBS > 60) &&  (VBS_retc!=1))
      begin
        outfile=$fopen(errFileName,"a");
        $strobe("rpp1s_3       VBS     leaving   OCA ( 60.000 V ..  ) at %7.4r  %M", $abstime );
        $fwrite(outfile,"rpp1s_3       VBS     leaving   OCA ( 60.000 V ..  ) at %7.4r  %M\n", $abstime );
        VBS_retc=1;
        VBS_cnt=VBS_cnt-1;
        $fclose(outfile);
      end
   end
   else
   begin
      if(VBS_cnt==0)
      begin
        outfile=$fopen(errFileName,"a");
        $strobe("rpp1s_3       VBS     error limit ( %d ) reached at %7.4r  %M", maxEv, $abstime );
        $fwrite(outfile,"rpp1s_3       VBS     error limit ( %d ) reached at %7.4r  %M\n", maxEv, $abstime );
        VBS_cnt=VBS_cnt-1;
        $fclose(outfile);
      end
   end

//      JDL
   JDL = I_A / w;
   if((JDL_cnt>0) || ( maxEv_flg==0 ))   begin
      if( (JDL < -450) && (JDL_retc!=-1))
      begin
        outfile=$fopen(errFileName,"a");
        $strobe("rpp1s_3       JDL     leaving   OCA (  .. -0.450 mA/um ) at %7.4r  %M", $abstime );
        $fwrite(outfile,"rpp1s_3       JDL     leaving   OCA (  .. -0.450 mA/um ) at %7.4r  %M\n", $abstime );
        JDL_retc=-1;
        JDL_cnt=JDL_cnt-1;
        $fclose(outfile);
      end
      if((JDL >= -450) &&  (JDL <= 450) && (JDL_retc!=0))
      begin
        outfile=$fopen(errFileName,"a");
        $strobe("rpp1s_3       JDL     entering SOCA ( -0.450 mA/um .. 0.450 mA/um ) at %7.4r  %M", $abstime );
        $fwrite(outfile,"rpp1s_3       JDL     entering SOCA ( -0.450 mA/um .. 0.450 mA/um ) at %7.4r  %M\n", $abstime );
        JDL_retc=0;
        JDL_cnt=JDL_cnt-1;
        $fclose(outfile);
      end
      if((JDL > 450) &&  (JDL_retc!=1))
      begin
        outfile=$fopen(errFileName,"a");
        $strobe("rpp1s_3       JDL     leaving   OCA ( 0.450 mA/um ..  ) at %7.4r  %M", $abstime );
        $fwrite(outfile,"rpp1s_3       JDL     leaving   OCA ( 0.450 mA/um ..  ) at %7.4r  %M\n", $abstime );
        JDL_retc=1;
        JDL_cnt=JDL_cnt-1;
        $fclose(outfile);
      end
   end
   else
   begin
      if(JDL_cnt==0)
      begin
        outfile=$fopen(errFileName,"a");
        $strobe("rpp1s_3       JDL     error limit ( %d ) reached at %7.4r  %M", maxEv, $abstime );
        $fwrite(outfile,"rpp1s_3       JDL     error limit ( %d ) reached at %7.4r  %M\n", maxEv, $abstime );
        JDL_cnt=JDL_cnt-1;
        $fclose(outfile);
      end
   end

end // analog
endmodule // rpp1s_3

// Verilog-A OC Watch for device rpp1k1 Parameters  VA VB JDL
module rpp1k1_ahdl(A1,B1,A,B);
parameter tstep_occ=100n;
parameter errFileName="./occ.err";
parameter w = 1u;
parameter maxEv = 25;
parameter maxEv_flg = 0;
inout A1,B1,A,B;
electrical A1,B1,A,B;

integer outfile;
real V_B;
real V_A;
real I_B;
real I_A;
real VA;
integer VA_retc;
integer VA_cnt;
real VB;
integer VB_retc;
integer VB_cnt;
real JDL;
integer JDL_retc;
integer JDL_cnt;

analog begin
   $bound_step( tstep_occ );
   @(initial_step) begin
      VA_retc=0;
      VA_cnt = maxEv;
      VB_retc=0;
      VB_cnt = maxEv;
      JDL_retc=0;
      JDL_cnt = maxEv;
   end
   V_B = V(B);
   V_A = V(A);
   I_B = I(B1,B);
   I_A = I(A1,A);

//      VA
   VA = V_A;
   if((VA_cnt>0) || ( maxEv_flg==0 ))   begin
      if( (VA < -60) && (VA_retc!=-1))
      begin
        outfile=$fopen(errFileName,"a");
        $strobe("rpp1k1        VA      leaving   OCA (  .. -60.000 V ) at %7.4r  %M", $abstime );
        $fwrite(outfile,"rpp1k1        VA      leaving   OCA (  .. -60.000 V ) at %7.4r  %M\n", $abstime );
        VA_retc=-1;
        VA_cnt=VA_cnt-1;
        $fclose(outfile);
      end
      if((VA >= -60) &&  (VA <= 60) && (VA_retc!=0))
      begin
        outfile=$fopen(errFileName,"a");
        $strobe("rpp1k1        VA      entering SOCA ( -60.000 V .. 60.000 V ) at %7.4r  %M", $abstime );
        $fwrite(outfile,"rpp1k1        VA      entering SOCA ( -60.000 V .. 60.000 V ) at %7.4r  %M\n", $abstime );
        VA_retc=0;
        VA_cnt=VA_cnt-1;
        $fclose(outfile);
      end
      if((VA > 60) &&  (VA_retc!=1))
      begin
        outfile=$fopen(errFileName,"a");
        $strobe("rpp1k1        VA      leaving   OCA ( 60.000 V ..  ) at %7.4r  %M", $abstime );
        $fwrite(outfile,"rpp1k1        VA      leaving   OCA ( 60.000 V ..  ) at %7.4r  %M\n", $abstime );
        VA_retc=1;
        VA_cnt=VA_cnt-1;
        $fclose(outfile);
      end
   end
   else
   begin
      if(VA_cnt==0)
      begin
        outfile=$fopen(errFileName,"a");
        $strobe("rpp1k1        VA      error limit ( %d ) reached at %7.4r  %M", maxEv, $abstime );
        $fwrite(outfile,"rpp1k1        VA      error limit ( %d ) reached at %7.4r  %M\n", maxEv, $abstime );
        VA_cnt=VA_cnt-1;
        $fclose(outfile);
      end
   end

//      VB
   VB = V_B;
   if((VB_cnt>0) || ( maxEv_flg==0 ))   begin
      if( (VB < -60) && (VB_retc!=-1))
      begin
        outfile=$fopen(errFileName,"a");
        $strobe("rpp1k1        VB      leaving   OCA (  .. -60.000 V ) at %7.4r  %M", $abstime );
        $fwrite(outfile,"rpp1k1        VB      leaving   OCA (  .. -60.000 V ) at %7.4r  %M\n", $abstime );
        VB_retc=-1;
        VB_cnt=VB_cnt-1;
        $fclose(outfile);
      end
      if((VB >= -60) &&  (VB <= 60) && (VB_retc!=0))
      begin
        outfile=$fopen(errFileName,"a");
        $strobe("rpp1k1        VB      entering SOCA ( -60.000 V .. 60.000 V ) at %7.4r  %M", $abstime );
        $fwrite(outfile,"rpp1k1        VB      entering SOCA ( -60.000 V .. 60.000 V ) at %7.4r  %M\n", $abstime );
        VB_retc=0;
        VB_cnt=VB_cnt-1;
        $fclose(outfile);
      end
      if((VB > 60) &&  (VB_retc!=1))
      begin
        outfile=$fopen(errFileName,"a");
        $strobe("rpp1k1        VB      leaving   OCA ( 60.000 V ..  ) at %7.4r  %M", $abstime );
        $fwrite(outfile,"rpp1k1        VB      leaving   OCA ( 60.000 V ..  ) at %7.4r  %M\n", $abstime );
        VB_retc=1;
        VB_cnt=VB_cnt-1;
        $fclose(outfile);
      end
   end
   else
   begin
      if(VB_cnt==0)
      begin
        outfile=$fopen(errFileName,"a");
        $strobe("rpp1k1        VB      error limit ( %d ) reached at %7.4r  %M", maxEv, $abstime );
        $fwrite(outfile,"rpp1k1        VB      error limit ( %d ) reached at %7.4r  %M\n", maxEv, $abstime );
        VB_cnt=VB_cnt-1;
        $fclose(outfile);
      end
   end

//      JDL
   JDL = I_A / w;
   if((JDL_cnt>0) || ( maxEv_flg==0 ))   begin
      if( (JDL < -250) && (JDL_retc!=-1))
      begin
        outfile=$fopen(errFileName,"a");
        $strobe("rpp1k1        JDL     leaving   OCA (  .. -0.250 mA/um ) at %7.4r  %M", $abstime );
        $fwrite(outfile,"rpp1k1        JDL     leaving   OCA (  .. -0.250 mA/um ) at %7.4r  %M\n", $abstime );
        JDL_retc=-1;
        JDL_cnt=JDL_cnt-1;
        $fclose(outfile);
      end
      if((JDL >= -250) &&  (JDL <= 250) && (JDL_retc!=0))
      begin
        outfile=$fopen(errFileName,"a");
        $strobe("rpp1k1        JDL     entering SOCA ( -0.250 mA/um .. 0.250 mA/um ) at %7.4r  %M", $abstime );
        $fwrite(outfile,"rpp1k1        JDL     entering SOCA ( -0.250 mA/um .. 0.250 mA/um ) at %7.4r  %M\n", $abstime );
        JDL_retc=0;
        JDL_cnt=JDL_cnt-1;
        $fclose(outfile);
      end
      if((JDL > 250) &&  (JDL_retc!=1))
      begin
        outfile=$fopen(errFileName,"a");
        $strobe("rpp1k1        JDL     leaving   OCA ( 0.250 mA/um ..  ) at %7.4r  %M", $abstime );
        $fwrite(outfile,"rpp1k1        JDL     leaving   OCA ( 0.250 mA/um ..  ) at %7.4r  %M\n", $abstime );
        JDL_retc=1;
        JDL_cnt=JDL_cnt-1;
        $fclose(outfile);
      end
   end
   else
   begin
      if(JDL_cnt==0)
      begin
        outfile=$fopen(errFileName,"a");
        $strobe("rpp1k1        JDL     error limit ( %d ) reached at %7.4r  %M", maxEv, $abstime );
        $fwrite(outfile,"rpp1k1        JDL     error limit ( %d ) reached at %7.4r  %M\n", maxEv, $abstime );
        JDL_cnt=JDL_cnt-1;
        $fclose(outfile);
      end
   end

end // analog
endmodule // rpp1k1

// Verilog-A OC Watch for device rpp1k1_3 Parameters  VAS VBS JDL
module rpp1k1_3_ahdl(A1,B1,S1,A,B,S);
parameter tstep_occ=100n;
parameter errFileName="./occ.err";
parameter w = 1u;
parameter maxEv = 25;
parameter maxEv_flg = 0;
inout A1,B1,S1,A,B,S;
electrical A1,B1,S1,A,B,S;

integer outfile;
real V_B_S;
real V_A_S;
real I_S;
real I_B;
real I_A;
real VAS;
integer VAS_retc;
integer VAS_cnt;
real VBS;
integer VBS_retc;
integer VBS_cnt;
real JDL;
integer JDL_retc;
integer JDL_cnt;

analog begin
   $bound_step( tstep_occ );
   @(initial_step) begin
      VAS_retc=0;
      VAS_cnt = maxEv;
      VBS_retc=0;
      VBS_cnt = maxEv;
      JDL_retc=0;
      JDL_cnt = maxEv;
   end
   V_B_S = V(B,S);
   V_A_S = V(A,S);
   I_S = I(S1,S);
   I_B = I(B1,B);
   I_A = I(A1,A);

//      VAS
   VAS = V_A_S;
   if((VAS_cnt>0) || ( maxEv_flg==0 ))   begin
      if( (VAS < -60) && (VAS_retc!=-1))
      begin
        outfile=$fopen(errFileName,"a");
        $strobe("rpp1k1_3      VAS     leaving   OCA (  .. -60.000 V ) at %7.4r  %M", $abstime );
        $fwrite(outfile,"rpp1k1_3      VAS     leaving   OCA (  .. -60.000 V ) at %7.4r  %M\n", $abstime );
        VAS_retc=-1;
        VAS_cnt=VAS_cnt-1;
        $fclose(outfile);
      end
      if((VAS >= -60) &&  (VAS <= 60) && (VAS_retc!=0))
      begin
        outfile=$fopen(errFileName,"a");
        $strobe("rpp1k1_3      VAS     entering SOCA ( -60.000 V .. 60.000 V ) at %7.4r  %M", $abstime );
        $fwrite(outfile,"rpp1k1_3      VAS     entering SOCA ( -60.000 V .. 60.000 V ) at %7.4r  %M\n", $abstime );
        VAS_retc=0;
        VAS_cnt=VAS_cnt-1;
        $fclose(outfile);
      end
      if((VAS > 60) &&  (VAS_retc!=1))
      begin
        outfile=$fopen(errFileName,"a");
        $strobe("rpp1k1_3      VAS     leaving   OCA ( 60.000 V ..  ) at %7.4r  %M", $abstime );
        $fwrite(outfile,"rpp1k1_3      VAS     leaving   OCA ( 60.000 V ..  ) at %7.4r  %M\n", $abstime );
        VAS_retc=1;
        VAS_cnt=VAS_cnt-1;
        $fclose(outfile);
      end
   end
   else
   begin
      if(VAS_cnt==0)
      begin
        outfile=$fopen(errFileName,"a");
        $strobe("rpp1k1_3      VAS     error limit ( %d ) reached at %7.4r  %M", maxEv, $abstime );
        $fwrite(outfile,"rpp1k1_3      VAS     error limit ( %d ) reached at %7.4r  %M\n", maxEv, $abstime );
        VAS_cnt=VAS_cnt-1;
        $fclose(outfile);
      end
   end

//      VBS
   VBS = V_B_S;
   if((VBS_cnt>0) || ( maxEv_flg==0 ))   begin
      if( (VBS < -60) && (VBS_retc!=-1))
      begin
        outfile=$fopen(errFileName,"a");
        $strobe("rpp1k1_3      VBS     leaving   OCA (  .. -60.000 V ) at %7.4r  %M", $abstime );
        $fwrite(outfile,"rpp1k1_3      VBS     leaving   OCA (  .. -60.000 V ) at %7.4r  %M\n", $abstime );
        VBS_retc=-1;
        VBS_cnt=VBS_cnt-1;
        $fclose(outfile);
      end
      if((VBS >= -60) &&  (VBS <= 60) && (VBS_retc!=0))
      begin
        outfile=$fopen(errFileName,"a");
        $strobe("rpp1k1_3      VBS     entering SOCA ( -60.000 V .. 60.000 V ) at %7.4r  %M", $abstime );
        $fwrite(outfile,"rpp1k1_3      VBS     entering SOCA ( -60.000 V .. 60.000 V ) at %7.4r  %M\n", $abstime );
        VBS_retc=0;
        VBS_cnt=VBS_cnt-1;
        $fclose(outfile);
      end
      if((VBS > 60) &&  (VBS_retc!=1))
      begin
        outfile=$fopen(errFileName,"a");
        $strobe("rpp1k1_3      VBS     leaving   OCA ( 60.000 V ..  ) at %7.4r  %M", $abstime );
        $fwrite(outfile,"rpp1k1_3      VBS     leaving   OCA ( 60.000 V ..  ) at %7.4r  %M\n", $abstime );
        VBS_retc=1;
        VBS_cnt=VBS_cnt-1;
        $fclose(outfile);
      end
   end
   else
   begin
      if(VBS_cnt==0)
      begin
        outfile=$fopen(errFileName,"a");
        $strobe("rpp1k1_3      VBS     error limit ( %d ) reached at %7.4r  %M", maxEv, $abstime );
        $fwrite(outfile,"rpp1k1_3      VBS     error limit ( %d ) reached at %7.4r  %M\n", maxEv, $abstime );
        VBS_cnt=VBS_cnt-1;
        $fclose(outfile);
      end
   end

//      JDL
   JDL = I_A / w;
   if((JDL_cnt>0) || ( maxEv_flg==0 ))   begin
      if( (JDL < -250) && (JDL_retc!=-1))
      begin
        outfile=$fopen(errFileName,"a");
        $strobe("rpp1k1_3      JDL     leaving   OCA (  .. -0.250 mA/um ) at %7.4r  %M", $abstime );
        $fwrite(outfile,"rpp1k1_3      JDL     leaving   OCA (  .. -0.250 mA/um ) at %7.4r  %M\n", $abstime );
        JDL_retc=-1;
        JDL_cnt=JDL_cnt-1;
        $fclose(outfile);
      end
      if((JDL >= -250) &&  (JDL <= 250) && (JDL_retc!=0))
      begin
        outfile=$fopen(errFileName,"a");
        $strobe("rpp1k1_3      JDL     entering SOCA ( -0.250 mA/um .. 0.250 mA/um ) at %7.4r  %M", $abstime );
        $fwrite(outfile,"rpp1k1_3      JDL     entering SOCA ( -0.250 mA/um .. 0.250 mA/um ) at %7.4r  %M\n", $abstime );
        JDL_retc=0;
        JDL_cnt=JDL_cnt-1;
        $fclose(outfile);
      end
      if((JDL > 250) &&  (JDL_retc!=1))
      begin
        outfile=$fopen(errFileName,"a");
        $strobe("rpp1k1_3      JDL     leaving   OCA ( 0.250 mA/um ..  ) at %7.4r  %M", $abstime );
        $fwrite(outfile,"rpp1k1_3      JDL     leaving   OCA ( 0.250 mA/um ..  ) at %7.4r  %M\n", $abstime );
        JDL_retc=1;
        JDL_cnt=JDL_cnt-1;
        $fclose(outfile);
      end
   end
   else
   begin
      if(JDL_cnt==0)
      begin
        outfile=$fopen(errFileName,"a");
        $strobe("rpp1k1_3      JDL     error limit ( %d ) reached at %7.4r  %M", maxEv, $abstime );
        $fwrite(outfile,"rpp1k1_3      JDL     error limit ( %d ) reached at %7.4r  %M\n", maxEv, $abstime );
        JDL_cnt=JDL_cnt-1;
        $fclose(outfile);
      end
   end

end // analog
endmodule // rpp1k1_3

// Verilog-A OC Watch for device rnp1h Parameters  VA VB JDL
module rnp1h_ahdl(A1,B1,A,B);
parameter tstep_occ=100n;
parameter errFileName="./occ.err";
parameter w = 1u;
parameter maxEv = 25;
parameter maxEv_flg = 0;
inout A1,B1,A,B;
electrical A1,B1,A,B;

integer outfile;
real V_B;
real V_A;
real I_B;
real I_A;
real VA;
integer VA_retc;
integer VA_cnt;
real VB;
integer VB_retc;
integer VB_cnt;
real JDL;
integer JDL_retc;
integer JDL_cnt;

analog begin
   $bound_step( tstep_occ );
   @(initial_step) begin
      VA_retc=0;
      VA_cnt = maxEv;
      VB_retc=0;
      VB_cnt = maxEv;
      JDL_retc=0;
      JDL_cnt = maxEv;
   end
   V_B = V(B);
   V_A = V(A);
   I_B = I(B1,B);
   I_A = I(A1,A);

//      VA
   VA = V_A;
   if((VA_cnt>0) || ( maxEv_flg==0 ))   begin
      if( (VA < -100) && (VA_retc!=-1))
      begin
        outfile=$fopen(errFileName,"a");
        $strobe("rnp1h         VA      leaving   OCA (  .. -100.000 V ) at %7.4r  %M", $abstime );
        $fwrite(outfile,"rnp1h         VA      leaving   OCA (  .. -100.000 V ) at %7.4r  %M\n", $abstime );
        VA_retc=-1;
        VA_cnt=VA_cnt-1;
        $fclose(outfile);
      end
      if((VA >= -100) &&  (VA <= 100) && (VA_retc!=0))
      begin
        outfile=$fopen(errFileName,"a");
        $strobe("rnp1h         VA      entering SOCA ( -100.000 V .. 100.000 V ) at %7.4r  %M", $abstime );
        $fwrite(outfile,"rnp1h         VA      entering SOCA ( -100.000 V .. 100.000 V ) at %7.4r  %M\n", $abstime );
        VA_retc=0;
        VA_cnt=VA_cnt-1;
        $fclose(outfile);
      end
      if((VA > 100) &&  (VA_retc!=1))
      begin
        outfile=$fopen(errFileName,"a");
        $strobe("rnp1h         VA      leaving   OCA ( 100.000 V ..  ) at %7.4r  %M", $abstime );
        $fwrite(outfile,"rnp1h         VA      leaving   OCA ( 100.000 V ..  ) at %7.4r  %M\n", $abstime );
        VA_retc=1;
        VA_cnt=VA_cnt-1;
        $fclose(outfile);
      end
   end
   else
   begin
      if(VA_cnt==0)
      begin
        outfile=$fopen(errFileName,"a");
        $strobe("rnp1h         VA      error limit ( %d ) reached at %7.4r  %M", maxEv, $abstime );
        $fwrite(outfile,"rnp1h         VA      error limit ( %d ) reached at %7.4r  %M\n", maxEv, $abstime );
        VA_cnt=VA_cnt-1;
        $fclose(outfile);
      end
   end

//      VB
   VB = V_B;
   if((VB_cnt>0) || ( maxEv_flg==0 ))   begin
      if( (VB < -100) && (VB_retc!=-1))
      begin
        outfile=$fopen(errFileName,"a");
        $strobe("rnp1h         VB      leaving   OCA (  .. -100.000 V ) at %7.4r  %M", $abstime );
        $fwrite(outfile,"rnp1h         VB      leaving   OCA (  .. -100.000 V ) at %7.4r  %M\n", $abstime );
        VB_retc=-1;
        VB_cnt=VB_cnt-1;
        $fclose(outfile);
      end
      if((VB >= -100) &&  (VB <= 100) && (VB_retc!=0))
      begin
        outfile=$fopen(errFileName,"a");
        $strobe("rnp1h         VB      entering SOCA ( -100.000 V .. 100.000 V ) at %7.4r  %M", $abstime );
        $fwrite(outfile,"rnp1h         VB      entering SOCA ( -100.000 V .. 100.000 V ) at %7.4r  %M\n", $abstime );
        VB_retc=0;
        VB_cnt=VB_cnt-1;
        $fclose(outfile);
      end
      if((VB > 100) &&  (VB_retc!=1))
      begin
        outfile=$fopen(errFileName,"a");
        $strobe("rnp1h         VB      leaving   OCA ( 100.000 V ..  ) at %7.4r  %M", $abstime );
        $fwrite(outfile,"rnp1h         VB      leaving   OCA ( 100.000 V ..  ) at %7.4r  %M\n", $abstime );
        VB_retc=1;
        VB_cnt=VB_cnt-1;
        $fclose(outfile);
      end
   end
   else
   begin
      if(VB_cnt==0)
      begin
        outfile=$fopen(errFileName,"a");
        $strobe("rnp1h         VB      error limit ( %d ) reached at %7.4r  %M", maxEv, $abstime );
        $fwrite(outfile,"rnp1h         VB      error limit ( %d ) reached at %7.4r  %M\n", maxEv, $abstime );
        VB_cnt=VB_cnt-1;
        $fclose(outfile);
      end
   end

//      JDL
   JDL = I_A / w;
   if((JDL_cnt>0) || ( maxEv_flg==0 ))   begin
      if( (JDL < -100) && (JDL_retc!=-1))
      begin
        outfile=$fopen(errFileName,"a");
        $strobe("rnp1h         JDL     leaving   OCA (  .. -0.100 mA/um ) at %7.4r  %M", $abstime );
        $fwrite(outfile,"rnp1h         JDL     leaving   OCA (  .. -0.100 mA/um ) at %7.4r  %M\n", $abstime );
        JDL_retc=-1;
        JDL_cnt=JDL_cnt-1;
        $fclose(outfile);
      end
      if((JDL >= -100) &&  (JDL <= 100) && (JDL_retc!=0))
      begin
        outfile=$fopen(errFileName,"a");
        $strobe("rnp1h         JDL     entering SOCA ( -0.100 mA/um .. 0.100 mA/um ) at %7.4r  %M", $abstime );
        $fwrite(outfile,"rnp1h         JDL     entering SOCA ( -0.100 mA/um .. 0.100 mA/um ) at %7.4r  %M\n", $abstime );
        JDL_retc=0;
        JDL_cnt=JDL_cnt-1;
        $fclose(outfile);
      end
      if((JDL > 100) &&  (JDL_retc!=1))
      begin
        outfile=$fopen(errFileName,"a");
        $strobe("rnp1h         JDL     leaving   OCA ( 0.100 mA/um ..  ) at %7.4r  %M", $abstime );
        $fwrite(outfile,"rnp1h         JDL     leaving   OCA ( 0.100 mA/um ..  ) at %7.4r  %M\n", $abstime );
        JDL_retc=1;
        JDL_cnt=JDL_cnt-1;
        $fclose(outfile);
      end
   end
   else
   begin
      if(JDL_cnt==0)
      begin
        outfile=$fopen(errFileName,"a");
        $strobe("rnp1h         JDL     error limit ( %d ) reached at %7.4r  %M", maxEv, $abstime );
        $fwrite(outfile,"rnp1h         JDL     error limit ( %d ) reached at %7.4r  %M\n", maxEv, $abstime );
        JDL_cnt=JDL_cnt-1;
        $fclose(outfile);
      end
   end

end // analog
endmodule // rnp1h

// Verilog-A OC Watch for device rnp1h_3 Parameters  VAS VBS JDL
module rnp1h_3_ahdl(A1,B1,S1,A,B,S);
parameter tstep_occ=100n;
parameter errFileName="./occ.err";
parameter w = 1u;
parameter maxEv = 25;
parameter maxEv_flg = 0;
inout A1,B1,S1,A,B,S;
electrical A1,B1,S1,A,B,S;

integer outfile;
real V_B_S;
real V_A_S;
real I_S;
real I_B;
real I_A;
real VAS;
integer VAS_retc;
integer VAS_cnt;
real VBS;
integer VBS_retc;
integer VBS_cnt;
real JDL;
integer JDL_retc;
integer JDL_cnt;

analog begin
   $bound_step( tstep_occ );
   @(initial_step) begin
      VAS_retc=0;
      VAS_cnt = maxEv;
      VBS_retc=0;
      VBS_cnt = maxEv;
      JDL_retc=0;
      JDL_cnt = maxEv;
   end
   V_B_S = V(B,S);
   V_A_S = V(A,S);
   I_S = I(S1,S);
   I_B = I(B1,B);
   I_A = I(A1,A);

//      VAS
   VAS = V_A_S;
   if((VAS_cnt>0) || ( maxEv_flg==0 ))   begin
      if( (VAS < -100) && (VAS_retc!=-1))
      begin
        outfile=$fopen(errFileName,"a");
        $strobe("rnp1h_3       VAS     leaving   OCA (  .. -100.000 V ) at %7.4r  %M", $abstime );
        $fwrite(outfile,"rnp1h_3       VAS     leaving   OCA (  .. -100.000 V ) at %7.4r  %M\n", $abstime );
        VAS_retc=-1;
        VAS_cnt=VAS_cnt-1;
        $fclose(outfile);
      end
      if((VAS >= -100) &&  (VAS <= 100) && (VAS_retc!=0))
      begin
        outfile=$fopen(errFileName,"a");
        $strobe("rnp1h_3       VAS     entering SOCA ( -100.000 V .. 100.000 V ) at %7.4r  %M", $abstime );
        $fwrite(outfile,"rnp1h_3       VAS     entering SOCA ( -100.000 V .. 100.000 V ) at %7.4r  %M\n", $abstime );
        VAS_retc=0;
        VAS_cnt=VAS_cnt-1;
        $fclose(outfile);
      end
      if((VAS > 100) &&  (VAS_retc!=1))
      begin
        outfile=$fopen(errFileName,"a");
        $strobe("rnp1h_3       VAS     leaving   OCA ( 100.000 V ..  ) at %7.4r  %M", $abstime );
        $fwrite(outfile,"rnp1h_3       VAS     leaving   OCA ( 100.000 V ..  ) at %7.4r  %M\n", $abstime );
        VAS_retc=1;
        VAS_cnt=VAS_cnt-1;
        $fclose(outfile);
      end
   end
   else
   begin
      if(VAS_cnt==0)
      begin
        outfile=$fopen(errFileName,"a");
        $strobe("rnp1h_3       VAS     error limit ( %d ) reached at %7.4r  %M", maxEv, $abstime );
        $fwrite(outfile,"rnp1h_3       VAS     error limit ( %d ) reached at %7.4r  %M\n", maxEv, $abstime );
        VAS_cnt=VAS_cnt-1;
        $fclose(outfile);
      end
   end

//      VBS
   VBS = V_B_S;
   if((VBS_cnt>0) || ( maxEv_flg==0 ))   begin
      if( (VBS < -100) && (VBS_retc!=-1))
      begin
        outfile=$fopen(errFileName,"a");
        $strobe("rnp1h_3       VBS     leaving   OCA (  .. -100.000 V ) at %7.4r  %M", $abstime );
        $fwrite(outfile,"rnp1h_3       VBS     leaving   OCA (  .. -100.000 V ) at %7.4r  %M\n", $abstime );
        VBS_retc=-1;
        VBS_cnt=VBS_cnt-1;
        $fclose(outfile);
      end
      if((VBS >= -100) &&  (VBS <= 100) && (VBS_retc!=0))
      begin
        outfile=$fopen(errFileName,"a");
        $strobe("rnp1h_3       VBS     entering SOCA ( -100.000 V .. 100.000 V ) at %7.4r  %M", $abstime );
        $fwrite(outfile,"rnp1h_3       VBS     entering SOCA ( -100.000 V .. 100.000 V ) at %7.4r  %M\n", $abstime );
        VBS_retc=0;
        VBS_cnt=VBS_cnt-1;
        $fclose(outfile);
      end
      if((VBS > 100) &&  (VBS_retc!=1))
      begin
        outfile=$fopen(errFileName,"a");
        $strobe("rnp1h_3       VBS     leaving   OCA ( 100.000 V ..  ) at %7.4r  %M", $abstime );
        $fwrite(outfile,"rnp1h_3       VBS     leaving   OCA ( 100.000 V ..  ) at %7.4r  %M\n", $abstime );
        VBS_retc=1;
        VBS_cnt=VBS_cnt-1;
        $fclose(outfile);
      end
   end
   else
   begin
      if(VBS_cnt==0)
      begin
        outfile=$fopen(errFileName,"a");
        $strobe("rnp1h_3       VBS     error limit ( %d ) reached at %7.4r  %M", maxEv, $abstime );
        $fwrite(outfile,"rnp1h_3       VBS     error limit ( %d ) reached at %7.4r  %M\n", maxEv, $abstime );
        VBS_cnt=VBS_cnt-1;
        $fclose(outfile);
      end
   end

//      JDL
   JDL = I_A / w;
   if((JDL_cnt>0) || ( maxEv_flg==0 ))   begin
      if( (JDL < -100) && (JDL_retc!=-1))
      begin
        outfile=$fopen(errFileName,"a");
        $strobe("rnp1h_3       JDL     leaving   OCA (  .. -0.100 mA/um ) at %7.4r  %M", $abstime );
        $fwrite(outfile,"rnp1h_3       JDL     leaving   OCA (  .. -0.100 mA/um ) at %7.4r  %M\n", $abstime );
        JDL_retc=-1;
        JDL_cnt=JDL_cnt-1;
        $fclose(outfile);
      end
      if((JDL >= -100) &&  (JDL <= 100) && (JDL_retc!=0))
      begin
        outfile=$fopen(errFileName,"a");
        $strobe("rnp1h_3       JDL     entering SOCA ( -0.100 mA/um .. 0.100 mA/um ) at %7.4r  %M", $abstime );
        $fwrite(outfile,"rnp1h_3       JDL     entering SOCA ( -0.100 mA/um .. 0.100 mA/um ) at %7.4r  %M\n", $abstime );
        JDL_retc=0;
        JDL_cnt=JDL_cnt-1;
        $fclose(outfile);
      end
      if((JDL > 100) &&  (JDL_retc!=1))
      begin
        outfile=$fopen(errFileName,"a");
        $strobe("rnp1h_3       JDL     leaving   OCA ( 0.100 mA/um ..  ) at %7.4r  %M", $abstime );
        $fwrite(outfile,"rnp1h_3       JDL     leaving   OCA ( 0.100 mA/um ..  ) at %7.4r  %M\n", $abstime );
        JDL_retc=1;
        JDL_cnt=JDL_cnt-1;
        $fclose(outfile);
      end
   end
   else
   begin
      if(JDL_cnt==0)
      begin
        outfile=$fopen(errFileName,"a");
        $strobe("rnp1h_3       JDL     error limit ( %d ) reached at %7.4r  %M", maxEv, $abstime );
        $fwrite(outfile,"rnp1h_3       JDL     error limit ( %d ) reached at %7.4r  %M\n", maxEv, $abstime );
        JDL_cnt=JDL_cnt-1;
        $fclose(outfile);
      end
   end

end // analog
endmodule // rnp1h_3

// Verilog-A OC Watch for device rpp1k1a Parameters  VA VB JDL
module rpp1k1a_ahdl(A1,B1,A,B);
parameter tstep_occ=100n;
parameter errFileName="./occ.err";
parameter w = 1u;
parameter maxEv = 25;
parameter maxEv_flg = 0;
inout A1,B1,A,B;
electrical A1,B1,A,B;

integer outfile;
real V_B;
real V_A;
real I_B;
real I_A;
real VA;
integer VA_retc;
integer VA_cnt;
real VB;
integer VB_retc;
integer VB_cnt;
real JDL;
integer JDL_retc;
integer JDL_cnt;

analog begin
   $bound_step( tstep_occ );
   @(initial_step) begin
      VA_retc=0;
      VA_cnt = maxEv;
      VB_retc=0;
      VB_cnt = maxEv;
      JDL_retc=0;
      JDL_cnt = maxEv;
   end
   V_B = V(B);
   V_A = V(A);
   I_B = I(B1,B);
   I_A = I(A1,A);

//      VA
   VA = V_A;
   if((VA_cnt>0) || ( maxEv_flg==0 ))   begin
      if( (VA < -100) && (VA_retc!=-1))
      begin
        outfile=$fopen(errFileName,"a");
        $strobe("rpp1k1a       VA      leaving   OCA (  .. -100.000 V ) at %7.4r  %M", $abstime );
        $fwrite(outfile,"rpp1k1a       VA      leaving   OCA (  .. -100.000 V ) at %7.4r  %M\n", $abstime );
        VA_retc=-1;
        VA_cnt=VA_cnt-1;
        $fclose(outfile);
      end
      if((VA >= -100) &&  (VA <= 100) && (VA_retc!=0))
      begin
        outfile=$fopen(errFileName,"a");
        $strobe("rpp1k1a       VA      entering SOCA ( -100.000 V .. 100.000 V ) at %7.4r  %M", $abstime );
        $fwrite(outfile,"rpp1k1a       VA      entering SOCA ( -100.000 V .. 100.000 V ) at %7.4r  %M\n", $abstime );
        VA_retc=0;
        VA_cnt=VA_cnt-1;
        $fclose(outfile);
      end
      if((VA > 100) &&  (VA_retc!=1))
      begin
        outfile=$fopen(errFileName,"a");
        $strobe("rpp1k1a       VA      leaving   OCA ( 100.000 V ..  ) at %7.4r  %M", $abstime );
        $fwrite(outfile,"rpp1k1a       VA      leaving   OCA ( 100.000 V ..  ) at %7.4r  %M\n", $abstime );
        VA_retc=1;
        VA_cnt=VA_cnt-1;
        $fclose(outfile);
      end
   end
   else
   begin
      if(VA_cnt==0)
      begin
        outfile=$fopen(errFileName,"a");
        $strobe("rpp1k1a       VA      error limit ( %d ) reached at %7.4r  %M", maxEv, $abstime );
        $fwrite(outfile,"rpp1k1a       VA      error limit ( %d ) reached at %7.4r  %M\n", maxEv, $abstime );
        VA_cnt=VA_cnt-1;
        $fclose(outfile);
      end
   end

//      VB
   VB = V_B;
   if((VB_cnt>0) || ( maxEv_flg==0 ))   begin
      if( (VB < -100) && (VB_retc!=-1))
      begin
        outfile=$fopen(errFileName,"a");
        $strobe("rpp1k1a       VB      leaving   OCA (  .. -100.000 V ) at %7.4r  %M", $abstime );
        $fwrite(outfile,"rpp1k1a       VB      leaving   OCA (  .. -100.000 V ) at %7.4r  %M\n", $abstime );
        VB_retc=-1;
        VB_cnt=VB_cnt-1;
        $fclose(outfile);
      end
      if((VB >= -100) &&  (VB <= 100) && (VB_retc!=0))
      begin
        outfile=$fopen(errFileName,"a");
        $strobe("rpp1k1a       VB      entering SOCA ( -100.000 V .. 100.000 V ) at %7.4r  %M", $abstime );
        $fwrite(outfile,"rpp1k1a       VB      entering SOCA ( -100.000 V .. 100.000 V ) at %7.4r  %M\n", $abstime );
        VB_retc=0;
        VB_cnt=VB_cnt-1;
        $fclose(outfile);
      end
      if((VB > 100) &&  (VB_retc!=1))
      begin
        outfile=$fopen(errFileName,"a");
        $strobe("rpp1k1a       VB      leaving   OCA ( 100.000 V ..  ) at %7.4r  %M", $abstime );
        $fwrite(outfile,"rpp1k1a       VB      leaving   OCA ( 100.000 V ..  ) at %7.4r  %M\n", $abstime );
        VB_retc=1;
        VB_cnt=VB_cnt-1;
        $fclose(outfile);
      end
   end
   else
   begin
      if(VB_cnt==0)
      begin
        outfile=$fopen(errFileName,"a");
        $strobe("rpp1k1a       VB      error limit ( %d ) reached at %7.4r  %M", maxEv, $abstime );
        $fwrite(outfile,"rpp1k1a       VB      error limit ( %d ) reached at %7.4r  %M\n", maxEv, $abstime );
        VB_cnt=VB_cnt-1;
        $fclose(outfile);
      end
   end

//      JDL
   JDL = I_A / w;
   if((JDL_cnt>0) || ( maxEv_flg==0 ))   begin
      if( (JDL < -250) && (JDL_retc!=-1))
      begin
        outfile=$fopen(errFileName,"a");
        $strobe("rpp1k1a       JDL     leaving   OCA (  .. -0.250 mA/um ) at %7.4r  %M", $abstime );
        $fwrite(outfile,"rpp1k1a       JDL     leaving   OCA (  .. -0.250 mA/um ) at %7.4r  %M\n", $abstime );
        JDL_retc=-1;
        JDL_cnt=JDL_cnt-1;
        $fclose(outfile);
      end
      if((JDL >= -250) &&  (JDL <= 250) && (JDL_retc!=0))
      begin
        outfile=$fopen(errFileName,"a");
        $strobe("rpp1k1a       JDL     entering SOCA ( -0.250 mA/um .. 0.250 mA/um ) at %7.4r  %M", $abstime );
        $fwrite(outfile,"rpp1k1a       JDL     entering SOCA ( -0.250 mA/um .. 0.250 mA/um ) at %7.4r  %M\n", $abstime );
        JDL_retc=0;
        JDL_cnt=JDL_cnt-1;
        $fclose(outfile);
      end
      if((JDL > 250) &&  (JDL_retc!=1))
      begin
        outfile=$fopen(errFileName,"a");
        $strobe("rpp1k1a       JDL     leaving   OCA ( 0.250 mA/um ..  ) at %7.4r  %M", $abstime );
        $fwrite(outfile,"rpp1k1a       JDL     leaving   OCA ( 0.250 mA/um ..  ) at %7.4r  %M\n", $abstime );
        JDL_retc=1;
        JDL_cnt=JDL_cnt-1;
        $fclose(outfile);
      end
   end
   else
   begin
      if(JDL_cnt==0)
      begin
        outfile=$fopen(errFileName,"a");
        $strobe("rpp1k1a       JDL     error limit ( %d ) reached at %7.4r  %M", maxEv, $abstime );
        $fwrite(outfile,"rpp1k1a       JDL     error limit ( %d ) reached at %7.4r  %M\n", maxEv, $abstime );
        JDL_cnt=JDL_cnt-1;
        $fclose(outfile);
      end
   end

end // analog
endmodule // rpp1k1a

// Verilog-A OC Watch for device rpp1k1a_3 Parameters  VAS VBS JDL
module rpp1k1a_3_ahdl(A1,B1,S1,A,B,S);
parameter tstep_occ=100n;
parameter errFileName="./occ.err";
parameter w = 1u;
parameter maxEv = 25;
parameter maxEv_flg = 0;
inout A1,B1,S1,A,B,S;
electrical A1,B1,S1,A,B,S;

integer outfile;
real V_B_S;
real V_A_S;
real I_S;
real I_B;
real I_A;
real VAS;
integer VAS_retc;
integer VAS_cnt;
real VBS;
integer VBS_retc;
integer VBS_cnt;
real JDL;
integer JDL_retc;
integer JDL_cnt;

analog begin
   $bound_step( tstep_occ );
   @(initial_step) begin
      VAS_retc=0;
      VAS_cnt = maxEv;
      VBS_retc=0;
      VBS_cnt = maxEv;
      JDL_retc=0;
      JDL_cnt = maxEv;
   end
   V_B_S = V(B,S);
   V_A_S = V(A,S);
   I_S = I(S1,S);
   I_B = I(B1,B);
   I_A = I(A1,A);

//      VAS
   VAS = V_A_S;
   if((VAS_cnt>0) || ( maxEv_flg==0 ))   begin
      if( (VAS < -100) && (VAS_retc!=-1))
      begin
        outfile=$fopen(errFileName,"a");
        $strobe("rpp1k1a_3     VAS     leaving   OCA (  .. -100.000 V ) at %7.4r  %M", $abstime );
        $fwrite(outfile,"rpp1k1a_3     VAS     leaving   OCA (  .. -100.000 V ) at %7.4r  %M\n", $abstime );
        VAS_retc=-1;
        VAS_cnt=VAS_cnt-1;
        $fclose(outfile);
      end
      if((VAS >= -100) &&  (VAS <= 100) && (VAS_retc!=0))
      begin
        outfile=$fopen(errFileName,"a");
        $strobe("rpp1k1a_3     VAS     entering SOCA ( -100.000 V .. 100.000 V ) at %7.4r  %M", $abstime );
        $fwrite(outfile,"rpp1k1a_3     VAS     entering SOCA ( -100.000 V .. 100.000 V ) at %7.4r  %M\n", $abstime );
        VAS_retc=0;
        VAS_cnt=VAS_cnt-1;
        $fclose(outfile);
      end
      if((VAS > 100) &&  (VAS_retc!=1))
      begin
        outfile=$fopen(errFileName,"a");
        $strobe("rpp1k1a_3     VAS     leaving   OCA ( 100.000 V ..  ) at %7.4r  %M", $abstime );
        $fwrite(outfile,"rpp1k1a_3     VAS     leaving   OCA ( 100.000 V ..  ) at %7.4r  %M\n", $abstime );
        VAS_retc=1;
        VAS_cnt=VAS_cnt-1;
        $fclose(outfile);
      end
   end
   else
   begin
      if(VAS_cnt==0)
      begin
        outfile=$fopen(errFileName,"a");
        $strobe("rpp1k1a_3     VAS     error limit ( %d ) reached at %7.4r  %M", maxEv, $abstime );
        $fwrite(outfile,"rpp1k1a_3     VAS     error limit ( %d ) reached at %7.4r  %M\n", maxEv, $abstime );
        VAS_cnt=VAS_cnt-1;
        $fclose(outfile);
      end
   end

//      VBS
   VBS = V_B_S;
   if((VBS_cnt>0) || ( maxEv_flg==0 ))   begin
      if( (VBS < -100) && (VBS_retc!=-1))
      begin
        outfile=$fopen(errFileName,"a");
        $strobe("rpp1k1a_3     VBS     leaving   OCA (  .. -100.000 V ) at %7.4r  %M", $abstime );
        $fwrite(outfile,"rpp1k1a_3     VBS     leaving   OCA (  .. -100.000 V ) at %7.4r  %M\n", $abstime );
        VBS_retc=-1;
        VBS_cnt=VBS_cnt-1;
        $fclose(outfile);
      end
      if((VBS >= -100) &&  (VBS <= 100) && (VBS_retc!=0))
      begin
        outfile=$fopen(errFileName,"a");
        $strobe("rpp1k1a_3     VBS     entering SOCA ( -100.000 V .. 100.000 V ) at %7.4r  %M", $abstime );
        $fwrite(outfile,"rpp1k1a_3     VBS     entering SOCA ( -100.000 V .. 100.000 V ) at %7.4r  %M\n", $abstime );
        VBS_retc=0;
        VBS_cnt=VBS_cnt-1;
        $fclose(outfile);
      end
      if((VBS > 100) &&  (VBS_retc!=1))
      begin
        outfile=$fopen(errFileName,"a");
        $strobe("rpp1k1a_3     VBS     leaving   OCA ( 100.000 V ..  ) at %7.4r  %M", $abstime );
        $fwrite(outfile,"rpp1k1a_3     VBS     leaving   OCA ( 100.000 V ..  ) at %7.4r  %M\n", $abstime );
        VBS_retc=1;
        VBS_cnt=VBS_cnt-1;
        $fclose(outfile);
      end
   end
   else
   begin
      if(VBS_cnt==0)
      begin
        outfile=$fopen(errFileName,"a");
        $strobe("rpp1k1a_3     VBS     error limit ( %d ) reached at %7.4r  %M", maxEv, $abstime );
        $fwrite(outfile,"rpp1k1a_3     VBS     error limit ( %d ) reached at %7.4r  %M\n", maxEv, $abstime );
        VBS_cnt=VBS_cnt-1;
        $fclose(outfile);
      end
   end

//      JDL
   JDL = I_A / w;
   if((JDL_cnt>0) || ( maxEv_flg==0 ))   begin
      if( (JDL < -250) && (JDL_retc!=-1))
      begin
        outfile=$fopen(errFileName,"a");
        $strobe("rpp1k1a_3     JDL     leaving   OCA (  .. -0.250 mA/um ) at %7.4r  %M", $abstime );
        $fwrite(outfile,"rpp1k1a_3     JDL     leaving   OCA (  .. -0.250 mA/um ) at %7.4r  %M\n", $abstime );
        JDL_retc=-1;
        JDL_cnt=JDL_cnt-1;
        $fclose(outfile);
      end
      if((JDL >= -250) &&  (JDL <= 250) && (JDL_retc!=0))
      begin
        outfile=$fopen(errFileName,"a");
        $strobe("rpp1k1a_3     JDL     entering SOCA ( -0.250 mA/um .. 0.250 mA/um ) at %7.4r  %M", $abstime );
        $fwrite(outfile,"rpp1k1a_3     JDL     entering SOCA ( -0.250 mA/um .. 0.250 mA/um ) at %7.4r  %M\n", $abstime );
        JDL_retc=0;
        JDL_cnt=JDL_cnt-1;
        $fclose(outfile);
      end
      if((JDL > 250) &&  (JDL_retc!=1))
      begin
        outfile=$fopen(errFileName,"a");
        $strobe("rpp1k1a_3     JDL     leaving   OCA ( 0.250 mA/um ..  ) at %7.4r  %M", $abstime );
        $fwrite(outfile,"rpp1k1a_3     JDL     leaving   OCA ( 0.250 mA/um ..  ) at %7.4r  %M\n", $abstime );
        JDL_retc=1;
        JDL_cnt=JDL_cnt-1;
        $fclose(outfile);
      end
   end
   else
   begin
      if(JDL_cnt==0)
      begin
        outfile=$fopen(errFileName,"a");
        $strobe("rpp1k1a_3     JDL     error limit ( %d ) reached at %7.4r  %M", maxEv, $abstime );
        $fwrite(outfile,"rpp1k1a_3     JDL     error limit ( %d ) reached at %7.4r  %M\n", maxEv, $abstime );
        JDL_cnt=JDL_cnt-1;
        $fclose(outfile);
      end
   end

end // analog
endmodule // rpp1k1a_3

// Verilog-A OC Watch for device cmm3 Parameters  VT1 VT2 VT1T2
module cmm3_ahdl(T1,T2);
parameter tstep_occ=100n;
parameter errFileName="./occ.err";
parameter maxEv = 25;
parameter maxEv_flg = 0;
inout T1,T2;
electrical T1,T2;

integer outfile;
real V_T1_T2;
real V_T2;
real V_T1;
real VT1;
integer VT1_retc;
integer VT1_cnt;
real VT2;
integer VT2_retc;
integer VT2_cnt;
real VT1T2;
integer VT1T2_retc;
integer VT1T2_cnt;

analog begin
   $bound_step( tstep_occ );
   @(initial_step) begin
      VT1_retc=0;
      VT1_cnt = maxEv;
      VT2_retc=0;
      VT2_cnt = maxEv;
      VT1T2_retc=0;
      VT1T2_cnt = maxEv;
   end
   V_T1_T2 = V(T1,T2);
   V_T2 = V(T2);
   V_T1 = V(T1);

//      VT1
   VT1 = V_T1;
   if((VT1_cnt>0) || ( maxEv_flg==0 ))   begin
      if( (VT1 < -420) && (VT1_retc!=-1))
      begin
        outfile=$fopen(errFileName,"a");
        $strobe("cmm3          VT1     leaving   OCA (  .. -420.000 V ) at %7.4r  %M", $abstime );
        $fwrite(outfile,"cmm3          VT1     leaving   OCA (  .. -420.000 V ) at %7.4r  %M\n", $abstime );
        VT1_retc=-1;
        VT1_cnt=VT1_cnt-1;
        $fclose(outfile);
      end
      if((VT1 >= -420) &&  (VT1 <= 420) && (VT1_retc!=0))
      begin
        outfile=$fopen(errFileName,"a");
        $strobe("cmm3          VT1     entering SOCA ( -420.000 V .. 420.000 V ) at %7.4r  %M", $abstime );
        $fwrite(outfile,"cmm3          VT1     entering SOCA ( -420.000 V .. 420.000 V ) at %7.4r  %M\n", $abstime );
        VT1_retc=0;
        VT1_cnt=VT1_cnt-1;
        $fclose(outfile);
      end
      if((VT1 > 420) &&  (VT1_retc!=1))
      begin
        outfile=$fopen(errFileName,"a");
        $strobe("cmm3          VT1     leaving   OCA ( 420.000 V ..  ) at %7.4r  %M", $abstime );
        $fwrite(outfile,"cmm3          VT1     leaving   OCA ( 420.000 V ..  ) at %7.4r  %M\n", $abstime );
        VT1_retc=1;
        VT1_cnt=VT1_cnt-1;
        $fclose(outfile);
      end
   end
   else
   begin
      if(VT1_cnt==0)
      begin
        outfile=$fopen(errFileName,"a");
        $strobe("cmm3          VT1     error limit ( %d ) reached at %7.4r  %M", maxEv, $abstime );
        $fwrite(outfile,"cmm3          VT1     error limit ( %d ) reached at %7.4r  %M\n", maxEv, $abstime );
        VT1_cnt=VT1_cnt-1;
        $fclose(outfile);
      end
   end

//      VT2
   VT2 = V_T2;
   if((VT2_cnt>0) || ( maxEv_flg==0 ))   begin
      if( (VT2 < -420) && (VT2_retc!=-1))
      begin
        outfile=$fopen(errFileName,"a");
        $strobe("cmm3          VT2     leaving   OCA (  .. -420.000 V ) at %7.4r  %M", $abstime );
        $fwrite(outfile,"cmm3          VT2     leaving   OCA (  .. -420.000 V ) at %7.4r  %M\n", $abstime );
        VT2_retc=-1;
        VT2_cnt=VT2_cnt-1;
        $fclose(outfile);
      end
      if((VT2 >= -420) &&  (VT2 <= 420) && (VT2_retc!=0))
      begin
        outfile=$fopen(errFileName,"a");
        $strobe("cmm3          VT2     entering SOCA ( -420.000 V .. 420.000 V ) at %7.4r  %M", $abstime );
        $fwrite(outfile,"cmm3          VT2     entering SOCA ( -420.000 V .. 420.000 V ) at %7.4r  %M\n", $abstime );
        VT2_retc=0;
        VT2_cnt=VT2_cnt-1;
        $fclose(outfile);
      end
      if((VT2 > 420) &&  (VT2_retc!=1))
      begin
        outfile=$fopen(errFileName,"a");
        $strobe("cmm3          VT2     leaving   OCA ( 420.000 V ..  ) at %7.4r  %M", $abstime );
        $fwrite(outfile,"cmm3          VT2     leaving   OCA ( 420.000 V ..  ) at %7.4r  %M\n", $abstime );
        VT2_retc=1;
        VT2_cnt=VT2_cnt-1;
        $fclose(outfile);
      end
   end
   else
   begin
      if(VT2_cnt==0)
      begin
        outfile=$fopen(errFileName,"a");
        $strobe("cmm3          VT2     error limit ( %d ) reached at %7.4r  %M", maxEv, $abstime );
        $fwrite(outfile,"cmm3          VT2     error limit ( %d ) reached at %7.4r  %M\n", maxEv, $abstime );
        VT2_cnt=VT2_cnt-1;
        $fclose(outfile);
      end
   end

//      VT1T2
   VT1T2 = V_T1_T2;
   if((VT1T2_cnt>0) || ( maxEv_flg==0 ))   begin
      if( (VT1T2 < -10) && (VT1T2_retc!=-1))
      begin
        outfile=$fopen(errFileName,"a");
        $strobe("cmm3          VT1T2   leaving   OCA (  .. -10.000 V ) at %7.4r  %M", $abstime );
        $fwrite(outfile,"cmm3          VT1T2   leaving   OCA (  .. -10.000 V ) at %7.4r  %M\n", $abstime );
        VT1T2_retc=-1;
        VT1T2_cnt=VT1T2_cnt-1;
        $fclose(outfile);
      end
      if((VT1T2 >= -10) &&  (VT1T2 <= 10) && (VT1T2_retc!=0))
      begin
        outfile=$fopen(errFileName,"a");
        $strobe("cmm3          VT1T2   entering SOCA ( -10.000 V .. 10.000 V ) at %7.4r  %M", $abstime );
        $fwrite(outfile,"cmm3          VT1T2   entering SOCA ( -10.000 V .. 10.000 V ) at %7.4r  %M\n", $abstime );
        VT1T2_retc=0;
        VT1T2_cnt=VT1T2_cnt-1;
        $fclose(outfile);
      end
      if((VT1T2 > 10) &&  (VT1T2_retc!=1))
      begin
        outfile=$fopen(errFileName,"a");
        $strobe("cmm3          VT1T2   leaving   OCA ( 10.000 V ..  ) at %7.4r  %M", $abstime );
        $fwrite(outfile,"cmm3          VT1T2   leaving   OCA ( 10.000 V ..  ) at %7.4r  %M\n", $abstime );
        VT1T2_retc=1;
        VT1T2_cnt=VT1T2_cnt-1;
        $fclose(outfile);
      end
   end
   else
   begin
      if(VT1T2_cnt==0)
      begin
        outfile=$fopen(errFileName,"a");
        $strobe("cmm3          VT1T2   error limit ( %d ) reached at %7.4r  %M", maxEv, $abstime );
        $fwrite(outfile,"cmm3          VT1T2   error limit ( %d ) reached at %7.4r  %M\n", maxEv, $abstime );
        VT1T2_cnt=VT1T2_cnt-1;
        $fclose(outfile);
      end
   end

end // analog
endmodule // cmm3

// Verilog-A OC Watch for device cmm4 Parameters  VT1 VT2 VT1T2
module cmm4_ahdl(T1,T2);
parameter tstep_occ=100n;
parameter errFileName="./occ.err";
parameter maxEv = 25;
parameter maxEv_flg = 0;
inout T1,T2;
electrical T1,T2;

integer outfile;
real V_T1_T2;
real V_T2;
real V_T1;
real VT1;
integer VT1_retc;
integer VT1_cnt;
real VT2;
integer VT2_retc;
integer VT2_cnt;
real VT1T2;
integer VT1T2_retc;
integer VT1T2_cnt;

analog begin
   $bound_step( tstep_occ );
   @(initial_step) begin
      VT1_retc=0;
      VT1_cnt = maxEv;
      VT2_retc=0;
      VT2_cnt = maxEv;
      VT1T2_retc=0;
      VT1T2_cnt = maxEv;
   end
   V_T1_T2 = V(T1,T2);
   V_T2 = V(T2);
   V_T1 = V(T1);

//      VT1
   VT1 = V_T1;
   if((VT1_cnt>0) || ( maxEv_flg==0 ))   begin
      if( (VT1 < -420) && (VT1_retc!=-1))
      begin
        outfile=$fopen(errFileName,"a");
        $strobe("cmm4          VT1     leaving   OCA (  .. -420.000 V ) at %7.4r  %M", $abstime );
        $fwrite(outfile,"cmm4          VT1     leaving   OCA (  .. -420.000 V ) at %7.4r  %M\n", $abstime );
        VT1_retc=-1;
        VT1_cnt=VT1_cnt-1;
        $fclose(outfile);
      end
      if((VT1 >= -420) &&  (VT1 <= 420) && (VT1_retc!=0))
      begin
        outfile=$fopen(errFileName,"a");
        $strobe("cmm4          VT1     entering SOCA ( -420.000 V .. 420.000 V ) at %7.4r  %M", $abstime );
        $fwrite(outfile,"cmm4          VT1     entering SOCA ( -420.000 V .. 420.000 V ) at %7.4r  %M\n", $abstime );
        VT1_retc=0;
        VT1_cnt=VT1_cnt-1;
        $fclose(outfile);
      end
      if((VT1 > 420) &&  (VT1_retc!=1))
      begin
        outfile=$fopen(errFileName,"a");
        $strobe("cmm4          VT1     leaving   OCA ( 420.000 V ..  ) at %7.4r  %M", $abstime );
        $fwrite(outfile,"cmm4          VT1     leaving   OCA ( 420.000 V ..  ) at %7.4r  %M\n", $abstime );
        VT1_retc=1;
        VT1_cnt=VT1_cnt-1;
        $fclose(outfile);
      end
   end
   else
   begin
      if(VT1_cnt==0)
      begin
        outfile=$fopen(errFileName,"a");
        $strobe("cmm4          VT1     error limit ( %d ) reached at %7.4r  %M", maxEv, $abstime );
        $fwrite(outfile,"cmm4          VT1     error limit ( %d ) reached at %7.4r  %M\n", maxEv, $abstime );
        VT1_cnt=VT1_cnt-1;
        $fclose(outfile);
      end
   end

//      VT2
   VT2 = V_T2;
   if((VT2_cnt>0) || ( maxEv_flg==0 ))   begin
      if( (VT2 < -420) && (VT2_retc!=-1))
      begin
        outfile=$fopen(errFileName,"a");
        $strobe("cmm4          VT2     leaving   OCA (  .. -420.000 V ) at %7.4r  %M", $abstime );
        $fwrite(outfile,"cmm4          VT2     leaving   OCA (  .. -420.000 V ) at %7.4r  %M\n", $abstime );
        VT2_retc=-1;
        VT2_cnt=VT2_cnt-1;
        $fclose(outfile);
      end
      if((VT2 >= -420) &&  (VT2 <= 420) && (VT2_retc!=0))
      begin
        outfile=$fopen(errFileName,"a");
        $strobe("cmm4          VT2     entering SOCA ( -420.000 V .. 420.000 V ) at %7.4r  %M", $abstime );
        $fwrite(outfile,"cmm4          VT2     entering SOCA ( -420.000 V .. 420.000 V ) at %7.4r  %M\n", $abstime );
        VT2_retc=0;
        VT2_cnt=VT2_cnt-1;
        $fclose(outfile);
      end
      if((VT2 > 420) &&  (VT2_retc!=1))
      begin
        outfile=$fopen(errFileName,"a");
        $strobe("cmm4          VT2     leaving   OCA ( 420.000 V ..  ) at %7.4r  %M", $abstime );
        $fwrite(outfile,"cmm4          VT2     leaving   OCA ( 420.000 V ..  ) at %7.4r  %M\n", $abstime );
        VT2_retc=1;
        VT2_cnt=VT2_cnt-1;
        $fclose(outfile);
      end
   end
   else
   begin
      if(VT2_cnt==0)
      begin
        outfile=$fopen(errFileName,"a");
        $strobe("cmm4          VT2     error limit ( %d ) reached at %7.4r  %M", maxEv, $abstime );
        $fwrite(outfile,"cmm4          VT2     error limit ( %d ) reached at %7.4r  %M\n", maxEv, $abstime );
        VT2_cnt=VT2_cnt-1;
        $fclose(outfile);
      end
   end

//      VT1T2
   VT1T2 = V_T1_T2;
   if((VT1T2_cnt>0) || ( maxEv_flg==0 ))   begin
      if( (VT1T2 < -10) && (VT1T2_retc!=-1))
      begin
        outfile=$fopen(errFileName,"a");
        $strobe("cmm4          VT1T2   leaving   OCA (  .. -10.000 V ) at %7.4r  %M", $abstime );
        $fwrite(outfile,"cmm4          VT1T2   leaving   OCA (  .. -10.000 V ) at %7.4r  %M\n", $abstime );
        VT1T2_retc=-1;
        VT1T2_cnt=VT1T2_cnt-1;
        $fclose(outfile);
      end
      if((VT1T2 >= -10) &&  (VT1T2 <= 10) && (VT1T2_retc!=0))
      begin
        outfile=$fopen(errFileName,"a");
        $strobe("cmm4          VT1T2   entering SOCA ( -10.000 V .. 10.000 V ) at %7.4r  %M", $abstime );
        $fwrite(outfile,"cmm4          VT1T2   entering SOCA ( -10.000 V .. 10.000 V ) at %7.4r  %M\n", $abstime );
        VT1T2_retc=0;
        VT1T2_cnt=VT1T2_cnt-1;
        $fclose(outfile);
      end
      if((VT1T2 > 10) &&  (VT1T2_retc!=1))
      begin
        outfile=$fopen(errFileName,"a");
        $strobe("cmm4          VT1T2   leaving   OCA ( 10.000 V ..  ) at %7.4r  %M", $abstime );
        $fwrite(outfile,"cmm4          VT1T2   leaving   OCA ( 10.000 V ..  ) at %7.4r  %M\n", $abstime );
        VT1T2_retc=1;
        VT1T2_cnt=VT1T2_cnt-1;
        $fclose(outfile);
      end
   end
   else
   begin
      if(VT1T2_cnt==0)
      begin
        outfile=$fopen(errFileName,"a");
        $strobe("cmm4          VT1T2   error limit ( %d ) reached at %7.4r  %M", maxEv, $abstime );
        $fwrite(outfile,"cmm4          VT1T2   error limit ( %d ) reached at %7.4r  %M\n", maxEv, $abstime );
        VT1T2_cnt=VT1T2_cnt-1;
        $fclose(outfile);
      end
   end

end // analog
endmodule // cmm4

// Verilog-A OC Watch for device cmm5 Parameters  VT1 VT2 VT1T2
module cmm5_ahdl(T1,T2);
parameter tstep_occ=100n;
parameter errFileName="./occ.err";
parameter maxEv = 25;
parameter maxEv_flg = 0;
inout T1,T2;
electrical T1,T2;

integer outfile;
real V_T1_T2;
real V_T2;
real V_T1;
real VT1;
integer VT1_retc;
integer VT1_cnt;
real VT2;
integer VT2_retc;
integer VT2_cnt;
real VT1T2;
integer VT1T2_retc;
integer VT1T2_cnt;

analog begin
   $bound_step( tstep_occ );
   @(initial_step) begin
      VT1_retc=0;
      VT1_cnt = maxEv;
      VT2_retc=0;
      VT2_cnt = maxEv;
      VT1T2_retc=0;
      VT1T2_cnt = maxEv;
   end
   V_T1_T2 = V(T1,T2);
   V_T2 = V(T2);
   V_T1 = V(T1);

//      VT1
   VT1 = V_T1;
   if((VT1_cnt>0) || ( maxEv_flg==0 ))   begin
      if( (VT1 < -420) && (VT1_retc!=-1))
      begin
        outfile=$fopen(errFileName,"a");
        $strobe("cmm5          VT1     leaving   OCA (  .. -420.000 V ) at %7.4r  %M", $abstime );
        $fwrite(outfile,"cmm5          VT1     leaving   OCA (  .. -420.000 V ) at %7.4r  %M\n", $abstime );
        VT1_retc=-1;
        VT1_cnt=VT1_cnt-1;
        $fclose(outfile);
      end
      if((VT1 >= -420) &&  (VT1 <= 420) && (VT1_retc!=0))
      begin
        outfile=$fopen(errFileName,"a");
        $strobe("cmm5          VT1     entering SOCA ( -420.000 V .. 420.000 V ) at %7.4r  %M", $abstime );
        $fwrite(outfile,"cmm5          VT1     entering SOCA ( -420.000 V .. 420.000 V ) at %7.4r  %M\n", $abstime );
        VT1_retc=0;
        VT1_cnt=VT1_cnt-1;
        $fclose(outfile);
      end
      if((VT1 > 420) &&  (VT1_retc!=1))
      begin
        outfile=$fopen(errFileName,"a");
        $strobe("cmm5          VT1     leaving   OCA ( 420.000 V ..  ) at %7.4r  %M", $abstime );
        $fwrite(outfile,"cmm5          VT1     leaving   OCA ( 420.000 V ..  ) at %7.4r  %M\n", $abstime );
        VT1_retc=1;
        VT1_cnt=VT1_cnt-1;
        $fclose(outfile);
      end
   end
   else
   begin
      if(VT1_cnt==0)
      begin
        outfile=$fopen(errFileName,"a");
        $strobe("cmm5          VT1     error limit ( %d ) reached at %7.4r  %M", maxEv, $abstime );
        $fwrite(outfile,"cmm5          VT1     error limit ( %d ) reached at %7.4r  %M\n", maxEv, $abstime );
        VT1_cnt=VT1_cnt-1;
        $fclose(outfile);
      end
   end

//      VT2
   VT2 = V_T2;
   if((VT2_cnt>0) || ( maxEv_flg==0 ))   begin
      if( (VT2 < -420) && (VT2_retc!=-1))
      begin
        outfile=$fopen(errFileName,"a");
        $strobe("cmm5          VT2     leaving   OCA (  .. -420.000 V ) at %7.4r  %M", $abstime );
        $fwrite(outfile,"cmm5          VT2     leaving   OCA (  .. -420.000 V ) at %7.4r  %M\n", $abstime );
        VT2_retc=-1;
        VT2_cnt=VT2_cnt-1;
        $fclose(outfile);
      end
      if((VT2 >= -420) &&  (VT2 <= 420) && (VT2_retc!=0))
      begin
        outfile=$fopen(errFileName,"a");
        $strobe("cmm5          VT2     entering SOCA ( -420.000 V .. 420.000 V ) at %7.4r  %M", $abstime );
        $fwrite(outfile,"cmm5          VT2     entering SOCA ( -420.000 V .. 420.000 V ) at %7.4r  %M\n", $abstime );
        VT2_retc=0;
        VT2_cnt=VT2_cnt-1;
        $fclose(outfile);
      end
      if((VT2 > 420) &&  (VT2_retc!=1))
      begin
        outfile=$fopen(errFileName,"a");
        $strobe("cmm5          VT2     leaving   OCA ( 420.000 V ..  ) at %7.4r  %M", $abstime );
        $fwrite(outfile,"cmm5          VT2     leaving   OCA ( 420.000 V ..  ) at %7.4r  %M\n", $abstime );
        VT2_retc=1;
        VT2_cnt=VT2_cnt-1;
        $fclose(outfile);
      end
   end
   else
   begin
      if(VT2_cnt==0)
      begin
        outfile=$fopen(errFileName,"a");
        $strobe("cmm5          VT2     error limit ( %d ) reached at %7.4r  %M", maxEv, $abstime );
        $fwrite(outfile,"cmm5          VT2     error limit ( %d ) reached at %7.4r  %M\n", maxEv, $abstime );
        VT2_cnt=VT2_cnt-1;
        $fclose(outfile);
      end
   end

//      VT1T2
   VT1T2 = V_T1_T2;
   if((VT1T2_cnt>0) || ( maxEv_flg==0 ))   begin
      if( (VT1T2 < -10) && (VT1T2_retc!=-1))
      begin
        outfile=$fopen(errFileName,"a");
        $strobe("cmm5          VT1T2   leaving   OCA (  .. -10.000 V ) at %7.4r  %M", $abstime );
        $fwrite(outfile,"cmm5          VT1T2   leaving   OCA (  .. -10.000 V ) at %7.4r  %M\n", $abstime );
        VT1T2_retc=-1;
        VT1T2_cnt=VT1T2_cnt-1;
        $fclose(outfile);
      end
      if((VT1T2 >= -10) &&  (VT1T2 <= 10) && (VT1T2_retc!=0))
      begin
        outfile=$fopen(errFileName,"a");
        $strobe("cmm5          VT1T2   entering SOCA ( -10.000 V .. 10.000 V ) at %7.4r  %M", $abstime );
        $fwrite(outfile,"cmm5          VT1T2   entering SOCA ( -10.000 V .. 10.000 V ) at %7.4r  %M\n", $abstime );
        VT1T2_retc=0;
        VT1T2_cnt=VT1T2_cnt-1;
        $fclose(outfile);
      end
      if((VT1T2 > 10) &&  (VT1T2_retc!=1))
      begin
        outfile=$fopen(errFileName,"a");
        $strobe("cmm5          VT1T2   leaving   OCA ( 10.000 V ..  ) at %7.4r  %M", $abstime );
        $fwrite(outfile,"cmm5          VT1T2   leaving   OCA ( 10.000 V ..  ) at %7.4r  %M\n", $abstime );
        VT1T2_retc=1;
        VT1T2_cnt=VT1T2_cnt-1;
        $fclose(outfile);
      end
   end
   else
   begin
      if(VT1T2_cnt==0)
      begin
        outfile=$fopen(errFileName,"a");
        $strobe("cmm5          VT1T2   error limit ( %d ) reached at %7.4r  %M", maxEv, $abstime );
        $fwrite(outfile,"cmm5          VT1T2   error limit ( %d ) reached at %7.4r  %M\n", maxEv, $abstime );
        VT1T2_cnt=VT1T2_cnt-1;
        $fclose(outfile);
      end
   end

end // analog
endmodule // cmm5

// Verilog-A OC Watch for device cmm3t Parameters  VT1 VT2 VT1T2
module cmm3t_ahdl(T1,T2);
parameter tstep_occ=100n;
parameter errFileName="./occ.err";
parameter maxEv = 25;
parameter maxEv_flg = 0;
inout T1,T2;
electrical T1,T2;

integer outfile;
real V_T1_T2;
real V_T2;
real V_T1;
real VT1;
integer VT1_retc;
integer VT1_cnt;
real VT2;
integer VT2_retc;
integer VT2_cnt;
real VT1T2;
integer VT1T2_retc;
integer VT1T2_cnt;

analog begin
   $bound_step( tstep_occ );
   @(initial_step) begin
      VT1_retc=0;
      VT1_cnt = maxEv;
      VT2_retc=0;
      VT2_cnt = maxEv;
      VT1T2_retc=0;
      VT1T2_cnt = maxEv;
   end
   V_T1_T2 = V(T1,T2);
   V_T2 = V(T2);
   V_T1 = V(T1);

//      VT1
   VT1 = V_T1;
   if((VT1_cnt>0) || ( maxEv_flg==0 ))   begin
      if( (VT1 < -420) && (VT1_retc!=-1))
      begin
        outfile=$fopen(errFileName,"a");
        $strobe("cmm3t         VT1     leaving   OCA (  .. -420.000 V ) at %7.4r  %M", $abstime );
        $fwrite(outfile,"cmm3t         VT1     leaving   OCA (  .. -420.000 V ) at %7.4r  %M\n", $abstime );
        VT1_retc=-1;
        VT1_cnt=VT1_cnt-1;
        $fclose(outfile);
      end
      if((VT1 >= -420) &&  (VT1 <= 420) && (VT1_retc!=0))
      begin
        outfile=$fopen(errFileName,"a");
        $strobe("cmm3t         VT1     entering SOCA ( -420.000 V .. 420.000 V ) at %7.4r  %M", $abstime );
        $fwrite(outfile,"cmm3t         VT1     entering SOCA ( -420.000 V .. 420.000 V ) at %7.4r  %M\n", $abstime );
        VT1_retc=0;
        VT1_cnt=VT1_cnt-1;
        $fclose(outfile);
      end
      if((VT1 > 420) &&  (VT1_retc!=1))
      begin
        outfile=$fopen(errFileName,"a");
        $strobe("cmm3t         VT1     leaving   OCA ( 420.000 V ..  ) at %7.4r  %M", $abstime );
        $fwrite(outfile,"cmm3t         VT1     leaving   OCA ( 420.000 V ..  ) at %7.4r  %M\n", $abstime );
        VT1_retc=1;
        VT1_cnt=VT1_cnt-1;
        $fclose(outfile);
      end
   end
   else
   begin
      if(VT1_cnt==0)
      begin
        outfile=$fopen(errFileName,"a");
        $strobe("cmm3t         VT1     error limit ( %d ) reached at %7.4r  %M", maxEv, $abstime );
        $fwrite(outfile,"cmm3t         VT1     error limit ( %d ) reached at %7.4r  %M\n", maxEv, $abstime );
        VT1_cnt=VT1_cnt-1;
        $fclose(outfile);
      end
   end

//      VT2
   VT2 = V_T2;
   if((VT2_cnt>0) || ( maxEv_flg==0 ))   begin
      if( (VT2 < -420) && (VT2_retc!=-1))
      begin
        outfile=$fopen(errFileName,"a");
        $strobe("cmm3t         VT2     leaving   OCA (  .. -420.000 V ) at %7.4r  %M", $abstime );
        $fwrite(outfile,"cmm3t         VT2     leaving   OCA (  .. -420.000 V ) at %7.4r  %M\n", $abstime );
        VT2_retc=-1;
        VT2_cnt=VT2_cnt-1;
        $fclose(outfile);
      end
      if((VT2 >= -420) &&  (VT2 <= 420) && (VT2_retc!=0))
      begin
        outfile=$fopen(errFileName,"a");
        $strobe("cmm3t         VT2     entering SOCA ( -420.000 V .. 420.000 V ) at %7.4r  %M", $abstime );
        $fwrite(outfile,"cmm3t         VT2     entering SOCA ( -420.000 V .. 420.000 V ) at %7.4r  %M\n", $abstime );
        VT2_retc=0;
        VT2_cnt=VT2_cnt-1;
        $fclose(outfile);
      end
      if((VT2 > 420) &&  (VT2_retc!=1))
      begin
        outfile=$fopen(errFileName,"a");
        $strobe("cmm3t         VT2     leaving   OCA ( 420.000 V ..  ) at %7.4r  %M", $abstime );
        $fwrite(outfile,"cmm3t         VT2     leaving   OCA ( 420.000 V ..  ) at %7.4r  %M\n", $abstime );
        VT2_retc=1;
        VT2_cnt=VT2_cnt-1;
        $fclose(outfile);
      end
   end
   else
   begin
      if(VT2_cnt==0)
      begin
        outfile=$fopen(errFileName,"a");
        $strobe("cmm3t         VT2     error limit ( %d ) reached at %7.4r  %M", maxEv, $abstime );
        $fwrite(outfile,"cmm3t         VT2     error limit ( %d ) reached at %7.4r  %M\n", maxEv, $abstime );
        VT2_cnt=VT2_cnt-1;
        $fclose(outfile);
      end
   end

//      VT1T2
   VT1T2 = V_T1_T2;
   if((VT1T2_cnt>0) || ( maxEv_flg==0 ))   begin
      if( (VT1T2 < -10) && (VT1T2_retc!=-1))
      begin
        outfile=$fopen(errFileName,"a");
        $strobe("cmm3t         VT1T2   leaving   OCA (  .. -10.000 V ) at %7.4r  %M", $abstime );
        $fwrite(outfile,"cmm3t         VT1T2   leaving   OCA (  .. -10.000 V ) at %7.4r  %M\n", $abstime );
        VT1T2_retc=-1;
        VT1T2_cnt=VT1T2_cnt-1;
        $fclose(outfile);
      end
      if((VT1T2 >= -10) &&  (VT1T2 <= 10) && (VT1T2_retc!=0))
      begin
        outfile=$fopen(errFileName,"a");
        $strobe("cmm3t         VT1T2   entering SOCA ( -10.000 V .. 10.000 V ) at %7.4r  %M", $abstime );
        $fwrite(outfile,"cmm3t         VT1T2   entering SOCA ( -10.000 V .. 10.000 V ) at %7.4r  %M\n", $abstime );
        VT1T2_retc=0;
        VT1T2_cnt=VT1T2_cnt-1;
        $fclose(outfile);
      end
      if((VT1T2 > 10) &&  (VT1T2_retc!=1))
      begin
        outfile=$fopen(errFileName,"a");
        $strobe("cmm3t         VT1T2   leaving   OCA ( 10.000 V ..  ) at %7.4r  %M", $abstime );
        $fwrite(outfile,"cmm3t         VT1T2   leaving   OCA ( 10.000 V ..  ) at %7.4r  %M\n", $abstime );
        VT1T2_retc=1;
        VT1T2_cnt=VT1T2_cnt-1;
        $fclose(outfile);
      end
   end
   else
   begin
      if(VT1T2_cnt==0)
      begin
        outfile=$fopen(errFileName,"a");
        $strobe("cmm3t         VT1T2   error limit ( %d ) reached at %7.4r  %M", maxEv, $abstime );
        $fwrite(outfile,"cmm3t         VT1T2   error limit ( %d ) reached at %7.4r  %M\n", maxEv, $abstime );
        VT1T2_cnt=VT1T2_cnt-1;
        $fclose(outfile);
      end
   end

end // analog
endmodule // cmm3t

// Verilog-A OC Watch for device cmm4t Parameters  VT1 VT2 VT1T2
module cmm4t_ahdl(T1,T2);
parameter tstep_occ=100n;
parameter errFileName="./occ.err";
parameter maxEv = 25;
parameter maxEv_flg = 0;
inout T1,T2;
electrical T1,T2;

integer outfile;
real V_T1_T2;
real V_T2;
real V_T1;
real VT1;
integer VT1_retc;
integer VT1_cnt;
real VT2;
integer VT2_retc;
integer VT2_cnt;
real VT1T2;
integer VT1T2_retc;
integer VT1T2_cnt;

analog begin
   $bound_step( tstep_occ );
   @(initial_step) begin
      VT1_retc=0;
      VT1_cnt = maxEv;
      VT2_retc=0;
      VT2_cnt = maxEv;
      VT1T2_retc=0;
      VT1T2_cnt = maxEv;
   end
   V_T1_T2 = V(T1,T2);
   V_T2 = V(T2);
   V_T1 = V(T1);

//      VT1
   VT1 = V_T1;
   if((VT1_cnt>0) || ( maxEv_flg==0 ))   begin
      if( (VT1 < -420) && (VT1_retc!=-1))
      begin
        outfile=$fopen(errFileName,"a");
        $strobe("cmm4t         VT1     leaving   OCA (  .. -420.000 V ) at %7.4r  %M", $abstime );
        $fwrite(outfile,"cmm4t         VT1     leaving   OCA (  .. -420.000 V ) at %7.4r  %M\n", $abstime );
        VT1_retc=-1;
        VT1_cnt=VT1_cnt-1;
        $fclose(outfile);
      end
      if((VT1 >= -420) &&  (VT1 <= 420) && (VT1_retc!=0))
      begin
        outfile=$fopen(errFileName,"a");
        $strobe("cmm4t         VT1     entering SOCA ( -420.000 V .. 420.000 V ) at %7.4r  %M", $abstime );
        $fwrite(outfile,"cmm4t         VT1     entering SOCA ( -420.000 V .. 420.000 V ) at %7.4r  %M\n", $abstime );
        VT1_retc=0;
        VT1_cnt=VT1_cnt-1;
        $fclose(outfile);
      end
      if((VT1 > 420) &&  (VT1_retc!=1))
      begin
        outfile=$fopen(errFileName,"a");
        $strobe("cmm4t         VT1     leaving   OCA ( 420.000 V ..  ) at %7.4r  %M", $abstime );
        $fwrite(outfile,"cmm4t         VT1     leaving   OCA ( 420.000 V ..  ) at %7.4r  %M\n", $abstime );
        VT1_retc=1;
        VT1_cnt=VT1_cnt-1;
        $fclose(outfile);
      end
   end
   else
   begin
      if(VT1_cnt==0)
      begin
        outfile=$fopen(errFileName,"a");
        $strobe("cmm4t         VT1     error limit ( %d ) reached at %7.4r  %M", maxEv, $abstime );
        $fwrite(outfile,"cmm4t         VT1     error limit ( %d ) reached at %7.4r  %M\n", maxEv, $abstime );
        VT1_cnt=VT1_cnt-1;
        $fclose(outfile);
      end
   end

//      VT2
   VT2 = V_T2;
   if((VT2_cnt>0) || ( maxEv_flg==0 ))   begin
      if( (VT2 < -420) && (VT2_retc!=-1))
      begin
        outfile=$fopen(errFileName,"a");
        $strobe("cmm4t         VT2     leaving   OCA (  .. -420.000 V ) at %7.4r  %M", $abstime );
        $fwrite(outfile,"cmm4t         VT2     leaving   OCA (  .. -420.000 V ) at %7.4r  %M\n", $abstime );
        VT2_retc=-1;
        VT2_cnt=VT2_cnt-1;
        $fclose(outfile);
      end
      if((VT2 >= -420) &&  (VT2 <= 420) && (VT2_retc!=0))
      begin
        outfile=$fopen(errFileName,"a");
        $strobe("cmm4t         VT2     entering SOCA ( -420.000 V .. 420.000 V ) at %7.4r  %M", $abstime );
        $fwrite(outfile,"cmm4t         VT2     entering SOCA ( -420.000 V .. 420.000 V ) at %7.4r  %M\n", $abstime );
        VT2_retc=0;
        VT2_cnt=VT2_cnt-1;
        $fclose(outfile);
      end
      if((VT2 > 420) &&  (VT2_retc!=1))
      begin
        outfile=$fopen(errFileName,"a");
        $strobe("cmm4t         VT2     leaving   OCA ( 420.000 V ..  ) at %7.4r  %M", $abstime );
        $fwrite(outfile,"cmm4t         VT2     leaving   OCA ( 420.000 V ..  ) at %7.4r  %M\n", $abstime );
        VT2_retc=1;
        VT2_cnt=VT2_cnt-1;
        $fclose(outfile);
      end
   end
   else
   begin
      if(VT2_cnt==0)
      begin
        outfile=$fopen(errFileName,"a");
        $strobe("cmm4t         VT2     error limit ( %d ) reached at %7.4r  %M", maxEv, $abstime );
        $fwrite(outfile,"cmm4t         VT2     error limit ( %d ) reached at %7.4r  %M\n", maxEv, $abstime );
        VT2_cnt=VT2_cnt-1;
        $fclose(outfile);
      end
   end

//      VT1T2
   VT1T2 = V_T1_T2;
   if((VT1T2_cnt>0) || ( maxEv_flg==0 ))   begin
      if( (VT1T2 < -10) && (VT1T2_retc!=-1))
      begin
        outfile=$fopen(errFileName,"a");
        $strobe("cmm4t         VT1T2   leaving   OCA (  .. -10.000 V ) at %7.4r  %M", $abstime );
        $fwrite(outfile,"cmm4t         VT1T2   leaving   OCA (  .. -10.000 V ) at %7.4r  %M\n", $abstime );
        VT1T2_retc=-1;
        VT1T2_cnt=VT1T2_cnt-1;
        $fclose(outfile);
      end
      if((VT1T2 >= -10) &&  (VT1T2 <= 10) && (VT1T2_retc!=0))
      begin
        outfile=$fopen(errFileName,"a");
        $strobe("cmm4t         VT1T2   entering SOCA ( -10.000 V .. 10.000 V ) at %7.4r  %M", $abstime );
        $fwrite(outfile,"cmm4t         VT1T2   entering SOCA ( -10.000 V .. 10.000 V ) at %7.4r  %M\n", $abstime );
        VT1T2_retc=0;
        VT1T2_cnt=VT1T2_cnt-1;
        $fclose(outfile);
      end
      if((VT1T2 > 10) &&  (VT1T2_retc!=1))
      begin
        outfile=$fopen(errFileName,"a");
        $strobe("cmm4t         VT1T2   leaving   OCA ( 10.000 V ..  ) at %7.4r  %M", $abstime );
        $fwrite(outfile,"cmm4t         VT1T2   leaving   OCA ( 10.000 V ..  ) at %7.4r  %M\n", $abstime );
        VT1T2_retc=1;
        VT1T2_cnt=VT1T2_cnt-1;
        $fclose(outfile);
      end
   end
   else
   begin
      if(VT1T2_cnt==0)
      begin
        outfile=$fopen(errFileName,"a");
        $strobe("cmm4t         VT1T2   error limit ( %d ) reached at %7.4r  %M", maxEv, $abstime );
        $fwrite(outfile,"cmm4t         VT1T2   error limit ( %d ) reached at %7.4r  %M\n", maxEv, $abstime );
        VT1T2_cnt=VT1T2_cnt-1;
        $fclose(outfile);
      end
   end

end // analog
endmodule // cmm4t

// Verilog-A OC Watch for device cmm5t Parameters  VT1 VT2 VT1T2
module cmm5t_ahdl(T1,T2);
parameter tstep_occ=100n;
parameter errFileName="./occ.err";
parameter maxEv = 25;
parameter maxEv_flg = 0;
inout T1,T2;
electrical T1,T2;

integer outfile;
real V_T1_T2;
real V_T2;
real V_T1;
real VT1;
integer VT1_retc;
integer VT1_cnt;
real VT2;
integer VT2_retc;
integer VT2_cnt;
real VT1T2;
integer VT1T2_retc;
integer VT1T2_cnt;

analog begin
   $bound_step( tstep_occ );
   @(initial_step) begin
      VT1_retc=0;
      VT1_cnt = maxEv;
      VT2_retc=0;
      VT2_cnt = maxEv;
      VT1T2_retc=0;
      VT1T2_cnt = maxEv;
   end
   V_T1_T2 = V(T1,T2);
   V_T2 = V(T2);
   V_T1 = V(T1);

//      VT1
   VT1 = V_T1;
   if((VT1_cnt>0) || ( maxEv_flg==0 ))   begin
      if( (VT1 < -420) && (VT1_retc!=-1))
      begin
        outfile=$fopen(errFileName,"a");
        $strobe("cmm5t         VT1     leaving   OCA (  .. -420.000 V ) at %7.4r  %M", $abstime );
        $fwrite(outfile,"cmm5t         VT1     leaving   OCA (  .. -420.000 V ) at %7.4r  %M\n", $abstime );
        VT1_retc=-1;
        VT1_cnt=VT1_cnt-1;
        $fclose(outfile);
      end
      if((VT1 >= -420) &&  (VT1 <= 420) && (VT1_retc!=0))
      begin
        outfile=$fopen(errFileName,"a");
        $strobe("cmm5t         VT1     entering SOCA ( -420.000 V .. 420.000 V ) at %7.4r  %M", $abstime );
        $fwrite(outfile,"cmm5t         VT1     entering SOCA ( -420.000 V .. 420.000 V ) at %7.4r  %M\n", $abstime );
        VT1_retc=0;
        VT1_cnt=VT1_cnt-1;
        $fclose(outfile);
      end
      if((VT1 > 420) &&  (VT1_retc!=1))
      begin
        outfile=$fopen(errFileName,"a");
        $strobe("cmm5t         VT1     leaving   OCA ( 420.000 V ..  ) at %7.4r  %M", $abstime );
        $fwrite(outfile,"cmm5t         VT1     leaving   OCA ( 420.000 V ..  ) at %7.4r  %M\n", $abstime );
        VT1_retc=1;
        VT1_cnt=VT1_cnt-1;
        $fclose(outfile);
      end
   end
   else
   begin
      if(VT1_cnt==0)
      begin
        outfile=$fopen(errFileName,"a");
        $strobe("cmm5t         VT1     error limit ( %d ) reached at %7.4r  %M", maxEv, $abstime );
        $fwrite(outfile,"cmm5t         VT1     error limit ( %d ) reached at %7.4r  %M\n", maxEv, $abstime );
        VT1_cnt=VT1_cnt-1;
        $fclose(outfile);
      end
   end

//      VT2
   VT2 = V_T2;
   if((VT2_cnt>0) || ( maxEv_flg==0 ))   begin
      if( (VT2 < -420) && (VT2_retc!=-1))
      begin
        outfile=$fopen(errFileName,"a");
        $strobe("cmm5t         VT2     leaving   OCA (  .. -420.000 V ) at %7.4r  %M", $abstime );
        $fwrite(outfile,"cmm5t         VT2     leaving   OCA (  .. -420.000 V ) at %7.4r  %M\n", $abstime );
        VT2_retc=-1;
        VT2_cnt=VT2_cnt-1;
        $fclose(outfile);
      end
      if((VT2 >= -420) &&  (VT2 <= 420) && (VT2_retc!=0))
      begin
        outfile=$fopen(errFileName,"a");
        $strobe("cmm5t         VT2     entering SOCA ( -420.000 V .. 420.000 V ) at %7.4r  %M", $abstime );
        $fwrite(outfile,"cmm5t         VT2     entering SOCA ( -420.000 V .. 420.000 V ) at %7.4r  %M\n", $abstime );
        VT2_retc=0;
        VT2_cnt=VT2_cnt-1;
        $fclose(outfile);
      end
      if((VT2 > 420) &&  (VT2_retc!=1))
      begin
        outfile=$fopen(errFileName,"a");
        $strobe("cmm5t         VT2     leaving   OCA ( 420.000 V ..  ) at %7.4r  %M", $abstime );
        $fwrite(outfile,"cmm5t         VT2     leaving   OCA ( 420.000 V ..  ) at %7.4r  %M\n", $abstime );
        VT2_retc=1;
        VT2_cnt=VT2_cnt-1;
        $fclose(outfile);
      end
   end
   else
   begin
      if(VT2_cnt==0)
      begin
        outfile=$fopen(errFileName,"a");
        $strobe("cmm5t         VT2     error limit ( %d ) reached at %7.4r  %M", maxEv, $abstime );
        $fwrite(outfile,"cmm5t         VT2     error limit ( %d ) reached at %7.4r  %M\n", maxEv, $abstime );
        VT2_cnt=VT2_cnt-1;
        $fclose(outfile);
      end
   end

//      VT1T2
   VT1T2 = V_T1_T2;
   if((VT1T2_cnt>0) || ( maxEv_flg==0 ))   begin
      if( (VT1T2 < -10) && (VT1T2_retc!=-1))
      begin
        outfile=$fopen(errFileName,"a");
        $strobe("cmm5t         VT1T2   leaving   OCA (  .. -10.000 V ) at %7.4r  %M", $abstime );
        $fwrite(outfile,"cmm5t         VT1T2   leaving   OCA (  .. -10.000 V ) at %7.4r  %M\n", $abstime );
        VT1T2_retc=-1;
        VT1T2_cnt=VT1T2_cnt-1;
        $fclose(outfile);
      end
      if((VT1T2 >= -10) &&  (VT1T2 <= 10) && (VT1T2_retc!=0))
      begin
        outfile=$fopen(errFileName,"a");
        $strobe("cmm5t         VT1T2   entering SOCA ( -10.000 V .. 10.000 V ) at %7.4r  %M", $abstime );
        $fwrite(outfile,"cmm5t         VT1T2   entering SOCA ( -10.000 V .. 10.000 V ) at %7.4r  %M\n", $abstime );
        VT1T2_retc=0;
        VT1T2_cnt=VT1T2_cnt-1;
        $fclose(outfile);
      end
      if((VT1T2 > 10) &&  (VT1T2_retc!=1))
      begin
        outfile=$fopen(errFileName,"a");
        $strobe("cmm5t         VT1T2   leaving   OCA ( 10.000 V ..  ) at %7.4r  %M", $abstime );
        $fwrite(outfile,"cmm5t         VT1T2   leaving   OCA ( 10.000 V ..  ) at %7.4r  %M\n", $abstime );
        VT1T2_retc=1;
        VT1T2_cnt=VT1T2_cnt-1;
        $fclose(outfile);
      end
   end
   else
   begin
      if(VT1T2_cnt==0)
      begin
        outfile=$fopen(errFileName,"a");
        $strobe("cmm5t         VT1T2   error limit ( %d ) reached at %7.4r  %M", maxEv, $abstime );
        $fwrite(outfile,"cmm5t         VT1T2   error limit ( %d ) reached at %7.4r  %M\n", maxEv, $abstime );
        VT1T2_cnt=VT1T2_cnt-1;
        $fclose(outfile);
      end
   end

end // analog
endmodule // cmm5t

// Verilog-A OC Watch for device cmm6t Parameters  VT1 VT2 VT1T2
module cmm6t_ahdl(T1,T2);
parameter tstep_occ=100n;
parameter errFileName="./occ.err";
parameter maxEv = 25;
parameter maxEv_flg = 0;
inout T1,T2;
electrical T1,T2;

integer outfile;
real V_T1_T2;
real V_T2;
real V_T1;
real VT1;
integer VT1_retc;
integer VT1_cnt;
real VT2;
integer VT2_retc;
integer VT2_cnt;
real VT1T2;
integer VT1T2_retc;
integer VT1T2_cnt;

analog begin
   $bound_step( tstep_occ );
   @(initial_step) begin
      VT1_retc=0;
      VT1_cnt = maxEv;
      VT2_retc=0;
      VT2_cnt = maxEv;
      VT1T2_retc=0;
      VT1T2_cnt = maxEv;
   end
   V_T1_T2 = V(T1,T2);
   V_T2 = V(T2);
   V_T1 = V(T1);

//      VT1
   VT1 = V_T1;
   if((VT1_cnt>0) || ( maxEv_flg==0 ))   begin
      if( (VT1 < -420) && (VT1_retc!=-1))
      begin
        outfile=$fopen(errFileName,"a");
        $strobe("cmm6t         VT1     leaving   OCA (  .. -420.000 V ) at %7.4r  %M", $abstime );
        $fwrite(outfile,"cmm6t         VT1     leaving   OCA (  .. -420.000 V ) at %7.4r  %M\n", $abstime );
        VT1_retc=-1;
        VT1_cnt=VT1_cnt-1;
        $fclose(outfile);
      end
      if((VT1 >= -420) &&  (VT1 <= 420) && (VT1_retc!=0))
      begin
        outfile=$fopen(errFileName,"a");
        $strobe("cmm6t         VT1     entering SOCA ( -420.000 V .. 420.000 V ) at %7.4r  %M", $abstime );
        $fwrite(outfile,"cmm6t         VT1     entering SOCA ( -420.000 V .. 420.000 V ) at %7.4r  %M\n", $abstime );
        VT1_retc=0;
        VT1_cnt=VT1_cnt-1;
        $fclose(outfile);
      end
      if((VT1 > 420) &&  (VT1_retc!=1))
      begin
        outfile=$fopen(errFileName,"a");
        $strobe("cmm6t         VT1     leaving   OCA ( 420.000 V ..  ) at %7.4r  %M", $abstime );
        $fwrite(outfile,"cmm6t         VT1     leaving   OCA ( 420.000 V ..  ) at %7.4r  %M\n", $abstime );
        VT1_retc=1;
        VT1_cnt=VT1_cnt-1;
        $fclose(outfile);
      end
   end
   else
   begin
      if(VT1_cnt==0)
      begin
        outfile=$fopen(errFileName,"a");
        $strobe("cmm6t         VT1     error limit ( %d ) reached at %7.4r  %M", maxEv, $abstime );
        $fwrite(outfile,"cmm6t         VT1     error limit ( %d ) reached at %7.4r  %M\n", maxEv, $abstime );
        VT1_cnt=VT1_cnt-1;
        $fclose(outfile);
      end
   end

//      VT2
   VT2 = V_T2;
   if((VT2_cnt>0) || ( maxEv_flg==0 ))   begin
      if( (VT2 < -420) && (VT2_retc!=-1))
      begin
        outfile=$fopen(errFileName,"a");
        $strobe("cmm6t         VT2     leaving   OCA (  .. -420.000 V ) at %7.4r  %M", $abstime );
        $fwrite(outfile,"cmm6t         VT2     leaving   OCA (  .. -420.000 V ) at %7.4r  %M\n", $abstime );
        VT2_retc=-1;
        VT2_cnt=VT2_cnt-1;
        $fclose(outfile);
      end
      if((VT2 >= -420) &&  (VT2 <= 420) && (VT2_retc!=0))
      begin
        outfile=$fopen(errFileName,"a");
        $strobe("cmm6t         VT2     entering SOCA ( -420.000 V .. 420.000 V ) at %7.4r  %M", $abstime );
        $fwrite(outfile,"cmm6t         VT2     entering SOCA ( -420.000 V .. 420.000 V ) at %7.4r  %M\n", $abstime );
        VT2_retc=0;
        VT2_cnt=VT2_cnt-1;
        $fclose(outfile);
      end
      if((VT2 > 420) &&  (VT2_retc!=1))
      begin
        outfile=$fopen(errFileName,"a");
        $strobe("cmm6t         VT2     leaving   OCA ( 420.000 V ..  ) at %7.4r  %M", $abstime );
        $fwrite(outfile,"cmm6t         VT2     leaving   OCA ( 420.000 V ..  ) at %7.4r  %M\n", $abstime );
        VT2_retc=1;
        VT2_cnt=VT2_cnt-1;
        $fclose(outfile);
      end
   end
   else
   begin
      if(VT2_cnt==0)
      begin
        outfile=$fopen(errFileName,"a");
        $strobe("cmm6t         VT2     error limit ( %d ) reached at %7.4r  %M", maxEv, $abstime );
        $fwrite(outfile,"cmm6t         VT2     error limit ( %d ) reached at %7.4r  %M\n", maxEv, $abstime );
        VT2_cnt=VT2_cnt-1;
        $fclose(outfile);
      end
   end

//      VT1T2
   VT1T2 = V_T1_T2;
   if((VT1T2_cnt>0) || ( maxEv_flg==0 ))   begin
      if( (VT1T2 < -10) && (VT1T2_retc!=-1))
      begin
        outfile=$fopen(errFileName,"a");
        $strobe("cmm6t         VT1T2   leaving   OCA (  .. -10.000 V ) at %7.4r  %M", $abstime );
        $fwrite(outfile,"cmm6t         VT1T2   leaving   OCA (  .. -10.000 V ) at %7.4r  %M\n", $abstime );
        VT1T2_retc=-1;
        VT1T2_cnt=VT1T2_cnt-1;
        $fclose(outfile);
      end
      if((VT1T2 >= -10) &&  (VT1T2 <= 10) && (VT1T2_retc!=0))
      begin
        outfile=$fopen(errFileName,"a");
        $strobe("cmm6t         VT1T2   entering SOCA ( -10.000 V .. 10.000 V ) at %7.4r  %M", $abstime );
        $fwrite(outfile,"cmm6t         VT1T2   entering SOCA ( -10.000 V .. 10.000 V ) at %7.4r  %M\n", $abstime );
        VT1T2_retc=0;
        VT1T2_cnt=VT1T2_cnt-1;
        $fclose(outfile);
      end
      if((VT1T2 > 10) &&  (VT1T2_retc!=1))
      begin
        outfile=$fopen(errFileName,"a");
        $strobe("cmm6t         VT1T2   leaving   OCA ( 10.000 V ..  ) at %7.4r  %M", $abstime );
        $fwrite(outfile,"cmm6t         VT1T2   leaving   OCA ( 10.000 V ..  ) at %7.4r  %M\n", $abstime );
        VT1T2_retc=1;
        VT1T2_cnt=VT1T2_cnt-1;
        $fclose(outfile);
      end
   end
   else
   begin
      if(VT1T2_cnt==0)
      begin
        outfile=$fopen(errFileName,"a");
        $strobe("cmm6t         VT1T2   error limit ( %d ) reached at %7.4r  %M", maxEv, $abstime );
        $fwrite(outfile,"cmm6t         VT1T2   error limit ( %d ) reached at %7.4r  %M\n", maxEv, $abstime );
        VT1T2_cnt=VT1T2_cnt-1;
        $fclose(outfile);
      end
   end

end // analog
endmodule // cmm6t

// Verilog-A OC Watch for device cdmm4 Parameters  VT1 VT2 VT1T2
module cdmm4_ahdl(T1,T2);
parameter tstep_occ=100n;
parameter errFileName="./occ.err";
parameter maxEv = 25;
parameter maxEv_flg = 0;
inout T1,T2;
electrical T1,T2;

integer outfile;
real V_T1_T2;
real V_T2;
real V_T1;
real VT1;
integer VT1_retc;
integer VT1_cnt;
real VT2;
integer VT2_retc;
integer VT2_cnt;
real VT1T2;
integer VT1T2_retc;
integer VT1T2_cnt;

analog begin
   $bound_step( tstep_occ );
   @(initial_step) begin
      VT1_retc=0;
      VT1_cnt = maxEv;
      VT2_retc=0;
      VT2_cnt = maxEv;
      VT1T2_retc=0;
      VT1T2_cnt = maxEv;
   end
   V_T1_T2 = V(T1,T2);
   V_T2 = V(T2);
   V_T1 = V(T1);

//      VT1
   VT1 = V_T1;
   if((VT1_cnt>0) || ( maxEv_flg==0 ))   begin
      if( (VT1 < -420) && (VT1_retc!=-1))
      begin
        outfile=$fopen(errFileName,"a");
        $strobe("cdmm4         VT1     leaving   OCA (  .. -420.000 V ) at %7.4r  %M", $abstime );
        $fwrite(outfile,"cdmm4         VT1     leaving   OCA (  .. -420.000 V ) at %7.4r  %M\n", $abstime );
        VT1_retc=-1;
        VT1_cnt=VT1_cnt-1;
        $fclose(outfile);
      end
      if((VT1 >= -420) &&  (VT1 <= 420) && (VT1_retc!=0))
      begin
        outfile=$fopen(errFileName,"a");
        $strobe("cdmm4         VT1     entering SOCA ( -420.000 V .. 420.000 V ) at %7.4r  %M", $abstime );
        $fwrite(outfile,"cdmm4         VT1     entering SOCA ( -420.000 V .. 420.000 V ) at %7.4r  %M\n", $abstime );
        VT1_retc=0;
        VT1_cnt=VT1_cnt-1;
        $fclose(outfile);
      end
      if((VT1 > 420) &&  (VT1_retc!=1))
      begin
        outfile=$fopen(errFileName,"a");
        $strobe("cdmm4         VT1     leaving   OCA ( 420.000 V ..  ) at %7.4r  %M", $abstime );
        $fwrite(outfile,"cdmm4         VT1     leaving   OCA ( 420.000 V ..  ) at %7.4r  %M\n", $abstime );
        VT1_retc=1;
        VT1_cnt=VT1_cnt-1;
        $fclose(outfile);
      end
   end
   else
   begin
      if(VT1_cnt==0)
      begin
        outfile=$fopen(errFileName,"a");
        $strobe("cdmm4         VT1     error limit ( %d ) reached at %7.4r  %M", maxEv, $abstime );
        $fwrite(outfile,"cdmm4         VT1     error limit ( %d ) reached at %7.4r  %M\n", maxEv, $abstime );
        VT1_cnt=VT1_cnt-1;
        $fclose(outfile);
      end
   end

//      VT2
   VT2 = V_T2;
   if((VT2_cnt>0) || ( maxEv_flg==0 ))   begin
      if( (VT2 < -420) && (VT2_retc!=-1))
      begin
        outfile=$fopen(errFileName,"a");
        $strobe("cdmm4         VT2     leaving   OCA (  .. -420.000 V ) at %7.4r  %M", $abstime );
        $fwrite(outfile,"cdmm4         VT2     leaving   OCA (  .. -420.000 V ) at %7.4r  %M\n", $abstime );
        VT2_retc=-1;
        VT2_cnt=VT2_cnt-1;
        $fclose(outfile);
      end
      if((VT2 >= -420) &&  (VT2 <= 420) && (VT2_retc!=0))
      begin
        outfile=$fopen(errFileName,"a");
        $strobe("cdmm4         VT2     entering SOCA ( -420.000 V .. 420.000 V ) at %7.4r  %M", $abstime );
        $fwrite(outfile,"cdmm4         VT2     entering SOCA ( -420.000 V .. 420.000 V ) at %7.4r  %M\n", $abstime );
        VT2_retc=0;
        VT2_cnt=VT2_cnt-1;
        $fclose(outfile);
      end
      if((VT2 > 420) &&  (VT2_retc!=1))
      begin
        outfile=$fopen(errFileName,"a");
        $strobe("cdmm4         VT2     leaving   OCA ( 420.000 V ..  ) at %7.4r  %M", $abstime );
        $fwrite(outfile,"cdmm4         VT2     leaving   OCA ( 420.000 V ..  ) at %7.4r  %M\n", $abstime );
        VT2_retc=1;
        VT2_cnt=VT2_cnt-1;
        $fclose(outfile);
      end
   end
   else
   begin
      if(VT2_cnt==0)
      begin
        outfile=$fopen(errFileName,"a");
        $strobe("cdmm4         VT2     error limit ( %d ) reached at %7.4r  %M", maxEv, $abstime );
        $fwrite(outfile,"cdmm4         VT2     error limit ( %d ) reached at %7.4r  %M\n", maxEv, $abstime );
        VT2_cnt=VT2_cnt-1;
        $fclose(outfile);
      end
   end

//      VT1T2
   VT1T2 = V_T1_T2;
   if((VT1T2_cnt>0) || ( maxEv_flg==0 ))   begin
      if( (VT1T2 < -10) && (VT1T2_retc!=-1))
      begin
        outfile=$fopen(errFileName,"a");
        $strobe("cdmm4         VT1T2   leaving   OCA (  .. -10.000 V ) at %7.4r  %M", $abstime );
        $fwrite(outfile,"cdmm4         VT1T2   leaving   OCA (  .. -10.000 V ) at %7.4r  %M\n", $abstime );
        VT1T2_retc=-1;
        VT1T2_cnt=VT1T2_cnt-1;
        $fclose(outfile);
      end
      if((VT1T2 >= -10) &&  (VT1T2 <= 10) && (VT1T2_retc!=0))
      begin
        outfile=$fopen(errFileName,"a");
        $strobe("cdmm4         VT1T2   entering SOCA ( -10.000 V .. 10.000 V ) at %7.4r  %M", $abstime );
        $fwrite(outfile,"cdmm4         VT1T2   entering SOCA ( -10.000 V .. 10.000 V ) at %7.4r  %M\n", $abstime );
        VT1T2_retc=0;
        VT1T2_cnt=VT1T2_cnt-1;
        $fclose(outfile);
      end
      if((VT1T2 > 10) &&  (VT1T2_retc!=1))
      begin
        outfile=$fopen(errFileName,"a");
        $strobe("cdmm4         VT1T2   leaving   OCA ( 10.000 V ..  ) at %7.4r  %M", $abstime );
        $fwrite(outfile,"cdmm4         VT1T2   leaving   OCA ( 10.000 V ..  ) at %7.4r  %M\n", $abstime );
        VT1T2_retc=1;
        VT1T2_cnt=VT1T2_cnt-1;
        $fclose(outfile);
      end
   end
   else
   begin
      if(VT1T2_cnt==0)
      begin
        outfile=$fopen(errFileName,"a");
        $strobe("cdmm4         VT1T2   error limit ( %d ) reached at %7.4r  %M", maxEv, $abstime );
        $fwrite(outfile,"cdmm4         VT1T2   error limit ( %d ) reached at %7.4r  %M\n", maxEv, $abstime );
        VT1T2_cnt=VT1T2_cnt-1;
        $fclose(outfile);
      end
   end

end // analog
endmodule // cdmm4

// Verilog-A OC Watch for device cdmm5 Parameters  VT1 VT2 VT1T2
module cdmm5_ahdl(T1,T2);
parameter tstep_occ=100n;
parameter errFileName="./occ.err";
parameter maxEv = 25;
parameter maxEv_flg = 0;
inout T1,T2;
electrical T1,T2;

integer outfile;
real V_T1_T2;
real V_T2;
real V_T1;
real VT1;
integer VT1_retc;
integer VT1_cnt;
real VT2;
integer VT2_retc;
integer VT2_cnt;
real VT1T2;
integer VT1T2_retc;
integer VT1T2_cnt;

analog begin
   $bound_step( tstep_occ );
   @(initial_step) begin
      VT1_retc=0;
      VT1_cnt = maxEv;
      VT2_retc=0;
      VT2_cnt = maxEv;
      VT1T2_retc=0;
      VT1T2_cnt = maxEv;
   end
   V_T1_T2 = V(T1,T2);
   V_T2 = V(T2);
   V_T1 = V(T1);

//      VT1
   VT1 = V_T1;
   if((VT1_cnt>0) || ( maxEv_flg==0 ))   begin
      if( (VT1 < -420) && (VT1_retc!=-1))
      begin
        outfile=$fopen(errFileName,"a");
        $strobe("cdmm5         VT1     leaving   OCA (  .. -420.000 V ) at %7.4r  %M", $abstime );
        $fwrite(outfile,"cdmm5         VT1     leaving   OCA (  .. -420.000 V ) at %7.4r  %M\n", $abstime );
        VT1_retc=-1;
        VT1_cnt=VT1_cnt-1;
        $fclose(outfile);
      end
      if((VT1 >= -420) &&  (VT1 <= 420) && (VT1_retc!=0))
      begin
        outfile=$fopen(errFileName,"a");
        $strobe("cdmm5         VT1     entering SOCA ( -420.000 V .. 420.000 V ) at %7.4r  %M", $abstime );
        $fwrite(outfile,"cdmm5         VT1     entering SOCA ( -420.000 V .. 420.000 V ) at %7.4r  %M\n", $abstime );
        VT1_retc=0;
        VT1_cnt=VT1_cnt-1;
        $fclose(outfile);
      end
      if((VT1 > 420) &&  (VT1_retc!=1))
      begin
        outfile=$fopen(errFileName,"a");
        $strobe("cdmm5         VT1     leaving   OCA ( 420.000 V ..  ) at %7.4r  %M", $abstime );
        $fwrite(outfile,"cdmm5         VT1     leaving   OCA ( 420.000 V ..  ) at %7.4r  %M\n", $abstime );
        VT1_retc=1;
        VT1_cnt=VT1_cnt-1;
        $fclose(outfile);
      end
   end
   else
   begin
      if(VT1_cnt==0)
      begin
        outfile=$fopen(errFileName,"a");
        $strobe("cdmm5         VT1     error limit ( %d ) reached at %7.4r  %M", maxEv, $abstime );
        $fwrite(outfile,"cdmm5         VT1     error limit ( %d ) reached at %7.4r  %M\n", maxEv, $abstime );
        VT1_cnt=VT1_cnt-1;
        $fclose(outfile);
      end
   end

//      VT2
   VT2 = V_T2;
   if((VT2_cnt>0) || ( maxEv_flg==0 ))   begin
      if( (VT2 < -420) && (VT2_retc!=-1))
      begin
        outfile=$fopen(errFileName,"a");
        $strobe("cdmm5         VT2     leaving   OCA (  .. -420.000 V ) at %7.4r  %M", $abstime );
        $fwrite(outfile,"cdmm5         VT2     leaving   OCA (  .. -420.000 V ) at %7.4r  %M\n", $abstime );
        VT2_retc=-1;
        VT2_cnt=VT2_cnt-1;
        $fclose(outfile);
      end
      if((VT2 >= -420) &&  (VT2 <= 420) && (VT2_retc!=0))
      begin
        outfile=$fopen(errFileName,"a");
        $strobe("cdmm5         VT2     entering SOCA ( -420.000 V .. 420.000 V ) at %7.4r  %M", $abstime );
        $fwrite(outfile,"cdmm5         VT2     entering SOCA ( -420.000 V .. 420.000 V ) at %7.4r  %M\n", $abstime );
        VT2_retc=0;
        VT2_cnt=VT2_cnt-1;
        $fclose(outfile);
      end
      if((VT2 > 420) &&  (VT2_retc!=1))
      begin
        outfile=$fopen(errFileName,"a");
        $strobe("cdmm5         VT2     leaving   OCA ( 420.000 V ..  ) at %7.4r  %M", $abstime );
        $fwrite(outfile,"cdmm5         VT2     leaving   OCA ( 420.000 V ..  ) at %7.4r  %M\n", $abstime );
        VT2_retc=1;
        VT2_cnt=VT2_cnt-1;
        $fclose(outfile);
      end
   end
   else
   begin
      if(VT2_cnt==0)
      begin
        outfile=$fopen(errFileName,"a");
        $strobe("cdmm5         VT2     error limit ( %d ) reached at %7.4r  %M", maxEv, $abstime );
        $fwrite(outfile,"cdmm5         VT2     error limit ( %d ) reached at %7.4r  %M\n", maxEv, $abstime );
        VT2_cnt=VT2_cnt-1;
        $fclose(outfile);
      end
   end

//      VT1T2
   VT1T2 = V_T1_T2;
   if((VT1T2_cnt>0) || ( maxEv_flg==0 ))   begin
      if( (VT1T2 < -10) && (VT1T2_retc!=-1))
      begin
        outfile=$fopen(errFileName,"a");
        $strobe("cdmm5         VT1T2   leaving   OCA (  .. -10.000 V ) at %7.4r  %M", $abstime );
        $fwrite(outfile,"cdmm5         VT1T2   leaving   OCA (  .. -10.000 V ) at %7.4r  %M\n", $abstime );
        VT1T2_retc=-1;
        VT1T2_cnt=VT1T2_cnt-1;
        $fclose(outfile);
      end
      if((VT1T2 >= -10) &&  (VT1T2 <= 10) && (VT1T2_retc!=0))
      begin
        outfile=$fopen(errFileName,"a");
        $strobe("cdmm5         VT1T2   entering SOCA ( -10.000 V .. 10.000 V ) at %7.4r  %M", $abstime );
        $fwrite(outfile,"cdmm5         VT1T2   entering SOCA ( -10.000 V .. 10.000 V ) at %7.4r  %M\n", $abstime );
        VT1T2_retc=0;
        VT1T2_cnt=VT1T2_cnt-1;
        $fclose(outfile);
      end
      if((VT1T2 > 10) &&  (VT1T2_retc!=1))
      begin
        outfile=$fopen(errFileName,"a");
        $strobe("cdmm5         VT1T2   leaving   OCA ( 10.000 V ..  ) at %7.4r  %M", $abstime );
        $fwrite(outfile,"cdmm5         VT1T2   leaving   OCA ( 10.000 V ..  ) at %7.4r  %M\n", $abstime );
        VT1T2_retc=1;
        VT1T2_cnt=VT1T2_cnt-1;
        $fclose(outfile);
      end
   end
   else
   begin
      if(VT1T2_cnt==0)
      begin
        outfile=$fopen(errFileName,"a");
        $strobe("cdmm5         VT1T2   error limit ( %d ) reached at %7.4r  %M", maxEv, $abstime );
        $fwrite(outfile,"cdmm5         VT1T2   error limit ( %d ) reached at %7.4r  %M\n", maxEv, $abstime );
        VT1T2_cnt=VT1T2_cnt-1;
        $fclose(outfile);
      end
   end

end // analog
endmodule // cdmm5

// Verilog-A OC Watch for device cdmm4t Parameters  VT1 VT2 VT1T2
module cdmm4t_ahdl(T1,T2);
parameter tstep_occ=100n;
parameter errFileName="./occ.err";
parameter maxEv = 25;
parameter maxEv_flg = 0;
inout T1,T2;
electrical T1,T2;

integer outfile;
real V_T1_T2;
real V_T2;
real V_T1;
real VT1;
integer VT1_retc;
integer VT1_cnt;
real VT2;
integer VT2_retc;
integer VT2_cnt;
real VT1T2;
integer VT1T2_retc;
integer VT1T2_cnt;

analog begin
   $bound_step( tstep_occ );
   @(initial_step) begin
      VT1_retc=0;
      VT1_cnt = maxEv;
      VT2_retc=0;
      VT2_cnt = maxEv;
      VT1T2_retc=0;
      VT1T2_cnt = maxEv;
   end
   V_T1_T2 = V(T1,T2);
   V_T2 = V(T2);
   V_T1 = V(T1);

//      VT1
   VT1 = V_T1;
   if((VT1_cnt>0) || ( maxEv_flg==0 ))   begin
      if( (VT1 < -420) && (VT1_retc!=-1))
      begin
        outfile=$fopen(errFileName,"a");
        $strobe("cdmm4t        VT1     leaving   OCA (  .. -420.000 V ) at %7.4r  %M", $abstime );
        $fwrite(outfile,"cdmm4t        VT1     leaving   OCA (  .. -420.000 V ) at %7.4r  %M\n", $abstime );
        VT1_retc=-1;
        VT1_cnt=VT1_cnt-1;
        $fclose(outfile);
      end
      if((VT1 >= -420) &&  (VT1 <= 420) && (VT1_retc!=0))
      begin
        outfile=$fopen(errFileName,"a");
        $strobe("cdmm4t        VT1     entering SOCA ( -420.000 V .. 420.000 V ) at %7.4r  %M", $abstime );
        $fwrite(outfile,"cdmm4t        VT1     entering SOCA ( -420.000 V .. 420.000 V ) at %7.4r  %M\n", $abstime );
        VT1_retc=0;
        VT1_cnt=VT1_cnt-1;
        $fclose(outfile);
      end
      if((VT1 > 420) &&  (VT1_retc!=1))
      begin
        outfile=$fopen(errFileName,"a");
        $strobe("cdmm4t        VT1     leaving   OCA ( 420.000 V ..  ) at %7.4r  %M", $abstime );
        $fwrite(outfile,"cdmm4t        VT1     leaving   OCA ( 420.000 V ..  ) at %7.4r  %M\n", $abstime );
        VT1_retc=1;
        VT1_cnt=VT1_cnt-1;
        $fclose(outfile);
      end
   end
   else
   begin
      if(VT1_cnt==0)
      begin
        outfile=$fopen(errFileName,"a");
        $strobe("cdmm4t        VT1     error limit ( %d ) reached at %7.4r  %M", maxEv, $abstime );
        $fwrite(outfile,"cdmm4t        VT1     error limit ( %d ) reached at %7.4r  %M\n", maxEv, $abstime );
        VT1_cnt=VT1_cnt-1;
        $fclose(outfile);
      end
   end

//      VT2
   VT2 = V_T2;
   if((VT2_cnt>0) || ( maxEv_flg==0 ))   begin
      if( (VT2 < -420) && (VT2_retc!=-1))
      begin
        outfile=$fopen(errFileName,"a");
        $strobe("cdmm4t        VT2     leaving   OCA (  .. -420.000 V ) at %7.4r  %M", $abstime );
        $fwrite(outfile,"cdmm4t        VT2     leaving   OCA (  .. -420.000 V ) at %7.4r  %M\n", $abstime );
        VT2_retc=-1;
        VT2_cnt=VT2_cnt-1;
        $fclose(outfile);
      end
      if((VT2 >= -420) &&  (VT2 <= 420) && (VT2_retc!=0))
      begin
        outfile=$fopen(errFileName,"a");
        $strobe("cdmm4t        VT2     entering SOCA ( -420.000 V .. 420.000 V ) at %7.4r  %M", $abstime );
        $fwrite(outfile,"cdmm4t        VT2     entering SOCA ( -420.000 V .. 420.000 V ) at %7.4r  %M\n", $abstime );
        VT2_retc=0;
        VT2_cnt=VT2_cnt-1;
        $fclose(outfile);
      end
      if((VT2 > 420) &&  (VT2_retc!=1))
      begin
        outfile=$fopen(errFileName,"a");
        $strobe("cdmm4t        VT2     leaving   OCA ( 420.000 V ..  ) at %7.4r  %M", $abstime );
        $fwrite(outfile,"cdmm4t        VT2     leaving   OCA ( 420.000 V ..  ) at %7.4r  %M\n", $abstime );
        VT2_retc=1;
        VT2_cnt=VT2_cnt-1;
        $fclose(outfile);
      end
   end
   else
   begin
      if(VT2_cnt==0)
      begin
        outfile=$fopen(errFileName,"a");
        $strobe("cdmm4t        VT2     error limit ( %d ) reached at %7.4r  %M", maxEv, $abstime );
        $fwrite(outfile,"cdmm4t        VT2     error limit ( %d ) reached at %7.4r  %M\n", maxEv, $abstime );
        VT2_cnt=VT2_cnt-1;
        $fclose(outfile);
      end
   end

//      VT1T2
   VT1T2 = V_T1_T2;
   if((VT1T2_cnt>0) || ( maxEv_flg==0 ))   begin
      if( (VT1T2 < -10) && (VT1T2_retc!=-1))
      begin
        outfile=$fopen(errFileName,"a");
        $strobe("cdmm4t        VT1T2   leaving   OCA (  .. -10.000 V ) at %7.4r  %M", $abstime );
        $fwrite(outfile,"cdmm4t        VT1T2   leaving   OCA (  .. -10.000 V ) at %7.4r  %M\n", $abstime );
        VT1T2_retc=-1;
        VT1T2_cnt=VT1T2_cnt-1;
        $fclose(outfile);
      end
      if((VT1T2 >= -10) &&  (VT1T2 <= 10) && (VT1T2_retc!=0))
      begin
        outfile=$fopen(errFileName,"a");
        $strobe("cdmm4t        VT1T2   entering SOCA ( -10.000 V .. 10.000 V ) at %7.4r  %M", $abstime );
        $fwrite(outfile,"cdmm4t        VT1T2   entering SOCA ( -10.000 V .. 10.000 V ) at %7.4r  %M\n", $abstime );
        VT1T2_retc=0;
        VT1T2_cnt=VT1T2_cnt-1;
        $fclose(outfile);
      end
      if((VT1T2 > 10) &&  (VT1T2_retc!=1))
      begin
        outfile=$fopen(errFileName,"a");
        $strobe("cdmm4t        VT1T2   leaving   OCA ( 10.000 V ..  ) at %7.4r  %M", $abstime );
        $fwrite(outfile,"cdmm4t        VT1T2   leaving   OCA ( 10.000 V ..  ) at %7.4r  %M\n", $abstime );
        VT1T2_retc=1;
        VT1T2_cnt=VT1T2_cnt-1;
        $fclose(outfile);
      end
   end
   else
   begin
      if(VT1T2_cnt==0)
      begin
        outfile=$fopen(errFileName,"a");
        $strobe("cdmm4t        VT1T2   error limit ( %d ) reached at %7.4r  %M", maxEv, $abstime );
        $fwrite(outfile,"cdmm4t        VT1T2   error limit ( %d ) reached at %7.4r  %M\n", maxEv, $abstime );
        VT1T2_cnt=VT1T2_cnt-1;
        $fclose(outfile);
      end
   end

end // analog
endmodule // cdmm4t

// Verilog-A OC Watch for device cdmm5t Parameters  VT1 VT2 VT1T2
module cdmm5t_ahdl(T1,T2);
parameter tstep_occ=100n;
parameter errFileName="./occ.err";
parameter maxEv = 25;
parameter maxEv_flg = 0;
inout T1,T2;
electrical T1,T2;

integer outfile;
real V_T1_T2;
real V_T2;
real V_T1;
real VT1;
integer VT1_retc;
integer VT1_cnt;
real VT2;
integer VT2_retc;
integer VT2_cnt;
real VT1T2;
integer VT1T2_retc;
integer VT1T2_cnt;

analog begin
   $bound_step( tstep_occ );
   @(initial_step) begin
      VT1_retc=0;
      VT1_cnt = maxEv;
      VT2_retc=0;
      VT2_cnt = maxEv;
      VT1T2_retc=0;
      VT1T2_cnt = maxEv;
   end
   V_T1_T2 = V(T1,T2);
   V_T2 = V(T2);
   V_T1 = V(T1);

//      VT1
   VT1 = V_T1;
   if((VT1_cnt>0) || ( maxEv_flg==0 ))   begin
      if( (VT1 < -420) && (VT1_retc!=-1))
      begin
        outfile=$fopen(errFileName,"a");
        $strobe("cdmm5t        VT1     leaving   OCA (  .. -420.000 V ) at %7.4r  %M", $abstime );
        $fwrite(outfile,"cdmm5t        VT1     leaving   OCA (  .. -420.000 V ) at %7.4r  %M\n", $abstime );
        VT1_retc=-1;
        VT1_cnt=VT1_cnt-1;
        $fclose(outfile);
      end
      if((VT1 >= -420) &&  (VT1 <= 420) && (VT1_retc!=0))
      begin
        outfile=$fopen(errFileName,"a");
        $strobe("cdmm5t        VT1     entering SOCA ( -420.000 V .. 420.000 V ) at %7.4r  %M", $abstime );
        $fwrite(outfile,"cdmm5t        VT1     entering SOCA ( -420.000 V .. 420.000 V ) at %7.4r  %M\n", $abstime );
        VT1_retc=0;
        VT1_cnt=VT1_cnt-1;
        $fclose(outfile);
      end
      if((VT1 > 420) &&  (VT1_retc!=1))
      begin
        outfile=$fopen(errFileName,"a");
        $strobe("cdmm5t        VT1     leaving   OCA ( 420.000 V ..  ) at %7.4r  %M", $abstime );
        $fwrite(outfile,"cdmm5t        VT1     leaving   OCA ( 420.000 V ..  ) at %7.4r  %M\n", $abstime );
        VT1_retc=1;
        VT1_cnt=VT1_cnt-1;
        $fclose(outfile);
      end
   end
   else
   begin
      if(VT1_cnt==0)
      begin
        outfile=$fopen(errFileName,"a");
        $strobe("cdmm5t        VT1     error limit ( %d ) reached at %7.4r  %M", maxEv, $abstime );
        $fwrite(outfile,"cdmm5t        VT1     error limit ( %d ) reached at %7.4r  %M\n", maxEv, $abstime );
        VT1_cnt=VT1_cnt-1;
        $fclose(outfile);
      end
   end

//      VT2
   VT2 = V_T2;
   if((VT2_cnt>0) || ( maxEv_flg==0 ))   begin
      if( (VT2 < -420) && (VT2_retc!=-1))
      begin
        outfile=$fopen(errFileName,"a");
        $strobe("cdmm5t        VT2     leaving   OCA (  .. -420.000 V ) at %7.4r  %M", $abstime );
        $fwrite(outfile,"cdmm5t        VT2     leaving   OCA (  .. -420.000 V ) at %7.4r  %M\n", $abstime );
        VT2_retc=-1;
        VT2_cnt=VT2_cnt-1;
        $fclose(outfile);
      end
      if((VT2 >= -420) &&  (VT2 <= 420) && (VT2_retc!=0))
      begin
        outfile=$fopen(errFileName,"a");
        $strobe("cdmm5t        VT2     entering SOCA ( -420.000 V .. 420.000 V ) at %7.4r  %M", $abstime );
        $fwrite(outfile,"cdmm5t        VT2     entering SOCA ( -420.000 V .. 420.000 V ) at %7.4r  %M\n", $abstime );
        VT2_retc=0;
        VT2_cnt=VT2_cnt-1;
        $fclose(outfile);
      end
      if((VT2 > 420) &&  (VT2_retc!=1))
      begin
        outfile=$fopen(errFileName,"a");
        $strobe("cdmm5t        VT2     leaving   OCA ( 420.000 V ..  ) at %7.4r  %M", $abstime );
        $fwrite(outfile,"cdmm5t        VT2     leaving   OCA ( 420.000 V ..  ) at %7.4r  %M\n", $abstime );
        VT2_retc=1;
        VT2_cnt=VT2_cnt-1;
        $fclose(outfile);
      end
   end
   else
   begin
      if(VT2_cnt==0)
      begin
        outfile=$fopen(errFileName,"a");
        $strobe("cdmm5t        VT2     error limit ( %d ) reached at %7.4r  %M", maxEv, $abstime );
        $fwrite(outfile,"cdmm5t        VT2     error limit ( %d ) reached at %7.4r  %M\n", maxEv, $abstime );
        VT2_cnt=VT2_cnt-1;
        $fclose(outfile);
      end
   end

//      VT1T2
   VT1T2 = V_T1_T2;
   if((VT1T2_cnt>0) || ( maxEv_flg==0 ))   begin
      if( (VT1T2 < -10) && (VT1T2_retc!=-1))
      begin
        outfile=$fopen(errFileName,"a");
        $strobe("cdmm5t        VT1T2   leaving   OCA (  .. -10.000 V ) at %7.4r  %M", $abstime );
        $fwrite(outfile,"cdmm5t        VT1T2   leaving   OCA (  .. -10.000 V ) at %7.4r  %M\n", $abstime );
        VT1T2_retc=-1;
        VT1T2_cnt=VT1T2_cnt-1;
        $fclose(outfile);
      end
      if((VT1T2 >= -10) &&  (VT1T2 <= 10) && (VT1T2_retc!=0))
      begin
        outfile=$fopen(errFileName,"a");
        $strobe("cdmm5t        VT1T2   entering SOCA ( -10.000 V .. 10.000 V ) at %7.4r  %M", $abstime );
        $fwrite(outfile,"cdmm5t        VT1T2   entering SOCA ( -10.000 V .. 10.000 V ) at %7.4r  %M\n", $abstime );
        VT1T2_retc=0;
        VT1T2_cnt=VT1T2_cnt-1;
        $fclose(outfile);
      end
      if((VT1T2 > 10) &&  (VT1T2_retc!=1))
      begin
        outfile=$fopen(errFileName,"a");
        $strobe("cdmm5t        VT1T2   leaving   OCA ( 10.000 V ..  ) at %7.4r  %M", $abstime );
        $fwrite(outfile,"cdmm5t        VT1T2   leaving   OCA ( 10.000 V ..  ) at %7.4r  %M\n", $abstime );
        VT1T2_retc=1;
        VT1T2_cnt=VT1T2_cnt-1;
        $fclose(outfile);
      end
   end
   else
   begin
      if(VT1T2_cnt==0)
      begin
        outfile=$fopen(errFileName,"a");
        $strobe("cdmm5t        VT1T2   error limit ( %d ) reached at %7.4r  %M", maxEv, $abstime );
        $fwrite(outfile,"cdmm5t        VT1T2   error limit ( %d ) reached at %7.4r  %M\n", maxEv, $abstime );
        VT1T2_cnt=VT1T2_cnt-1;
        $fclose(outfile);
      end
   end

end // analog
endmodule // cdmm5t

// Verilog-A OC Watch for device ctmm5 Parameters  VT1 VT2 VT1T2
module ctmm5_ahdl(T1,T2);
parameter tstep_occ=100n;
parameter errFileName="./occ.err";
parameter maxEv = 25;
parameter maxEv_flg = 0;
inout T1,T2;
electrical T1,T2;

integer outfile;
real V_T1_T2;
real V_T2;
real V_T1;
real VT1;
integer VT1_retc;
integer VT1_cnt;
real VT2;
integer VT2_retc;
integer VT2_cnt;
real VT1T2;
integer VT1T2_retc;
integer VT1T2_cnt;

analog begin
   $bound_step( tstep_occ );
   @(initial_step) begin
      VT1_retc=0;
      VT1_cnt = maxEv;
      VT2_retc=0;
      VT2_cnt = maxEv;
      VT1T2_retc=0;
      VT1T2_cnt = maxEv;
   end
   V_T1_T2 = V(T1,T2);
   V_T2 = V(T2);
   V_T1 = V(T1);

//      VT1
   VT1 = V_T1;
   if((VT1_cnt>0) || ( maxEv_flg==0 ))   begin
      if( (VT1 < -420) && (VT1_retc!=-1))
      begin
        outfile=$fopen(errFileName,"a");
        $strobe("ctmm5         VT1     leaving   OCA (  .. -420.000 V ) at %7.4r  %M", $abstime );
        $fwrite(outfile,"ctmm5         VT1     leaving   OCA (  .. -420.000 V ) at %7.4r  %M\n", $abstime );
        VT1_retc=-1;
        VT1_cnt=VT1_cnt-1;
        $fclose(outfile);
      end
      if((VT1 >= -420) &&  (VT1 <= 420) && (VT1_retc!=0))
      begin
        outfile=$fopen(errFileName,"a");
        $strobe("ctmm5         VT1     entering SOCA ( -420.000 V .. 420.000 V ) at %7.4r  %M", $abstime );
        $fwrite(outfile,"ctmm5         VT1     entering SOCA ( -420.000 V .. 420.000 V ) at %7.4r  %M\n", $abstime );
        VT1_retc=0;
        VT1_cnt=VT1_cnt-1;
        $fclose(outfile);
      end
      if((VT1 > 420) &&  (VT1_retc!=1))
      begin
        outfile=$fopen(errFileName,"a");
        $strobe("ctmm5         VT1     leaving   OCA ( 420.000 V ..  ) at %7.4r  %M", $abstime );
        $fwrite(outfile,"ctmm5         VT1     leaving   OCA ( 420.000 V ..  ) at %7.4r  %M\n", $abstime );
        VT1_retc=1;
        VT1_cnt=VT1_cnt-1;
        $fclose(outfile);
      end
   end
   else
   begin
      if(VT1_cnt==0)
      begin
        outfile=$fopen(errFileName,"a");
        $strobe("ctmm5         VT1     error limit ( %d ) reached at %7.4r  %M", maxEv, $abstime );
        $fwrite(outfile,"ctmm5         VT1     error limit ( %d ) reached at %7.4r  %M\n", maxEv, $abstime );
        VT1_cnt=VT1_cnt-1;
        $fclose(outfile);
      end
   end

//      VT2
   VT2 = V_T2;
   if((VT2_cnt>0) || ( maxEv_flg==0 ))   begin
      if( (VT2 < -420) && (VT2_retc!=-1))
      begin
        outfile=$fopen(errFileName,"a");
        $strobe("ctmm5         VT2     leaving   OCA (  .. -420.000 V ) at %7.4r  %M", $abstime );
        $fwrite(outfile,"ctmm5         VT2     leaving   OCA (  .. -420.000 V ) at %7.4r  %M\n", $abstime );
        VT2_retc=-1;
        VT2_cnt=VT2_cnt-1;
        $fclose(outfile);
      end
      if((VT2 >= -420) &&  (VT2 <= 420) && (VT2_retc!=0))
      begin
        outfile=$fopen(errFileName,"a");
        $strobe("ctmm5         VT2     entering SOCA ( -420.000 V .. 420.000 V ) at %7.4r  %M", $abstime );
        $fwrite(outfile,"ctmm5         VT2     entering SOCA ( -420.000 V .. 420.000 V ) at %7.4r  %M\n", $abstime );
        VT2_retc=0;
        VT2_cnt=VT2_cnt-1;
        $fclose(outfile);
      end
      if((VT2 > 420) &&  (VT2_retc!=1))
      begin
        outfile=$fopen(errFileName,"a");
        $strobe("ctmm5         VT2     leaving   OCA ( 420.000 V ..  ) at %7.4r  %M", $abstime );
        $fwrite(outfile,"ctmm5         VT2     leaving   OCA ( 420.000 V ..  ) at %7.4r  %M\n", $abstime );
        VT2_retc=1;
        VT2_cnt=VT2_cnt-1;
        $fclose(outfile);
      end
   end
   else
   begin
      if(VT2_cnt==0)
      begin
        outfile=$fopen(errFileName,"a");
        $strobe("ctmm5         VT2     error limit ( %d ) reached at %7.4r  %M", maxEv, $abstime );
        $fwrite(outfile,"ctmm5         VT2     error limit ( %d ) reached at %7.4r  %M\n", maxEv, $abstime );
        VT2_cnt=VT2_cnt-1;
        $fclose(outfile);
      end
   end

//      VT1T2
   VT1T2 = V_T1_T2;
   if((VT1T2_cnt>0) || ( maxEv_flg==0 ))   begin
      if( (VT1T2 < -10) && (VT1T2_retc!=-1))
      begin
        outfile=$fopen(errFileName,"a");
        $strobe("ctmm5         VT1T2   leaving   OCA (  .. -10.000 V ) at %7.4r  %M", $abstime );
        $fwrite(outfile,"ctmm5         VT1T2   leaving   OCA (  .. -10.000 V ) at %7.4r  %M\n", $abstime );
        VT1T2_retc=-1;
        VT1T2_cnt=VT1T2_cnt-1;
        $fclose(outfile);
      end
      if((VT1T2 >= -10) &&  (VT1T2 <= 10) && (VT1T2_retc!=0))
      begin
        outfile=$fopen(errFileName,"a");
        $strobe("ctmm5         VT1T2   entering SOCA ( -10.000 V .. 10.000 V ) at %7.4r  %M", $abstime );
        $fwrite(outfile,"ctmm5         VT1T2   entering SOCA ( -10.000 V .. 10.000 V ) at %7.4r  %M\n", $abstime );
        VT1T2_retc=0;
        VT1T2_cnt=VT1T2_cnt-1;
        $fclose(outfile);
      end
      if((VT1T2 > 10) &&  (VT1T2_retc!=1))
      begin
        outfile=$fopen(errFileName,"a");
        $strobe("ctmm5         VT1T2   leaving   OCA ( 10.000 V ..  ) at %7.4r  %M", $abstime );
        $fwrite(outfile,"ctmm5         VT1T2   leaving   OCA ( 10.000 V ..  ) at %7.4r  %M\n", $abstime );
        VT1T2_retc=1;
        VT1T2_cnt=VT1T2_cnt-1;
        $fclose(outfile);
      end
   end
   else
   begin
      if(VT1T2_cnt==0)
      begin
        outfile=$fopen(errFileName,"a");
        $strobe("ctmm5         VT1T2   error limit ( %d ) reached at %7.4r  %M", maxEv, $abstime );
        $fwrite(outfile,"ctmm5         VT1T2   error limit ( %d ) reached at %7.4r  %M\n", maxEv, $abstime );
        VT1T2_cnt=VT1T2_cnt-1;
        $fclose(outfile);
      end
   end

end // analog
endmodule // ctmm5

// Verilog-A OC Watch for device ctmm5t Parameters  VT1 VT2 VT1T2
module ctmm5t_ahdl(T1,T2);
parameter tstep_occ=100n;
parameter errFileName="./occ.err";
parameter maxEv = 25;
parameter maxEv_flg = 0;
inout T1,T2;
electrical T1,T2;

integer outfile;
real V_T1_T2;
real V_T2;
real V_T1;
real VT1;
integer VT1_retc;
integer VT1_cnt;
real VT2;
integer VT2_retc;
integer VT2_cnt;
real VT1T2;
integer VT1T2_retc;
integer VT1T2_cnt;

analog begin
   $bound_step( tstep_occ );
   @(initial_step) begin
      VT1_retc=0;
      VT1_cnt = maxEv;
      VT2_retc=0;
      VT2_cnt = maxEv;
      VT1T2_retc=0;
      VT1T2_cnt = maxEv;
   end
   V_T1_T2 = V(T1,T2);
   V_T2 = V(T2);
   V_T1 = V(T1);

//      VT1
   VT1 = V_T1;
   if((VT1_cnt>0) || ( maxEv_flg==0 ))   begin
      if( (VT1 < -420) && (VT1_retc!=-1))
      begin
        outfile=$fopen(errFileName,"a");
        $strobe("ctmm5t        VT1     leaving   OCA (  .. -420.000 V ) at %7.4r  %M", $abstime );
        $fwrite(outfile,"ctmm5t        VT1     leaving   OCA (  .. -420.000 V ) at %7.4r  %M\n", $abstime );
        VT1_retc=-1;
        VT1_cnt=VT1_cnt-1;
        $fclose(outfile);
      end
      if((VT1 >= -420) &&  (VT1 <= 420) && (VT1_retc!=0))
      begin
        outfile=$fopen(errFileName,"a");
        $strobe("ctmm5t        VT1     entering SOCA ( -420.000 V .. 420.000 V ) at %7.4r  %M", $abstime );
        $fwrite(outfile,"ctmm5t        VT1     entering SOCA ( -420.000 V .. 420.000 V ) at %7.4r  %M\n", $abstime );
        VT1_retc=0;
        VT1_cnt=VT1_cnt-1;
        $fclose(outfile);
      end
      if((VT1 > 420) &&  (VT1_retc!=1))
      begin
        outfile=$fopen(errFileName,"a");
        $strobe("ctmm5t        VT1     leaving   OCA ( 420.000 V ..  ) at %7.4r  %M", $abstime );
        $fwrite(outfile,"ctmm5t        VT1     leaving   OCA ( 420.000 V ..  ) at %7.4r  %M\n", $abstime );
        VT1_retc=1;
        VT1_cnt=VT1_cnt-1;
        $fclose(outfile);
      end
   end
   else
   begin
      if(VT1_cnt==0)
      begin
        outfile=$fopen(errFileName,"a");
        $strobe("ctmm5t        VT1     error limit ( %d ) reached at %7.4r  %M", maxEv, $abstime );
        $fwrite(outfile,"ctmm5t        VT1     error limit ( %d ) reached at %7.4r  %M\n", maxEv, $abstime );
        VT1_cnt=VT1_cnt-1;
        $fclose(outfile);
      end
   end

//      VT2
   VT2 = V_T2;
   if((VT2_cnt>0) || ( maxEv_flg==0 ))   begin
      if( (VT2 < -420) && (VT2_retc!=-1))
      begin
        outfile=$fopen(errFileName,"a");
        $strobe("ctmm5t        VT2     leaving   OCA (  .. -420.000 V ) at %7.4r  %M", $abstime );
        $fwrite(outfile,"ctmm5t        VT2     leaving   OCA (  .. -420.000 V ) at %7.4r  %M\n", $abstime );
        VT2_retc=-1;
        VT2_cnt=VT2_cnt-1;
        $fclose(outfile);
      end
      if((VT2 >= -420) &&  (VT2 <= 420) && (VT2_retc!=0))
      begin
        outfile=$fopen(errFileName,"a");
        $strobe("ctmm5t        VT2     entering SOCA ( -420.000 V .. 420.000 V ) at %7.4r  %M", $abstime );
        $fwrite(outfile,"ctmm5t        VT2     entering SOCA ( -420.000 V .. 420.000 V ) at %7.4r  %M\n", $abstime );
        VT2_retc=0;
        VT2_cnt=VT2_cnt-1;
        $fclose(outfile);
      end
      if((VT2 > 420) &&  (VT2_retc!=1))
      begin
        outfile=$fopen(errFileName,"a");
        $strobe("ctmm5t        VT2     leaving   OCA ( 420.000 V ..  ) at %7.4r  %M", $abstime );
        $fwrite(outfile,"ctmm5t        VT2     leaving   OCA ( 420.000 V ..  ) at %7.4r  %M\n", $abstime );
        VT2_retc=1;
        VT2_cnt=VT2_cnt-1;
        $fclose(outfile);
      end
   end
   else
   begin
      if(VT2_cnt==0)
      begin
        outfile=$fopen(errFileName,"a");
        $strobe("ctmm5t        VT2     error limit ( %d ) reached at %7.4r  %M", maxEv, $abstime );
        $fwrite(outfile,"ctmm5t        VT2     error limit ( %d ) reached at %7.4r  %M\n", maxEv, $abstime );
        VT2_cnt=VT2_cnt-1;
        $fclose(outfile);
      end
   end

//      VT1T2
   VT1T2 = V_T1_T2;
   if((VT1T2_cnt>0) || ( maxEv_flg==0 ))   begin
      if( (VT1T2 < -10) && (VT1T2_retc!=-1))
      begin
        outfile=$fopen(errFileName,"a");
        $strobe("ctmm5t        VT1T2   leaving   OCA (  .. -10.000 V ) at %7.4r  %M", $abstime );
        $fwrite(outfile,"ctmm5t        VT1T2   leaving   OCA (  .. -10.000 V ) at %7.4r  %M\n", $abstime );
        VT1T2_retc=-1;
        VT1T2_cnt=VT1T2_cnt-1;
        $fclose(outfile);
      end
      if((VT1T2 >= -10) &&  (VT1T2 <= 10) && (VT1T2_retc!=0))
      begin
        outfile=$fopen(errFileName,"a");
        $strobe("ctmm5t        VT1T2   entering SOCA ( -10.000 V .. 10.000 V ) at %7.4r  %M", $abstime );
        $fwrite(outfile,"ctmm5t        VT1T2   entering SOCA ( -10.000 V .. 10.000 V ) at %7.4r  %M\n", $abstime );
        VT1T2_retc=0;
        VT1T2_cnt=VT1T2_cnt-1;
        $fclose(outfile);
      end
      if((VT1T2 > 10) &&  (VT1T2_retc!=1))
      begin
        outfile=$fopen(errFileName,"a");
        $strobe("ctmm5t        VT1T2   leaving   OCA ( 10.000 V ..  ) at %7.4r  %M", $abstime );
        $fwrite(outfile,"ctmm5t        VT1T2   leaving   OCA ( 10.000 V ..  ) at %7.4r  %M\n", $abstime );
        VT1T2_retc=1;
        VT1T2_cnt=VT1T2_cnt-1;
        $fclose(outfile);
      end
   end
   else
   begin
      if(VT1T2_cnt==0)
      begin
        outfile=$fopen(errFileName,"a");
        $strobe("ctmm5t        VT1T2   error limit ( %d ) reached at %7.4r  %M", maxEv, $abstime );
        $fwrite(outfile,"ctmm5t        VT1T2   error limit ( %d ) reached at %7.4r  %M\n", maxEv, $abstime );
        VT1T2_cnt=VT1T2_cnt-1;
        $fclose(outfile);
      end
   end

end // analog
endmodule // ctmm5t

// Verilog-A OC Watch for device cmmh3 Parameters  VT1 VT2 VT1T2
module cmmh3_ahdl(T1,T2);
parameter tstep_occ=100n;
parameter errFileName="./occ.err";
parameter maxEv = 25;
parameter maxEv_flg = 0;
inout T1,T2;
electrical T1,T2;

integer outfile;
real V_T1_T2;
real V_T2;
real V_T1;
real VT1;
integer VT1_retc;
integer VT1_cnt;
real VT2;
integer VT2_retc;
integer VT2_cnt;
real VT1T2;
integer VT1T2_retc;
integer VT1T2_cnt;

analog begin
   $bound_step( tstep_occ );
   @(initial_step) begin
      VT1_retc=0;
      VT1_cnt = maxEv;
      VT2_retc=0;
      VT2_cnt = maxEv;
      VT1T2_retc=0;
      VT1T2_cnt = maxEv;
   end
   V_T1_T2 = V(T1,T2);
   V_T2 = V(T2);
   V_T1 = V(T1);

//      VT1
   VT1 = V_T1;
   if((VT1_cnt>0) || ( maxEv_flg==0 ))   begin
      if( (VT1 < -420) && (VT1_retc!=-1))
      begin
        outfile=$fopen(errFileName,"a");
        $strobe("cmmh3         VT1     leaving   OCA (  .. -420.000 V ) at %7.4r  %M", $abstime );
        $fwrite(outfile,"cmmh3         VT1     leaving   OCA (  .. -420.000 V ) at %7.4r  %M\n", $abstime );
        VT1_retc=-1;
        VT1_cnt=VT1_cnt-1;
        $fclose(outfile);
      end
      if((VT1 >= -420) &&  (VT1 <= 420) && (VT1_retc!=0))
      begin
        outfile=$fopen(errFileName,"a");
        $strobe("cmmh3         VT1     entering SOCA ( -420.000 V .. 420.000 V ) at %7.4r  %M", $abstime );
        $fwrite(outfile,"cmmh3         VT1     entering SOCA ( -420.000 V .. 420.000 V ) at %7.4r  %M\n", $abstime );
        VT1_retc=0;
        VT1_cnt=VT1_cnt-1;
        $fclose(outfile);
      end
      if((VT1 > 420) &&  (VT1_retc!=1))
      begin
        outfile=$fopen(errFileName,"a");
        $strobe("cmmh3         VT1     leaving   OCA ( 420.000 V ..  ) at %7.4r  %M", $abstime );
        $fwrite(outfile,"cmmh3         VT1     leaving   OCA ( 420.000 V ..  ) at %7.4r  %M\n", $abstime );
        VT1_retc=1;
        VT1_cnt=VT1_cnt-1;
        $fclose(outfile);
      end
   end
   else
   begin
      if(VT1_cnt==0)
      begin
        outfile=$fopen(errFileName,"a");
        $strobe("cmmh3         VT1     error limit ( %d ) reached at %7.4r  %M", maxEv, $abstime );
        $fwrite(outfile,"cmmh3         VT1     error limit ( %d ) reached at %7.4r  %M\n", maxEv, $abstime );
        VT1_cnt=VT1_cnt-1;
        $fclose(outfile);
      end
   end

//      VT2
   VT2 = V_T2;
   if((VT2_cnt>0) || ( maxEv_flg==0 ))   begin
      if( (VT2 < -420) && (VT2_retc!=-1))
      begin
        outfile=$fopen(errFileName,"a");
        $strobe("cmmh3         VT2     leaving   OCA (  .. -420.000 V ) at %7.4r  %M", $abstime );
        $fwrite(outfile,"cmmh3         VT2     leaving   OCA (  .. -420.000 V ) at %7.4r  %M\n", $abstime );
        VT2_retc=-1;
        VT2_cnt=VT2_cnt-1;
        $fclose(outfile);
      end
      if((VT2 >= -420) &&  (VT2 <= 420) && (VT2_retc!=0))
      begin
        outfile=$fopen(errFileName,"a");
        $strobe("cmmh3         VT2     entering SOCA ( -420.000 V .. 420.000 V ) at %7.4r  %M", $abstime );
        $fwrite(outfile,"cmmh3         VT2     entering SOCA ( -420.000 V .. 420.000 V ) at %7.4r  %M\n", $abstime );
        VT2_retc=0;
        VT2_cnt=VT2_cnt-1;
        $fclose(outfile);
      end
      if((VT2 > 420) &&  (VT2_retc!=1))
      begin
        outfile=$fopen(errFileName,"a");
        $strobe("cmmh3         VT2     leaving   OCA ( 420.000 V ..  ) at %7.4r  %M", $abstime );
        $fwrite(outfile,"cmmh3         VT2     leaving   OCA ( 420.000 V ..  ) at %7.4r  %M\n", $abstime );
        VT2_retc=1;
        VT2_cnt=VT2_cnt-1;
        $fclose(outfile);
      end
   end
   else
   begin
      if(VT2_cnt==0)
      begin
        outfile=$fopen(errFileName,"a");
        $strobe("cmmh3         VT2     error limit ( %d ) reached at %7.4r  %M", maxEv, $abstime );
        $fwrite(outfile,"cmmh3         VT2     error limit ( %d ) reached at %7.4r  %M\n", maxEv, $abstime );
        VT2_cnt=VT2_cnt-1;
        $fclose(outfile);
      end
   end

//      VT1T2
   VT1T2 = V_T1_T2;
   if((VT1T2_cnt>0) || ( maxEv_flg==0 ))   begin
      if( (VT1T2 < -5.5) && (VT1T2_retc!=-1))
      begin
        outfile=$fopen(errFileName,"a");
        $strobe("cmmh3         VT1T2   leaving   OCA (  .. -5.500 V ) at %7.4r  %M", $abstime );
        $fwrite(outfile,"cmmh3         VT1T2   leaving   OCA (  .. -5.500 V ) at %7.4r  %M\n", $abstime );
        VT1T2_retc=-1;
        VT1T2_cnt=VT1T2_cnt-1;
        $fclose(outfile);
      end
      if((VT1T2 >= -5.5) &&  (VT1T2 <= 5.5) && (VT1T2_retc!=0))
      begin
        outfile=$fopen(errFileName,"a");
        $strobe("cmmh3         VT1T2   entering SOCA ( -5.500 V .. 5.500 V ) at %7.4r  %M", $abstime );
        $fwrite(outfile,"cmmh3         VT1T2   entering SOCA ( -5.500 V .. 5.500 V ) at %7.4r  %M\n", $abstime );
        VT1T2_retc=0;
        VT1T2_cnt=VT1T2_cnt-1;
        $fclose(outfile);
      end
      if((VT1T2 > 5.5) &&  (VT1T2_retc!=1))
      begin
        outfile=$fopen(errFileName,"a");
        $strobe("cmmh3         VT1T2   leaving   OCA ( 5.500 V ..  ) at %7.4r  %M", $abstime );
        $fwrite(outfile,"cmmh3         VT1T2   leaving   OCA ( 5.500 V ..  ) at %7.4r  %M\n", $abstime );
        VT1T2_retc=1;
        VT1T2_cnt=VT1T2_cnt-1;
        $fclose(outfile);
      end
   end
   else
   begin
      if(VT1T2_cnt==0)
      begin
        outfile=$fopen(errFileName,"a");
        $strobe("cmmh3         VT1T2   error limit ( %d ) reached at %7.4r  %M", maxEv, $abstime );
        $fwrite(outfile,"cmmh3         VT1T2   error limit ( %d ) reached at %7.4r  %M\n", maxEv, $abstime );
        VT1T2_cnt=VT1T2_cnt-1;
        $fclose(outfile);
      end
   end

end // analog
endmodule // cmmh3

// Verilog-A OC Watch for device cmmh4 Parameters  VT1 VT2 VT1T2
module cmmh4_ahdl(T1,T2);
parameter tstep_occ=100n;
parameter errFileName="./occ.err";
parameter maxEv = 25;
parameter maxEv_flg = 0;
inout T1,T2;
electrical T1,T2;

integer outfile;
real V_T1_T2;
real V_T2;
real V_T1;
real VT1;
integer VT1_retc;
integer VT1_cnt;
real VT2;
integer VT2_retc;
integer VT2_cnt;
real VT1T2;
integer VT1T2_retc;
integer VT1T2_cnt;

analog begin
   $bound_step( tstep_occ );
   @(initial_step) begin
      VT1_retc=0;
      VT1_cnt = maxEv;
      VT2_retc=0;
      VT2_cnt = maxEv;
      VT1T2_retc=0;
      VT1T2_cnt = maxEv;
   end
   V_T1_T2 = V(T1,T2);
   V_T2 = V(T2);
   V_T1 = V(T1);

//      VT1
   VT1 = V_T1;
   if((VT1_cnt>0) || ( maxEv_flg==0 ))   begin
      if( (VT1 < -420) && (VT1_retc!=-1))
      begin
        outfile=$fopen(errFileName,"a");
        $strobe("cmmh4         VT1     leaving   OCA (  .. -420.000 V ) at %7.4r  %M", $abstime );
        $fwrite(outfile,"cmmh4         VT1     leaving   OCA (  .. -420.000 V ) at %7.4r  %M\n", $abstime );
        VT1_retc=-1;
        VT1_cnt=VT1_cnt-1;
        $fclose(outfile);
      end
      if((VT1 >= -420) &&  (VT1 <= 420) && (VT1_retc!=0))
      begin
        outfile=$fopen(errFileName,"a");
        $strobe("cmmh4         VT1     entering SOCA ( -420.000 V .. 420.000 V ) at %7.4r  %M", $abstime );
        $fwrite(outfile,"cmmh4         VT1     entering SOCA ( -420.000 V .. 420.000 V ) at %7.4r  %M\n", $abstime );
        VT1_retc=0;
        VT1_cnt=VT1_cnt-1;
        $fclose(outfile);
      end
      if((VT1 > 420) &&  (VT1_retc!=1))
      begin
        outfile=$fopen(errFileName,"a");
        $strobe("cmmh4         VT1     leaving   OCA ( 420.000 V ..  ) at %7.4r  %M", $abstime );
        $fwrite(outfile,"cmmh4         VT1     leaving   OCA ( 420.000 V ..  ) at %7.4r  %M\n", $abstime );
        VT1_retc=1;
        VT1_cnt=VT1_cnt-1;
        $fclose(outfile);
      end
   end
   else
   begin
      if(VT1_cnt==0)
      begin
        outfile=$fopen(errFileName,"a");
        $strobe("cmmh4         VT1     error limit ( %d ) reached at %7.4r  %M", maxEv, $abstime );
        $fwrite(outfile,"cmmh4         VT1     error limit ( %d ) reached at %7.4r  %M\n", maxEv, $abstime );
        VT1_cnt=VT1_cnt-1;
        $fclose(outfile);
      end
   end

//      VT2
   VT2 = V_T2;
   if((VT2_cnt>0) || ( maxEv_flg==0 ))   begin
      if( (VT2 < -420) && (VT2_retc!=-1))
      begin
        outfile=$fopen(errFileName,"a");
        $strobe("cmmh4         VT2     leaving   OCA (  .. -420.000 V ) at %7.4r  %M", $abstime );
        $fwrite(outfile,"cmmh4         VT2     leaving   OCA (  .. -420.000 V ) at %7.4r  %M\n", $abstime );
        VT2_retc=-1;
        VT2_cnt=VT2_cnt-1;
        $fclose(outfile);
      end
      if((VT2 >= -420) &&  (VT2 <= 420) && (VT2_retc!=0))
      begin
        outfile=$fopen(errFileName,"a");
        $strobe("cmmh4         VT2     entering SOCA ( -420.000 V .. 420.000 V ) at %7.4r  %M", $abstime );
        $fwrite(outfile,"cmmh4         VT2     entering SOCA ( -420.000 V .. 420.000 V ) at %7.4r  %M\n", $abstime );
        VT2_retc=0;
        VT2_cnt=VT2_cnt-1;
        $fclose(outfile);
      end
      if((VT2 > 420) &&  (VT2_retc!=1))
      begin
        outfile=$fopen(errFileName,"a");
        $strobe("cmmh4         VT2     leaving   OCA ( 420.000 V ..  ) at %7.4r  %M", $abstime );
        $fwrite(outfile,"cmmh4         VT2     leaving   OCA ( 420.000 V ..  ) at %7.4r  %M\n", $abstime );
        VT2_retc=1;
        VT2_cnt=VT2_cnt-1;
        $fclose(outfile);
      end
   end
   else
   begin
      if(VT2_cnt==0)
      begin
        outfile=$fopen(errFileName,"a");
        $strobe("cmmh4         VT2     error limit ( %d ) reached at %7.4r  %M", maxEv, $abstime );
        $fwrite(outfile,"cmmh4         VT2     error limit ( %d ) reached at %7.4r  %M\n", maxEv, $abstime );
        VT2_cnt=VT2_cnt-1;
        $fclose(outfile);
      end
   end

//      VT1T2
   VT1T2 = V_T1_T2;
   if((VT1T2_cnt>0) || ( maxEv_flg==0 ))   begin
      if( (VT1T2 < -5.5) && (VT1T2_retc!=-1))
      begin
        outfile=$fopen(errFileName,"a");
        $strobe("cmmh4         VT1T2   leaving   OCA (  .. -5.500 V ) at %7.4r  %M", $abstime );
        $fwrite(outfile,"cmmh4         VT1T2   leaving   OCA (  .. -5.500 V ) at %7.4r  %M\n", $abstime );
        VT1T2_retc=-1;
        VT1T2_cnt=VT1T2_cnt-1;
        $fclose(outfile);
      end
      if((VT1T2 >= -5.5) &&  (VT1T2 <= 5.5) && (VT1T2_retc!=0))
      begin
        outfile=$fopen(errFileName,"a");
        $strobe("cmmh4         VT1T2   entering SOCA ( -5.500 V .. 5.500 V ) at %7.4r  %M", $abstime );
        $fwrite(outfile,"cmmh4         VT1T2   entering SOCA ( -5.500 V .. 5.500 V ) at %7.4r  %M\n", $abstime );
        VT1T2_retc=0;
        VT1T2_cnt=VT1T2_cnt-1;
        $fclose(outfile);
      end
      if((VT1T2 > 5.5) &&  (VT1T2_retc!=1))
      begin
        outfile=$fopen(errFileName,"a");
        $strobe("cmmh4         VT1T2   leaving   OCA ( 5.500 V ..  ) at %7.4r  %M", $abstime );
        $fwrite(outfile,"cmmh4         VT1T2   leaving   OCA ( 5.500 V ..  ) at %7.4r  %M\n", $abstime );
        VT1T2_retc=1;
        VT1T2_cnt=VT1T2_cnt-1;
        $fclose(outfile);
      end
   end
   else
   begin
      if(VT1T2_cnt==0)
      begin
        outfile=$fopen(errFileName,"a");
        $strobe("cmmh4         VT1T2   error limit ( %d ) reached at %7.4r  %M", maxEv, $abstime );
        $fwrite(outfile,"cmmh4         VT1T2   error limit ( %d ) reached at %7.4r  %M\n", maxEv, $abstime );
        VT1T2_cnt=VT1T2_cnt-1;
        $fclose(outfile);
      end
   end

end // analog
endmodule // cmmh4

// Verilog-A OC Watch for device cmmh5 Parameters  VT1 VT2 VT1T2
module cmmh5_ahdl(T1,T2);
parameter tstep_occ=100n;
parameter errFileName="./occ.err";
parameter maxEv = 25;
parameter maxEv_flg = 0;
inout T1,T2;
electrical T1,T2;

integer outfile;
real V_T1_T2;
real V_T2;
real V_T1;
real VT1;
integer VT1_retc;
integer VT1_cnt;
real VT2;
integer VT2_retc;
integer VT2_cnt;
real VT1T2;
integer VT1T2_retc;
integer VT1T2_cnt;

analog begin
   $bound_step( tstep_occ );
   @(initial_step) begin
      VT1_retc=0;
      VT1_cnt = maxEv;
      VT2_retc=0;
      VT2_cnt = maxEv;
      VT1T2_retc=0;
      VT1T2_cnt = maxEv;
   end
   V_T1_T2 = V(T1,T2);
   V_T2 = V(T2);
   V_T1 = V(T1);

//      VT1
   VT1 = V_T1;
   if((VT1_cnt>0) || ( maxEv_flg==0 ))   begin
      if( (VT1 < -420) && (VT1_retc!=-1))
      begin
        outfile=$fopen(errFileName,"a");
        $strobe("cmmh5         VT1     leaving   OCA (  .. -420.000 V ) at %7.4r  %M", $abstime );
        $fwrite(outfile,"cmmh5         VT1     leaving   OCA (  .. -420.000 V ) at %7.4r  %M\n", $abstime );
        VT1_retc=-1;
        VT1_cnt=VT1_cnt-1;
        $fclose(outfile);
      end
      if((VT1 >= -420) &&  (VT1 <= 420) && (VT1_retc!=0))
      begin
        outfile=$fopen(errFileName,"a");
        $strobe("cmmh5         VT1     entering SOCA ( -420.000 V .. 420.000 V ) at %7.4r  %M", $abstime );
        $fwrite(outfile,"cmmh5         VT1     entering SOCA ( -420.000 V .. 420.000 V ) at %7.4r  %M\n", $abstime );
        VT1_retc=0;
        VT1_cnt=VT1_cnt-1;
        $fclose(outfile);
      end
      if((VT1 > 420) &&  (VT1_retc!=1))
      begin
        outfile=$fopen(errFileName,"a");
        $strobe("cmmh5         VT1     leaving   OCA ( 420.000 V ..  ) at %7.4r  %M", $abstime );
        $fwrite(outfile,"cmmh5         VT1     leaving   OCA ( 420.000 V ..  ) at %7.4r  %M\n", $abstime );
        VT1_retc=1;
        VT1_cnt=VT1_cnt-1;
        $fclose(outfile);
      end
   end
   else
   begin
      if(VT1_cnt==0)
      begin
        outfile=$fopen(errFileName,"a");
        $strobe("cmmh5         VT1     error limit ( %d ) reached at %7.4r  %M", maxEv, $abstime );
        $fwrite(outfile,"cmmh5         VT1     error limit ( %d ) reached at %7.4r  %M\n", maxEv, $abstime );
        VT1_cnt=VT1_cnt-1;
        $fclose(outfile);
      end
   end

//      VT2
   VT2 = V_T2;
   if((VT2_cnt>0) || ( maxEv_flg==0 ))   begin
      if( (VT2 < -420) && (VT2_retc!=-1))
      begin
        outfile=$fopen(errFileName,"a");
        $strobe("cmmh5         VT2     leaving   OCA (  .. -420.000 V ) at %7.4r  %M", $abstime );
        $fwrite(outfile,"cmmh5         VT2     leaving   OCA (  .. -420.000 V ) at %7.4r  %M\n", $abstime );
        VT2_retc=-1;
        VT2_cnt=VT2_cnt-1;
        $fclose(outfile);
      end
      if((VT2 >= -420) &&  (VT2 <= 420) && (VT2_retc!=0))
      begin
        outfile=$fopen(errFileName,"a");
        $strobe("cmmh5         VT2     entering SOCA ( -420.000 V .. 420.000 V ) at %7.4r  %M", $abstime );
        $fwrite(outfile,"cmmh5         VT2     entering SOCA ( -420.000 V .. 420.000 V ) at %7.4r  %M\n", $abstime );
        VT2_retc=0;
        VT2_cnt=VT2_cnt-1;
        $fclose(outfile);
      end
      if((VT2 > 420) &&  (VT2_retc!=1))
      begin
        outfile=$fopen(errFileName,"a");
        $strobe("cmmh5         VT2     leaving   OCA ( 420.000 V ..  ) at %7.4r  %M", $abstime );
        $fwrite(outfile,"cmmh5         VT2     leaving   OCA ( 420.000 V ..  ) at %7.4r  %M\n", $abstime );
        VT2_retc=1;
        VT2_cnt=VT2_cnt-1;
        $fclose(outfile);
      end
   end
   else
   begin
      if(VT2_cnt==0)
      begin
        outfile=$fopen(errFileName,"a");
        $strobe("cmmh5         VT2     error limit ( %d ) reached at %7.4r  %M", maxEv, $abstime );
        $fwrite(outfile,"cmmh5         VT2     error limit ( %d ) reached at %7.4r  %M\n", maxEv, $abstime );
        VT2_cnt=VT2_cnt-1;
        $fclose(outfile);
      end
   end

//      VT1T2
   VT1T2 = V_T1_T2;
   if((VT1T2_cnt>0) || ( maxEv_flg==0 ))   begin
      if( (VT1T2 < -5.5) && (VT1T2_retc!=-1))
      begin
        outfile=$fopen(errFileName,"a");
        $strobe("cmmh5         VT1T2   leaving   OCA (  .. -5.500 V ) at %7.4r  %M", $abstime );
        $fwrite(outfile,"cmmh5         VT1T2   leaving   OCA (  .. -5.500 V ) at %7.4r  %M\n", $abstime );
        VT1T2_retc=-1;
        VT1T2_cnt=VT1T2_cnt-1;
        $fclose(outfile);
      end
      if((VT1T2 >= -5.5) &&  (VT1T2 <= 5.5) && (VT1T2_retc!=0))
      begin
        outfile=$fopen(errFileName,"a");
        $strobe("cmmh5         VT1T2   entering SOCA ( -5.500 V .. 5.500 V ) at %7.4r  %M", $abstime );
        $fwrite(outfile,"cmmh5         VT1T2   entering SOCA ( -5.500 V .. 5.500 V ) at %7.4r  %M\n", $abstime );
        VT1T2_retc=0;
        VT1T2_cnt=VT1T2_cnt-1;
        $fclose(outfile);
      end
      if((VT1T2 > 5.5) &&  (VT1T2_retc!=1))
      begin
        outfile=$fopen(errFileName,"a");
        $strobe("cmmh5         VT1T2   leaving   OCA ( 5.500 V ..  ) at %7.4r  %M", $abstime );
        $fwrite(outfile,"cmmh5         VT1T2   leaving   OCA ( 5.500 V ..  ) at %7.4r  %M\n", $abstime );
        VT1T2_retc=1;
        VT1T2_cnt=VT1T2_cnt-1;
        $fclose(outfile);
      end
   end
   else
   begin
      if(VT1T2_cnt==0)
      begin
        outfile=$fopen(errFileName,"a");
        $strobe("cmmh5         VT1T2   error limit ( %d ) reached at %7.4r  %M", maxEv, $abstime );
        $fwrite(outfile,"cmmh5         VT1T2   error limit ( %d ) reached at %7.4r  %M\n", maxEv, $abstime );
        VT1T2_cnt=VT1T2_cnt-1;
        $fclose(outfile);
      end
   end

end // analog
endmodule // cmmh5

// Verilog-A OC Watch for device cmmh3t Parameters  VT1 VT2 VT1T2
module cmmh3t_ahdl(T1,T2);
parameter tstep_occ=100n;
parameter errFileName="./occ.err";
parameter maxEv = 25;
parameter maxEv_flg = 0;
inout T1,T2;
electrical T1,T2;

integer outfile;
real V_T1_T2;
real V_T2;
real V_T1;
real VT1;
integer VT1_retc;
integer VT1_cnt;
real VT2;
integer VT2_retc;
integer VT2_cnt;
real VT1T2;
integer VT1T2_retc;
integer VT1T2_cnt;

analog begin
   $bound_step( tstep_occ );
   @(initial_step) begin
      VT1_retc=0;
      VT1_cnt = maxEv;
      VT2_retc=0;
      VT2_cnt = maxEv;
      VT1T2_retc=0;
      VT1T2_cnt = maxEv;
   end
   V_T1_T2 = V(T1,T2);
   V_T2 = V(T2);
   V_T1 = V(T1);

//      VT1
   VT1 = V_T1;
   if((VT1_cnt>0) || ( maxEv_flg==0 ))   begin
      if( (VT1 < -420) && (VT1_retc!=-1))
      begin
        outfile=$fopen(errFileName,"a");
        $strobe("cmmh3t        VT1     leaving   OCA (  .. -420.000 V ) at %7.4r  %M", $abstime );
        $fwrite(outfile,"cmmh3t        VT1     leaving   OCA (  .. -420.000 V ) at %7.4r  %M\n", $abstime );
        VT1_retc=-1;
        VT1_cnt=VT1_cnt-1;
        $fclose(outfile);
      end
      if((VT1 >= -420) &&  (VT1 <= 420) && (VT1_retc!=0))
      begin
        outfile=$fopen(errFileName,"a");
        $strobe("cmmh3t        VT1     entering SOCA ( -420.000 V .. 420.000 V ) at %7.4r  %M", $abstime );
        $fwrite(outfile,"cmmh3t        VT1     entering SOCA ( -420.000 V .. 420.000 V ) at %7.4r  %M\n", $abstime );
        VT1_retc=0;
        VT1_cnt=VT1_cnt-1;
        $fclose(outfile);
      end
      if((VT1 > 420) &&  (VT1_retc!=1))
      begin
        outfile=$fopen(errFileName,"a");
        $strobe("cmmh3t        VT1     leaving   OCA ( 420.000 V ..  ) at %7.4r  %M", $abstime );
        $fwrite(outfile,"cmmh3t        VT1     leaving   OCA ( 420.000 V ..  ) at %7.4r  %M\n", $abstime );
        VT1_retc=1;
        VT1_cnt=VT1_cnt-1;
        $fclose(outfile);
      end
   end
   else
   begin
      if(VT1_cnt==0)
      begin
        outfile=$fopen(errFileName,"a");
        $strobe("cmmh3t        VT1     error limit ( %d ) reached at %7.4r  %M", maxEv, $abstime );
        $fwrite(outfile,"cmmh3t        VT1     error limit ( %d ) reached at %7.4r  %M\n", maxEv, $abstime );
        VT1_cnt=VT1_cnt-1;
        $fclose(outfile);
      end
   end

//      VT2
   VT2 = V_T2;
   if((VT2_cnt>0) || ( maxEv_flg==0 ))   begin
      if( (VT2 < -420) && (VT2_retc!=-1))
      begin
        outfile=$fopen(errFileName,"a");
        $strobe("cmmh3t        VT2     leaving   OCA (  .. -420.000 V ) at %7.4r  %M", $abstime );
        $fwrite(outfile,"cmmh3t        VT2     leaving   OCA (  .. -420.000 V ) at %7.4r  %M\n", $abstime );
        VT2_retc=-1;
        VT2_cnt=VT2_cnt-1;
        $fclose(outfile);
      end
      if((VT2 >= -420) &&  (VT2 <= 420) && (VT2_retc!=0))
      begin
        outfile=$fopen(errFileName,"a");
        $strobe("cmmh3t        VT2     entering SOCA ( -420.000 V .. 420.000 V ) at %7.4r  %M", $abstime );
        $fwrite(outfile,"cmmh3t        VT2     entering SOCA ( -420.000 V .. 420.000 V ) at %7.4r  %M\n", $abstime );
        VT2_retc=0;
        VT2_cnt=VT2_cnt-1;
        $fclose(outfile);
      end
      if((VT2 > 420) &&  (VT2_retc!=1))
      begin
        outfile=$fopen(errFileName,"a");
        $strobe("cmmh3t        VT2     leaving   OCA ( 420.000 V ..  ) at %7.4r  %M", $abstime );
        $fwrite(outfile,"cmmh3t        VT2     leaving   OCA ( 420.000 V ..  ) at %7.4r  %M\n", $abstime );
        VT2_retc=1;
        VT2_cnt=VT2_cnt-1;
        $fclose(outfile);
      end
   end
   else
   begin
      if(VT2_cnt==0)
      begin
        outfile=$fopen(errFileName,"a");
        $strobe("cmmh3t        VT2     error limit ( %d ) reached at %7.4r  %M", maxEv, $abstime );
        $fwrite(outfile,"cmmh3t        VT2     error limit ( %d ) reached at %7.4r  %M\n", maxEv, $abstime );
        VT2_cnt=VT2_cnt-1;
        $fclose(outfile);
      end
   end

//      VT1T2
   VT1T2 = V_T1_T2;
   if((VT1T2_cnt>0) || ( maxEv_flg==0 ))   begin
      if( (VT1T2 < -5.5) && (VT1T2_retc!=-1))
      begin
        outfile=$fopen(errFileName,"a");
        $strobe("cmmh3t        VT1T2   leaving   OCA (  .. -5.500 V ) at %7.4r  %M", $abstime );
        $fwrite(outfile,"cmmh3t        VT1T2   leaving   OCA (  .. -5.500 V ) at %7.4r  %M\n", $abstime );
        VT1T2_retc=-1;
        VT1T2_cnt=VT1T2_cnt-1;
        $fclose(outfile);
      end
      if((VT1T2 >= -5.5) &&  (VT1T2 <= 5.5) && (VT1T2_retc!=0))
      begin
        outfile=$fopen(errFileName,"a");
        $strobe("cmmh3t        VT1T2   entering SOCA ( -5.500 V .. 5.500 V ) at %7.4r  %M", $abstime );
        $fwrite(outfile,"cmmh3t        VT1T2   entering SOCA ( -5.500 V .. 5.500 V ) at %7.4r  %M\n", $abstime );
        VT1T2_retc=0;
        VT1T2_cnt=VT1T2_cnt-1;
        $fclose(outfile);
      end
      if((VT1T2 > 5.5) &&  (VT1T2_retc!=1))
      begin
        outfile=$fopen(errFileName,"a");
        $strobe("cmmh3t        VT1T2   leaving   OCA ( 5.500 V ..  ) at %7.4r  %M", $abstime );
        $fwrite(outfile,"cmmh3t        VT1T2   leaving   OCA ( 5.500 V ..  ) at %7.4r  %M\n", $abstime );
        VT1T2_retc=1;
        VT1T2_cnt=VT1T2_cnt-1;
        $fclose(outfile);
      end
   end
   else
   begin
      if(VT1T2_cnt==0)
      begin
        outfile=$fopen(errFileName,"a");
        $strobe("cmmh3t        VT1T2   error limit ( %d ) reached at %7.4r  %M", maxEv, $abstime );
        $fwrite(outfile,"cmmh3t        VT1T2   error limit ( %d ) reached at %7.4r  %M\n", maxEv, $abstime );
        VT1T2_cnt=VT1T2_cnt-1;
        $fclose(outfile);
      end
   end

end // analog
endmodule // cmmh3t

// Verilog-A OC Watch for device cmmh4t Parameters  VT1 VT2 VT1T2
module cmmh4t_ahdl(T1,T2);
parameter tstep_occ=100n;
parameter errFileName="./occ.err";
parameter maxEv = 25;
parameter maxEv_flg = 0;
inout T1,T2;
electrical T1,T2;

integer outfile;
real V_T1_T2;
real V_T2;
real V_T1;
real VT1;
integer VT1_retc;
integer VT1_cnt;
real VT2;
integer VT2_retc;
integer VT2_cnt;
real VT1T2;
integer VT1T2_retc;
integer VT1T2_cnt;

analog begin
   $bound_step( tstep_occ );
   @(initial_step) begin
      VT1_retc=0;
      VT1_cnt = maxEv;
      VT2_retc=0;
      VT2_cnt = maxEv;
      VT1T2_retc=0;
      VT1T2_cnt = maxEv;
   end
   V_T1_T2 = V(T1,T2);
   V_T2 = V(T2);
   V_T1 = V(T1);

//      VT1
   VT1 = V_T1;
   if((VT1_cnt>0) || ( maxEv_flg==0 ))   begin
      if( (VT1 < -420) && (VT1_retc!=-1))
      begin
        outfile=$fopen(errFileName,"a");
        $strobe("cmmh4t        VT1     leaving   OCA (  .. -420.000 V ) at %7.4r  %M", $abstime );
        $fwrite(outfile,"cmmh4t        VT1     leaving   OCA (  .. -420.000 V ) at %7.4r  %M\n", $abstime );
        VT1_retc=-1;
        VT1_cnt=VT1_cnt-1;
        $fclose(outfile);
      end
      if((VT1 >= -420) &&  (VT1 <= 420) && (VT1_retc!=0))
      begin
        outfile=$fopen(errFileName,"a");
        $strobe("cmmh4t        VT1     entering SOCA ( -420.000 V .. 420.000 V ) at %7.4r  %M", $abstime );
        $fwrite(outfile,"cmmh4t        VT1     entering SOCA ( -420.000 V .. 420.000 V ) at %7.4r  %M\n", $abstime );
        VT1_retc=0;
        VT1_cnt=VT1_cnt-1;
        $fclose(outfile);
      end
      if((VT1 > 420) &&  (VT1_retc!=1))
      begin
        outfile=$fopen(errFileName,"a");
        $strobe("cmmh4t        VT1     leaving   OCA ( 420.000 V ..  ) at %7.4r  %M", $abstime );
        $fwrite(outfile,"cmmh4t        VT1     leaving   OCA ( 420.000 V ..  ) at %7.4r  %M\n", $abstime );
        VT1_retc=1;
        VT1_cnt=VT1_cnt-1;
        $fclose(outfile);
      end
   end
   else
   begin
      if(VT1_cnt==0)
      begin
        outfile=$fopen(errFileName,"a");
        $strobe("cmmh4t        VT1     error limit ( %d ) reached at %7.4r  %M", maxEv, $abstime );
        $fwrite(outfile,"cmmh4t        VT1     error limit ( %d ) reached at %7.4r  %M\n", maxEv, $abstime );
        VT1_cnt=VT1_cnt-1;
        $fclose(outfile);
      end
   end

//      VT2
   VT2 = V_T2;
   if((VT2_cnt>0) || ( maxEv_flg==0 ))   begin
      if( (VT2 < -420) && (VT2_retc!=-1))
      begin
        outfile=$fopen(errFileName,"a");
        $strobe("cmmh4t        VT2     leaving   OCA (  .. -420.000 V ) at %7.4r  %M", $abstime );
        $fwrite(outfile,"cmmh4t        VT2     leaving   OCA (  .. -420.000 V ) at %7.4r  %M\n", $abstime );
        VT2_retc=-1;
        VT2_cnt=VT2_cnt-1;
        $fclose(outfile);
      end
      if((VT2 >= -420) &&  (VT2 <= 420) && (VT2_retc!=0))
      begin
        outfile=$fopen(errFileName,"a");
        $strobe("cmmh4t        VT2     entering SOCA ( -420.000 V .. 420.000 V ) at %7.4r  %M", $abstime );
        $fwrite(outfile,"cmmh4t        VT2     entering SOCA ( -420.000 V .. 420.000 V ) at %7.4r  %M\n", $abstime );
        VT2_retc=0;
        VT2_cnt=VT2_cnt-1;
        $fclose(outfile);
      end
      if((VT2 > 420) &&  (VT2_retc!=1))
      begin
        outfile=$fopen(errFileName,"a");
        $strobe("cmmh4t        VT2     leaving   OCA ( 420.000 V ..  ) at %7.4r  %M", $abstime );
        $fwrite(outfile,"cmmh4t        VT2     leaving   OCA ( 420.000 V ..  ) at %7.4r  %M\n", $abstime );
        VT2_retc=1;
        VT2_cnt=VT2_cnt-1;
        $fclose(outfile);
      end
   end
   else
   begin
      if(VT2_cnt==0)
      begin
        outfile=$fopen(errFileName,"a");
        $strobe("cmmh4t        VT2     error limit ( %d ) reached at %7.4r  %M", maxEv, $abstime );
        $fwrite(outfile,"cmmh4t        VT2     error limit ( %d ) reached at %7.4r  %M\n", maxEv, $abstime );
        VT2_cnt=VT2_cnt-1;
        $fclose(outfile);
      end
   end

//      VT1T2
   VT1T2 = V_T1_T2;
   if((VT1T2_cnt>0) || ( maxEv_flg==0 ))   begin
      if( (VT1T2 < -5.5) && (VT1T2_retc!=-1))
      begin
        outfile=$fopen(errFileName,"a");
        $strobe("cmmh4t        VT1T2   leaving   OCA (  .. -5.500 V ) at %7.4r  %M", $abstime );
        $fwrite(outfile,"cmmh4t        VT1T2   leaving   OCA (  .. -5.500 V ) at %7.4r  %M\n", $abstime );
        VT1T2_retc=-1;
        VT1T2_cnt=VT1T2_cnt-1;
        $fclose(outfile);
      end
      if((VT1T2 >= -5.5) &&  (VT1T2 <= 5.5) && (VT1T2_retc!=0))
      begin
        outfile=$fopen(errFileName,"a");
        $strobe("cmmh4t        VT1T2   entering SOCA ( -5.500 V .. 5.500 V ) at %7.4r  %M", $abstime );
        $fwrite(outfile,"cmmh4t        VT1T2   entering SOCA ( -5.500 V .. 5.500 V ) at %7.4r  %M\n", $abstime );
        VT1T2_retc=0;
        VT1T2_cnt=VT1T2_cnt-1;
        $fclose(outfile);
      end
      if((VT1T2 > 5.5) &&  (VT1T2_retc!=1))
      begin
        outfile=$fopen(errFileName,"a");
        $strobe("cmmh4t        VT1T2   leaving   OCA ( 5.500 V ..  ) at %7.4r  %M", $abstime );
        $fwrite(outfile,"cmmh4t        VT1T2   leaving   OCA ( 5.500 V ..  ) at %7.4r  %M\n", $abstime );
        VT1T2_retc=1;
        VT1T2_cnt=VT1T2_cnt-1;
        $fclose(outfile);
      end
   end
   else
   begin
      if(VT1T2_cnt==0)
      begin
        outfile=$fopen(errFileName,"a");
        $strobe("cmmh4t        VT1T2   error limit ( %d ) reached at %7.4r  %M", maxEv, $abstime );
        $fwrite(outfile,"cmmh4t        VT1T2   error limit ( %d ) reached at %7.4r  %M\n", maxEv, $abstime );
        VT1T2_cnt=VT1T2_cnt-1;
        $fclose(outfile);
      end
   end

end // analog
endmodule // cmmh4t

// Verilog-A OC Watch for device cmmh5t Parameters  VT1 VT2 VT1T2
module cmmh5t_ahdl(T1,T2);
parameter tstep_occ=100n;
parameter errFileName="./occ.err";
parameter maxEv = 25;
parameter maxEv_flg = 0;
inout T1,T2;
electrical T1,T2;

integer outfile;
real V_T1_T2;
real V_T2;
real V_T1;
real VT1;
integer VT1_retc;
integer VT1_cnt;
real VT2;
integer VT2_retc;
integer VT2_cnt;
real VT1T2;
integer VT1T2_retc;
integer VT1T2_cnt;

analog begin
   $bound_step( tstep_occ );
   @(initial_step) begin
      VT1_retc=0;
      VT1_cnt = maxEv;
      VT2_retc=0;
      VT2_cnt = maxEv;
      VT1T2_retc=0;
      VT1T2_cnt = maxEv;
   end
   V_T1_T2 = V(T1,T2);
   V_T2 = V(T2);
   V_T1 = V(T1);

//      VT1
   VT1 = V_T1;
   if((VT1_cnt>0) || ( maxEv_flg==0 ))   begin
      if( (VT1 < -420) && (VT1_retc!=-1))
      begin
        outfile=$fopen(errFileName,"a");
        $strobe("cmmh5t        VT1     leaving   OCA (  .. -420.000 V ) at %7.4r  %M", $abstime );
        $fwrite(outfile,"cmmh5t        VT1     leaving   OCA (  .. -420.000 V ) at %7.4r  %M\n", $abstime );
        VT1_retc=-1;
        VT1_cnt=VT1_cnt-1;
        $fclose(outfile);
      end
      if((VT1 >= -420) &&  (VT1 <= 420) && (VT1_retc!=0))
      begin
        outfile=$fopen(errFileName,"a");
        $strobe("cmmh5t        VT1     entering SOCA ( -420.000 V .. 420.000 V ) at %7.4r  %M", $abstime );
        $fwrite(outfile,"cmmh5t        VT1     entering SOCA ( -420.000 V .. 420.000 V ) at %7.4r  %M\n", $abstime );
        VT1_retc=0;
        VT1_cnt=VT1_cnt-1;
        $fclose(outfile);
      end
      if((VT1 > 420) &&  (VT1_retc!=1))
      begin
        outfile=$fopen(errFileName,"a");
        $strobe("cmmh5t        VT1     leaving   OCA ( 420.000 V ..  ) at %7.4r  %M", $abstime );
        $fwrite(outfile,"cmmh5t        VT1     leaving   OCA ( 420.000 V ..  ) at %7.4r  %M\n", $abstime );
        VT1_retc=1;
        VT1_cnt=VT1_cnt-1;
        $fclose(outfile);
      end
   end
   else
   begin
      if(VT1_cnt==0)
      begin
        outfile=$fopen(errFileName,"a");
        $strobe("cmmh5t        VT1     error limit ( %d ) reached at %7.4r  %M", maxEv, $abstime );
        $fwrite(outfile,"cmmh5t        VT1     error limit ( %d ) reached at %7.4r  %M\n", maxEv, $abstime );
        VT1_cnt=VT1_cnt-1;
        $fclose(outfile);
      end
   end

//      VT2
   VT2 = V_T2;
   if((VT2_cnt>0) || ( maxEv_flg==0 ))   begin
      if( (VT2 < -420) && (VT2_retc!=-1))
      begin
        outfile=$fopen(errFileName,"a");
        $strobe("cmmh5t        VT2     leaving   OCA (  .. -420.000 V ) at %7.4r  %M", $abstime );
        $fwrite(outfile,"cmmh5t        VT2     leaving   OCA (  .. -420.000 V ) at %7.4r  %M\n", $abstime );
        VT2_retc=-1;
        VT2_cnt=VT2_cnt-1;
        $fclose(outfile);
      end
      if((VT2 >= -420) &&  (VT2 <= 420) && (VT2_retc!=0))
      begin
        outfile=$fopen(errFileName,"a");
        $strobe("cmmh5t        VT2     entering SOCA ( -420.000 V .. 420.000 V ) at %7.4r  %M", $abstime );
        $fwrite(outfile,"cmmh5t        VT2     entering SOCA ( -420.000 V .. 420.000 V ) at %7.4r  %M\n", $abstime );
        VT2_retc=0;
        VT2_cnt=VT2_cnt-1;
        $fclose(outfile);
      end
      if((VT2 > 420) &&  (VT2_retc!=1))
      begin
        outfile=$fopen(errFileName,"a");
        $strobe("cmmh5t        VT2     leaving   OCA ( 420.000 V ..  ) at %7.4r  %M", $abstime );
        $fwrite(outfile,"cmmh5t        VT2     leaving   OCA ( 420.000 V ..  ) at %7.4r  %M\n", $abstime );
        VT2_retc=1;
        VT2_cnt=VT2_cnt-1;
        $fclose(outfile);
      end
   end
   else
   begin
      if(VT2_cnt==0)
      begin
        outfile=$fopen(errFileName,"a");
        $strobe("cmmh5t        VT2     error limit ( %d ) reached at %7.4r  %M", maxEv, $abstime );
        $fwrite(outfile,"cmmh5t        VT2     error limit ( %d ) reached at %7.4r  %M\n", maxEv, $abstime );
        VT2_cnt=VT2_cnt-1;
        $fclose(outfile);
      end
   end

//      VT1T2
   VT1T2 = V_T1_T2;
   if((VT1T2_cnt>0) || ( maxEv_flg==0 ))   begin
      if( (VT1T2 < -5.5) && (VT1T2_retc!=-1))
      begin
        outfile=$fopen(errFileName,"a");
        $strobe("cmmh5t        VT1T2   leaving   OCA (  .. -5.500 V ) at %7.4r  %M", $abstime );
        $fwrite(outfile,"cmmh5t        VT1T2   leaving   OCA (  .. -5.500 V ) at %7.4r  %M\n", $abstime );
        VT1T2_retc=-1;
        VT1T2_cnt=VT1T2_cnt-1;
        $fclose(outfile);
      end
      if((VT1T2 >= -5.5) &&  (VT1T2 <= 5.5) && (VT1T2_retc!=0))
      begin
        outfile=$fopen(errFileName,"a");
        $strobe("cmmh5t        VT1T2   entering SOCA ( -5.500 V .. 5.500 V ) at %7.4r  %M", $abstime );
        $fwrite(outfile,"cmmh5t        VT1T2   entering SOCA ( -5.500 V .. 5.500 V ) at %7.4r  %M\n", $abstime );
        VT1T2_retc=0;
        VT1T2_cnt=VT1T2_cnt-1;
        $fclose(outfile);
      end
      if((VT1T2 > 5.5) &&  (VT1T2_retc!=1))
      begin
        outfile=$fopen(errFileName,"a");
        $strobe("cmmh5t        VT1T2   leaving   OCA ( 5.500 V ..  ) at %7.4r  %M", $abstime );
        $fwrite(outfile,"cmmh5t        VT1T2   leaving   OCA ( 5.500 V ..  ) at %7.4r  %M\n", $abstime );
        VT1T2_retc=1;
        VT1T2_cnt=VT1T2_cnt-1;
        $fclose(outfile);
      end
   end
   else
   begin
      if(VT1T2_cnt==0)
      begin
        outfile=$fopen(errFileName,"a");
        $strobe("cmmh5t        VT1T2   error limit ( %d ) reached at %7.4r  %M", maxEv, $abstime );
        $fwrite(outfile,"cmmh5t        VT1T2   error limit ( %d ) reached at %7.4r  %M\n", maxEv, $abstime );
        VT1T2_cnt=VT1T2_cnt-1;
        $fclose(outfile);
      end
   end

end // analog
endmodule // cmmh5t

// Verilog-A OC Watch for device cmmh6t Parameters  VT1 VT2 VT1T2
module cmmh6t_ahdl(T1,T2);
parameter tstep_occ=100n;
parameter errFileName="./occ.err";
parameter maxEv = 25;
parameter maxEv_flg = 0;
inout T1,T2;
electrical T1,T2;

integer outfile;
real V_T1_T2;
real V_T2;
real V_T1;
real VT1;
integer VT1_retc;
integer VT1_cnt;
real VT2;
integer VT2_retc;
integer VT2_cnt;
real VT1T2;
integer VT1T2_retc;
integer VT1T2_cnt;

analog begin
   $bound_step( tstep_occ );
   @(initial_step) begin
      VT1_retc=0;
      VT1_cnt = maxEv;
      VT2_retc=0;
      VT2_cnt = maxEv;
      VT1T2_retc=0;
      VT1T2_cnt = maxEv;
   end
   V_T1_T2 = V(T1,T2);
   V_T2 = V(T2);
   V_T1 = V(T1);

//      VT1
   VT1 = V_T1;
   if((VT1_cnt>0) || ( maxEv_flg==0 ))   begin
      if( (VT1 < -420) && (VT1_retc!=-1))
      begin
        outfile=$fopen(errFileName,"a");
        $strobe("cmmh6t        VT1     leaving   OCA (  .. -420.000 V ) at %7.4r  %M", $abstime );
        $fwrite(outfile,"cmmh6t        VT1     leaving   OCA (  .. -420.000 V ) at %7.4r  %M\n", $abstime );
        VT1_retc=-1;
        VT1_cnt=VT1_cnt-1;
        $fclose(outfile);
      end
      if((VT1 >= -420) &&  (VT1 <= 420) && (VT1_retc!=0))
      begin
        outfile=$fopen(errFileName,"a");
        $strobe("cmmh6t        VT1     entering SOCA ( -420.000 V .. 420.000 V ) at %7.4r  %M", $abstime );
        $fwrite(outfile,"cmmh6t        VT1     entering SOCA ( -420.000 V .. 420.000 V ) at %7.4r  %M\n", $abstime );
        VT1_retc=0;
        VT1_cnt=VT1_cnt-1;
        $fclose(outfile);
      end
      if((VT1 > 420) &&  (VT1_retc!=1))
      begin
        outfile=$fopen(errFileName,"a");
        $strobe("cmmh6t        VT1     leaving   OCA ( 420.000 V ..  ) at %7.4r  %M", $abstime );
        $fwrite(outfile,"cmmh6t        VT1     leaving   OCA ( 420.000 V ..  ) at %7.4r  %M\n", $abstime );
        VT1_retc=1;
        VT1_cnt=VT1_cnt-1;
        $fclose(outfile);
      end
   end
   else
   begin
      if(VT1_cnt==0)
      begin
        outfile=$fopen(errFileName,"a");
        $strobe("cmmh6t        VT1     error limit ( %d ) reached at %7.4r  %M", maxEv, $abstime );
        $fwrite(outfile,"cmmh6t        VT1     error limit ( %d ) reached at %7.4r  %M\n", maxEv, $abstime );
        VT1_cnt=VT1_cnt-1;
        $fclose(outfile);
      end
   end

//      VT2
   VT2 = V_T2;
   if((VT2_cnt>0) || ( maxEv_flg==0 ))   begin
      if( (VT2 < -420) && (VT2_retc!=-1))
      begin
        outfile=$fopen(errFileName,"a");
        $strobe("cmmh6t        VT2     leaving   OCA (  .. -420.000 V ) at %7.4r  %M", $abstime );
        $fwrite(outfile,"cmmh6t        VT2     leaving   OCA (  .. -420.000 V ) at %7.4r  %M\n", $abstime );
        VT2_retc=-1;
        VT2_cnt=VT2_cnt-1;
        $fclose(outfile);
      end
      if((VT2 >= -420) &&  (VT2 <= 420) && (VT2_retc!=0))
      begin
        outfile=$fopen(errFileName,"a");
        $strobe("cmmh6t        VT2     entering SOCA ( -420.000 V .. 420.000 V ) at %7.4r  %M", $abstime );
        $fwrite(outfile,"cmmh6t        VT2     entering SOCA ( -420.000 V .. 420.000 V ) at %7.4r  %M\n", $abstime );
        VT2_retc=0;
        VT2_cnt=VT2_cnt-1;
        $fclose(outfile);
      end
      if((VT2 > 420) &&  (VT2_retc!=1))
      begin
        outfile=$fopen(errFileName,"a");
        $strobe("cmmh6t        VT2     leaving   OCA ( 420.000 V ..  ) at %7.4r  %M", $abstime );
        $fwrite(outfile,"cmmh6t        VT2     leaving   OCA ( 420.000 V ..  ) at %7.4r  %M\n", $abstime );
        VT2_retc=1;
        VT2_cnt=VT2_cnt-1;
        $fclose(outfile);
      end
   end
   else
   begin
      if(VT2_cnt==0)
      begin
        outfile=$fopen(errFileName,"a");
        $strobe("cmmh6t        VT2     error limit ( %d ) reached at %7.4r  %M", maxEv, $abstime );
        $fwrite(outfile,"cmmh6t        VT2     error limit ( %d ) reached at %7.4r  %M\n", maxEv, $abstime );
        VT2_cnt=VT2_cnt-1;
        $fclose(outfile);
      end
   end

//      VT1T2
   VT1T2 = V_T1_T2;
   if((VT1T2_cnt>0) || ( maxEv_flg==0 ))   begin
      if( (VT1T2 < -5.5) && (VT1T2_retc!=-1))
      begin
        outfile=$fopen(errFileName,"a");
        $strobe("cmmh6t        VT1T2   leaving   OCA (  .. -5.500 V ) at %7.4r  %M", $abstime );
        $fwrite(outfile,"cmmh6t        VT1T2   leaving   OCA (  .. -5.500 V ) at %7.4r  %M\n", $abstime );
        VT1T2_retc=-1;
        VT1T2_cnt=VT1T2_cnt-1;
        $fclose(outfile);
      end
      if((VT1T2 >= -5.5) &&  (VT1T2 <= 5.5) && (VT1T2_retc!=0))
      begin
        outfile=$fopen(errFileName,"a");
        $strobe("cmmh6t        VT1T2   entering SOCA ( -5.500 V .. 5.500 V ) at %7.4r  %M", $abstime );
        $fwrite(outfile,"cmmh6t        VT1T2   entering SOCA ( -5.500 V .. 5.500 V ) at %7.4r  %M\n", $abstime );
        VT1T2_retc=0;
        VT1T2_cnt=VT1T2_cnt-1;
        $fclose(outfile);
      end
      if((VT1T2 > 5.5) &&  (VT1T2_retc!=1))
      begin
        outfile=$fopen(errFileName,"a");
        $strobe("cmmh6t        VT1T2   leaving   OCA ( 5.500 V ..  ) at %7.4r  %M", $abstime );
        $fwrite(outfile,"cmmh6t        VT1T2   leaving   OCA ( 5.500 V ..  ) at %7.4r  %M\n", $abstime );
        VT1T2_retc=1;
        VT1T2_cnt=VT1T2_cnt-1;
        $fclose(outfile);
      end
   end
   else
   begin
      if(VT1T2_cnt==0)
      begin
        outfile=$fopen(errFileName,"a");
        $strobe("cmmh6t        VT1T2   error limit ( %d ) reached at %7.4r  %M", maxEv, $abstime );
        $fwrite(outfile,"cmmh6t        VT1T2   error limit ( %d ) reached at %7.4r  %M\n", maxEv, $abstime );
        VT1T2_cnt=VT1T2_cnt-1;
        $fclose(outfile);
      end
   end

end // analog
endmodule // cmmh6t

// Verilog-A OC Watch for device cdmmh4 Parameters  VT1 VT2 VT1T2
module cdmmh4_ahdl(T1,T2);
parameter tstep_occ=100n;
parameter errFileName="./occ.err";
parameter maxEv = 25;
parameter maxEv_flg = 0;
inout T1,T2;
electrical T1,T2;

integer outfile;
real V_T1_T2;
real V_T2;
real V_T1;
real VT1;
integer VT1_retc;
integer VT1_cnt;
real VT2;
integer VT2_retc;
integer VT2_cnt;
real VT1T2;
integer VT1T2_retc;
integer VT1T2_cnt;

analog begin
   $bound_step( tstep_occ );
   @(initial_step) begin
      VT1_retc=0;
      VT1_cnt = maxEv;
      VT2_retc=0;
      VT2_cnt = maxEv;
      VT1T2_retc=0;
      VT1T2_cnt = maxEv;
   end
   V_T1_T2 = V(T1,T2);
   V_T2 = V(T2);
   V_T1 = V(T1);

//      VT1
   VT1 = V_T1;
   if((VT1_cnt>0) || ( maxEv_flg==0 ))   begin
      if( (VT1 < -420) && (VT1_retc!=-1))
      begin
        outfile=$fopen(errFileName,"a");
        $strobe("cdmmh4        VT1     leaving   OCA (  .. -420.000 V ) at %7.4r  %M", $abstime );
        $fwrite(outfile,"cdmmh4        VT1     leaving   OCA (  .. -420.000 V ) at %7.4r  %M\n", $abstime );
        VT1_retc=-1;
        VT1_cnt=VT1_cnt-1;
        $fclose(outfile);
      end
      if((VT1 >= -420) &&  (VT1 <= 420) && (VT1_retc!=0))
      begin
        outfile=$fopen(errFileName,"a");
        $strobe("cdmmh4        VT1     entering SOCA ( -420.000 V .. 420.000 V ) at %7.4r  %M", $abstime );
        $fwrite(outfile,"cdmmh4        VT1     entering SOCA ( -420.000 V .. 420.000 V ) at %7.4r  %M\n", $abstime );
        VT1_retc=0;
        VT1_cnt=VT1_cnt-1;
        $fclose(outfile);
      end
      if((VT1 > 420) &&  (VT1_retc!=1))
      begin
        outfile=$fopen(errFileName,"a");
        $strobe("cdmmh4        VT1     leaving   OCA ( 420.000 V ..  ) at %7.4r  %M", $abstime );
        $fwrite(outfile,"cdmmh4        VT1     leaving   OCA ( 420.000 V ..  ) at %7.4r  %M\n", $abstime );
        VT1_retc=1;
        VT1_cnt=VT1_cnt-1;
        $fclose(outfile);
      end
   end
   else
   begin
      if(VT1_cnt==0)
      begin
        outfile=$fopen(errFileName,"a");
        $strobe("cdmmh4        VT1     error limit ( %d ) reached at %7.4r  %M", maxEv, $abstime );
        $fwrite(outfile,"cdmmh4        VT1     error limit ( %d ) reached at %7.4r  %M\n", maxEv, $abstime );
        VT1_cnt=VT1_cnt-1;
        $fclose(outfile);
      end
   end

//      VT2
   VT2 = V_T2;
   if((VT2_cnt>0) || ( maxEv_flg==0 ))   begin
      if( (VT2 < -420) && (VT2_retc!=-1))
      begin
        outfile=$fopen(errFileName,"a");
        $strobe("cdmmh4        VT2     leaving   OCA (  .. -420.000 V ) at %7.4r  %M", $abstime );
        $fwrite(outfile,"cdmmh4        VT2     leaving   OCA (  .. -420.000 V ) at %7.4r  %M\n", $abstime );
        VT2_retc=-1;
        VT2_cnt=VT2_cnt-1;
        $fclose(outfile);
      end
      if((VT2 >= -420) &&  (VT2 <= 420) && (VT2_retc!=0))
      begin
        outfile=$fopen(errFileName,"a");
        $strobe("cdmmh4        VT2     entering SOCA ( -420.000 V .. 420.000 V ) at %7.4r  %M", $abstime );
        $fwrite(outfile,"cdmmh4        VT2     entering SOCA ( -420.000 V .. 420.000 V ) at %7.4r  %M\n", $abstime );
        VT2_retc=0;
        VT2_cnt=VT2_cnt-1;
        $fclose(outfile);
      end
      if((VT2 > 420) &&  (VT2_retc!=1))
      begin
        outfile=$fopen(errFileName,"a");
        $strobe("cdmmh4        VT2     leaving   OCA ( 420.000 V ..  ) at %7.4r  %M", $abstime );
        $fwrite(outfile,"cdmmh4        VT2     leaving   OCA ( 420.000 V ..  ) at %7.4r  %M\n", $abstime );
        VT2_retc=1;
        VT2_cnt=VT2_cnt-1;
        $fclose(outfile);
      end
   end
   else
   begin
      if(VT2_cnt==0)
      begin
        outfile=$fopen(errFileName,"a");
        $strobe("cdmmh4        VT2     error limit ( %d ) reached at %7.4r  %M", maxEv, $abstime );
        $fwrite(outfile,"cdmmh4        VT2     error limit ( %d ) reached at %7.4r  %M\n", maxEv, $abstime );
        VT2_cnt=VT2_cnt-1;
        $fclose(outfile);
      end
   end

//      VT1T2
   VT1T2 = V_T1_T2;
   if((VT1T2_cnt>0) || ( maxEv_flg==0 ))   begin
      if( (VT1T2 < -5.5) && (VT1T2_retc!=-1))
      begin
        outfile=$fopen(errFileName,"a");
        $strobe("cdmmh4        VT1T2   leaving   OCA (  .. -5.500 V ) at %7.4r  %M", $abstime );
        $fwrite(outfile,"cdmmh4        VT1T2   leaving   OCA (  .. -5.500 V ) at %7.4r  %M\n", $abstime );
        VT1T2_retc=-1;
        VT1T2_cnt=VT1T2_cnt-1;
        $fclose(outfile);
      end
      if((VT1T2 >= -5.5) &&  (VT1T2 <= 5.5) && (VT1T2_retc!=0))
      begin
        outfile=$fopen(errFileName,"a");
        $strobe("cdmmh4        VT1T2   entering SOCA ( -5.500 V .. 5.500 V ) at %7.4r  %M", $abstime );
        $fwrite(outfile,"cdmmh4        VT1T2   entering SOCA ( -5.500 V .. 5.500 V ) at %7.4r  %M\n", $abstime );
        VT1T2_retc=0;
        VT1T2_cnt=VT1T2_cnt-1;
        $fclose(outfile);
      end
      if((VT1T2 > 5.5) &&  (VT1T2_retc!=1))
      begin
        outfile=$fopen(errFileName,"a");
        $strobe("cdmmh4        VT1T2   leaving   OCA ( 5.500 V ..  ) at %7.4r  %M", $abstime );
        $fwrite(outfile,"cdmmh4        VT1T2   leaving   OCA ( 5.500 V ..  ) at %7.4r  %M\n", $abstime );
        VT1T2_retc=1;
        VT1T2_cnt=VT1T2_cnt-1;
        $fclose(outfile);
      end
   end
   else
   begin
      if(VT1T2_cnt==0)
      begin
        outfile=$fopen(errFileName,"a");
        $strobe("cdmmh4        VT1T2   error limit ( %d ) reached at %7.4r  %M", maxEv, $abstime );
        $fwrite(outfile,"cdmmh4        VT1T2   error limit ( %d ) reached at %7.4r  %M\n", maxEv, $abstime );
        VT1T2_cnt=VT1T2_cnt-1;
        $fclose(outfile);
      end
   end

end // analog
endmodule // cdmmh4

// Verilog-A OC Watch for device cdmmh5 Parameters  VT1 VT2 VT1T2
module cdmmh5_ahdl(T1,T2);
parameter tstep_occ=100n;
parameter errFileName="./occ.err";
parameter maxEv = 25;
parameter maxEv_flg = 0;
inout T1,T2;
electrical T1,T2;

integer outfile;
real V_T1_T2;
real V_T2;
real V_T1;
real VT1;
integer VT1_retc;
integer VT1_cnt;
real VT2;
integer VT2_retc;
integer VT2_cnt;
real VT1T2;
integer VT1T2_retc;
integer VT1T2_cnt;

analog begin
   $bound_step( tstep_occ );
   @(initial_step) begin
      VT1_retc=0;
      VT1_cnt = maxEv;
      VT2_retc=0;
      VT2_cnt = maxEv;
      VT1T2_retc=0;
      VT1T2_cnt = maxEv;
   end
   V_T1_T2 = V(T1,T2);
   V_T2 = V(T2);
   V_T1 = V(T1);

//      VT1
   VT1 = V_T1;
   if((VT1_cnt>0) || ( maxEv_flg==0 ))   begin
      if( (VT1 < -420) && (VT1_retc!=-1))
      begin
        outfile=$fopen(errFileName,"a");
        $strobe("cdmmh5        VT1     leaving   OCA (  .. -420.000 V ) at %7.4r  %M", $abstime );
        $fwrite(outfile,"cdmmh5        VT1     leaving   OCA (  .. -420.000 V ) at %7.4r  %M\n", $abstime );
        VT1_retc=-1;
        VT1_cnt=VT1_cnt-1;
        $fclose(outfile);
      end
      if((VT1 >= -420) &&  (VT1 <= 420) && (VT1_retc!=0))
      begin
        outfile=$fopen(errFileName,"a");
        $strobe("cdmmh5        VT1     entering SOCA ( -420.000 V .. 420.000 V ) at %7.4r  %M", $abstime );
        $fwrite(outfile,"cdmmh5        VT1     entering SOCA ( -420.000 V .. 420.000 V ) at %7.4r  %M\n", $abstime );
        VT1_retc=0;
        VT1_cnt=VT1_cnt-1;
        $fclose(outfile);
      end
      if((VT1 > 420) &&  (VT1_retc!=1))
      begin
        outfile=$fopen(errFileName,"a");
        $strobe("cdmmh5        VT1     leaving   OCA ( 420.000 V ..  ) at %7.4r  %M", $abstime );
        $fwrite(outfile,"cdmmh5        VT1     leaving   OCA ( 420.000 V ..  ) at %7.4r  %M\n", $abstime );
        VT1_retc=1;
        VT1_cnt=VT1_cnt-1;
        $fclose(outfile);
      end
   end
   else
   begin
      if(VT1_cnt==0)
      begin
        outfile=$fopen(errFileName,"a");
        $strobe("cdmmh5        VT1     error limit ( %d ) reached at %7.4r  %M", maxEv, $abstime );
        $fwrite(outfile,"cdmmh5        VT1     error limit ( %d ) reached at %7.4r  %M\n", maxEv, $abstime );
        VT1_cnt=VT1_cnt-1;
        $fclose(outfile);
      end
   end

//      VT2
   VT2 = V_T2;
   if((VT2_cnt>0) || ( maxEv_flg==0 ))   begin
      if( (VT2 < -420) && (VT2_retc!=-1))
      begin
        outfile=$fopen(errFileName,"a");
        $strobe("cdmmh5        VT2     leaving   OCA (  .. -420.000 V ) at %7.4r  %M", $abstime );
        $fwrite(outfile,"cdmmh5        VT2     leaving   OCA (  .. -420.000 V ) at %7.4r  %M\n", $abstime );
        VT2_retc=-1;
        VT2_cnt=VT2_cnt-1;
        $fclose(outfile);
      end
      if((VT2 >= -420) &&  (VT2 <= 420) && (VT2_retc!=0))
      begin
        outfile=$fopen(errFileName,"a");
        $strobe("cdmmh5        VT2     entering SOCA ( -420.000 V .. 420.000 V ) at %7.4r  %M", $abstime );
        $fwrite(outfile,"cdmmh5        VT2     entering SOCA ( -420.000 V .. 420.000 V ) at %7.4r  %M\n", $abstime );
        VT2_retc=0;
        VT2_cnt=VT2_cnt-1;
        $fclose(outfile);
      end
      if((VT2 > 420) &&  (VT2_retc!=1))
      begin
        outfile=$fopen(errFileName,"a");
        $strobe("cdmmh5        VT2     leaving   OCA ( 420.000 V ..  ) at %7.4r  %M", $abstime );
        $fwrite(outfile,"cdmmh5        VT2     leaving   OCA ( 420.000 V ..  ) at %7.4r  %M\n", $abstime );
        VT2_retc=1;
        VT2_cnt=VT2_cnt-1;
        $fclose(outfile);
      end
   end
   else
   begin
      if(VT2_cnt==0)
      begin
        outfile=$fopen(errFileName,"a");
        $strobe("cdmmh5        VT2     error limit ( %d ) reached at %7.4r  %M", maxEv, $abstime );
        $fwrite(outfile,"cdmmh5        VT2     error limit ( %d ) reached at %7.4r  %M\n", maxEv, $abstime );
        VT2_cnt=VT2_cnt-1;
        $fclose(outfile);
      end
   end

//      VT1T2
   VT1T2 = V_T1_T2;
   if((VT1T2_cnt>0) || ( maxEv_flg==0 ))   begin
      if( (VT1T2 < -5.5) && (VT1T2_retc!=-1))
      begin
        outfile=$fopen(errFileName,"a");
        $strobe("cdmmh5        VT1T2   leaving   OCA (  .. -5.500 V ) at %7.4r  %M", $abstime );
        $fwrite(outfile,"cdmmh5        VT1T2   leaving   OCA (  .. -5.500 V ) at %7.4r  %M\n", $abstime );
        VT1T2_retc=-1;
        VT1T2_cnt=VT1T2_cnt-1;
        $fclose(outfile);
      end
      if((VT1T2 >= -5.5) &&  (VT1T2 <= 5.5) && (VT1T2_retc!=0))
      begin
        outfile=$fopen(errFileName,"a");
        $strobe("cdmmh5        VT1T2   entering SOCA ( -5.500 V .. 5.500 V ) at %7.4r  %M", $abstime );
        $fwrite(outfile,"cdmmh5        VT1T2   entering SOCA ( -5.500 V .. 5.500 V ) at %7.4r  %M\n", $abstime );
        VT1T2_retc=0;
        VT1T2_cnt=VT1T2_cnt-1;
        $fclose(outfile);
      end
      if((VT1T2 > 5.5) &&  (VT1T2_retc!=1))
      begin
        outfile=$fopen(errFileName,"a");
        $strobe("cdmmh5        VT1T2   leaving   OCA ( 5.500 V ..  ) at %7.4r  %M", $abstime );
        $fwrite(outfile,"cdmmh5        VT1T2   leaving   OCA ( 5.500 V ..  ) at %7.4r  %M\n", $abstime );
        VT1T2_retc=1;
        VT1T2_cnt=VT1T2_cnt-1;
        $fclose(outfile);
      end
   end
   else
   begin
      if(VT1T2_cnt==0)
      begin
        outfile=$fopen(errFileName,"a");
        $strobe("cdmmh5        VT1T2   error limit ( %d ) reached at %7.4r  %M", maxEv, $abstime );
        $fwrite(outfile,"cdmmh5        VT1T2   error limit ( %d ) reached at %7.4r  %M\n", maxEv, $abstime );
        VT1T2_cnt=VT1T2_cnt-1;
        $fclose(outfile);
      end
   end

end // analog
endmodule // cdmmh5

// Verilog-A OC Watch for device cdmmh4t Parameters  VT1 VT2 VT1T2
module cdmmh4t_ahdl(T1,T2);
parameter tstep_occ=100n;
parameter errFileName="./occ.err";
parameter maxEv = 25;
parameter maxEv_flg = 0;
inout T1,T2;
electrical T1,T2;

integer outfile;
real V_T1_T2;
real V_T2;
real V_T1;
real VT1;
integer VT1_retc;
integer VT1_cnt;
real VT2;
integer VT2_retc;
integer VT2_cnt;
real VT1T2;
integer VT1T2_retc;
integer VT1T2_cnt;

analog begin
   $bound_step( tstep_occ );
   @(initial_step) begin
      VT1_retc=0;
      VT1_cnt = maxEv;
      VT2_retc=0;
      VT2_cnt = maxEv;
      VT1T2_retc=0;
      VT1T2_cnt = maxEv;
   end
   V_T1_T2 = V(T1,T2);
   V_T2 = V(T2);
   V_T1 = V(T1);

//      VT1
   VT1 = V_T1;
   if((VT1_cnt>0) || ( maxEv_flg==0 ))   begin
      if( (VT1 < -420) && (VT1_retc!=-1))
      begin
        outfile=$fopen(errFileName,"a");
        $strobe("cdmmh4t       VT1     leaving   OCA (  .. -420.000 V ) at %7.4r  %M", $abstime );
        $fwrite(outfile,"cdmmh4t       VT1     leaving   OCA (  .. -420.000 V ) at %7.4r  %M\n", $abstime );
        VT1_retc=-1;
        VT1_cnt=VT1_cnt-1;
        $fclose(outfile);
      end
      if((VT1 >= -420) &&  (VT1 <= 420) && (VT1_retc!=0))
      begin
        outfile=$fopen(errFileName,"a");
        $strobe("cdmmh4t       VT1     entering SOCA ( -420.000 V .. 420.000 V ) at %7.4r  %M", $abstime );
        $fwrite(outfile,"cdmmh4t       VT1     entering SOCA ( -420.000 V .. 420.000 V ) at %7.4r  %M\n", $abstime );
        VT1_retc=0;
        VT1_cnt=VT1_cnt-1;
        $fclose(outfile);
      end
      if((VT1 > 420) &&  (VT1_retc!=1))
      begin
        outfile=$fopen(errFileName,"a");
        $strobe("cdmmh4t       VT1     leaving   OCA ( 420.000 V ..  ) at %7.4r  %M", $abstime );
        $fwrite(outfile,"cdmmh4t       VT1     leaving   OCA ( 420.000 V ..  ) at %7.4r  %M\n", $abstime );
        VT1_retc=1;
        VT1_cnt=VT1_cnt-1;
        $fclose(outfile);
      end
   end
   else
   begin
      if(VT1_cnt==0)
      begin
        outfile=$fopen(errFileName,"a");
        $strobe("cdmmh4t       VT1     error limit ( %d ) reached at %7.4r  %M", maxEv, $abstime );
        $fwrite(outfile,"cdmmh4t       VT1     error limit ( %d ) reached at %7.4r  %M\n", maxEv, $abstime );
        VT1_cnt=VT1_cnt-1;
        $fclose(outfile);
      end
   end

//      VT2
   VT2 = V_T2;
   if((VT2_cnt>0) || ( maxEv_flg==0 ))   begin
      if( (VT2 < -420) && (VT2_retc!=-1))
      begin
        outfile=$fopen(errFileName,"a");
        $strobe("cdmmh4t       VT2     leaving   OCA (  .. -420.000 V ) at %7.4r  %M", $abstime );
        $fwrite(outfile,"cdmmh4t       VT2     leaving   OCA (  .. -420.000 V ) at %7.4r  %M\n", $abstime );
        VT2_retc=-1;
        VT2_cnt=VT2_cnt-1;
        $fclose(outfile);
      end
      if((VT2 >= -420) &&  (VT2 <= 420) && (VT2_retc!=0))
      begin
        outfile=$fopen(errFileName,"a");
        $strobe("cdmmh4t       VT2     entering SOCA ( -420.000 V .. 420.000 V ) at %7.4r  %M", $abstime );
        $fwrite(outfile,"cdmmh4t       VT2     entering SOCA ( -420.000 V .. 420.000 V ) at %7.4r  %M\n", $abstime );
        VT2_retc=0;
        VT2_cnt=VT2_cnt-1;
        $fclose(outfile);
      end
      if((VT2 > 420) &&  (VT2_retc!=1))
      begin
        outfile=$fopen(errFileName,"a");
        $strobe("cdmmh4t       VT2     leaving   OCA ( 420.000 V ..  ) at %7.4r  %M", $abstime );
        $fwrite(outfile,"cdmmh4t       VT2     leaving   OCA ( 420.000 V ..  ) at %7.4r  %M\n", $abstime );
        VT2_retc=1;
        VT2_cnt=VT2_cnt-1;
        $fclose(outfile);
      end
   end
   else
   begin
      if(VT2_cnt==0)
      begin
        outfile=$fopen(errFileName,"a");
        $strobe("cdmmh4t       VT2     error limit ( %d ) reached at %7.4r  %M", maxEv, $abstime );
        $fwrite(outfile,"cdmmh4t       VT2     error limit ( %d ) reached at %7.4r  %M\n", maxEv, $abstime );
        VT2_cnt=VT2_cnt-1;
        $fclose(outfile);
      end
   end

//      VT1T2
   VT1T2 = V_T1_T2;
   if((VT1T2_cnt>0) || ( maxEv_flg==0 ))   begin
      if( (VT1T2 < -5.5) && (VT1T2_retc!=-1))
      begin
        outfile=$fopen(errFileName,"a");
        $strobe("cdmmh4t       VT1T2   leaving   OCA (  .. -5.500 V ) at %7.4r  %M", $abstime );
        $fwrite(outfile,"cdmmh4t       VT1T2   leaving   OCA (  .. -5.500 V ) at %7.4r  %M\n", $abstime );
        VT1T2_retc=-1;
        VT1T2_cnt=VT1T2_cnt-1;
        $fclose(outfile);
      end
      if((VT1T2 >= -5.5) &&  (VT1T2 <= 5.5) && (VT1T2_retc!=0))
      begin
        outfile=$fopen(errFileName,"a");
        $strobe("cdmmh4t       VT1T2   entering SOCA ( -5.500 V .. 5.500 V ) at %7.4r  %M", $abstime );
        $fwrite(outfile,"cdmmh4t       VT1T2   entering SOCA ( -5.500 V .. 5.500 V ) at %7.4r  %M\n", $abstime );
        VT1T2_retc=0;
        VT1T2_cnt=VT1T2_cnt-1;
        $fclose(outfile);
      end
      if((VT1T2 > 5.5) &&  (VT1T2_retc!=1))
      begin
        outfile=$fopen(errFileName,"a");
        $strobe("cdmmh4t       VT1T2   leaving   OCA ( 5.500 V ..  ) at %7.4r  %M", $abstime );
        $fwrite(outfile,"cdmmh4t       VT1T2   leaving   OCA ( 5.500 V ..  ) at %7.4r  %M\n", $abstime );
        VT1T2_retc=1;
        VT1T2_cnt=VT1T2_cnt-1;
        $fclose(outfile);
      end
   end
   else
   begin
      if(VT1T2_cnt==0)
      begin
        outfile=$fopen(errFileName,"a");
        $strobe("cdmmh4t       VT1T2   error limit ( %d ) reached at %7.4r  %M", maxEv, $abstime );
        $fwrite(outfile,"cdmmh4t       VT1T2   error limit ( %d ) reached at %7.4r  %M\n", maxEv, $abstime );
        VT1T2_cnt=VT1T2_cnt-1;
        $fclose(outfile);
      end
   end

end // analog
endmodule // cdmmh4t

// Verilog-A OC Watch for device cdmmh5t Parameters  VT1 VT2 VT1T2
module cdmmh5t_ahdl(T1,T2);
parameter tstep_occ=100n;
parameter errFileName="./occ.err";
parameter maxEv = 25;
parameter maxEv_flg = 0;
inout T1,T2;
electrical T1,T2;

integer outfile;
real V_T1_T2;
real V_T2;
real V_T1;
real VT1;
integer VT1_retc;
integer VT1_cnt;
real VT2;
integer VT2_retc;
integer VT2_cnt;
real VT1T2;
integer VT1T2_retc;
integer VT1T2_cnt;

analog begin
   $bound_step( tstep_occ );
   @(initial_step) begin
      VT1_retc=0;
      VT1_cnt = maxEv;
      VT2_retc=0;
      VT2_cnt = maxEv;
      VT1T2_retc=0;
      VT1T2_cnt = maxEv;
   end
   V_T1_T2 = V(T1,T2);
   V_T2 = V(T2);
   V_T1 = V(T1);

//      VT1
   VT1 = V_T1;
   if((VT1_cnt>0) || ( maxEv_flg==0 ))   begin
      if( (VT1 < -420) && (VT1_retc!=-1))
      begin
        outfile=$fopen(errFileName,"a");
        $strobe("cdmmh5t       VT1     leaving   OCA (  .. -420.000 V ) at %7.4r  %M", $abstime );
        $fwrite(outfile,"cdmmh5t       VT1     leaving   OCA (  .. -420.000 V ) at %7.4r  %M\n", $abstime );
        VT1_retc=-1;
        VT1_cnt=VT1_cnt-1;
        $fclose(outfile);
      end
      if((VT1 >= -420) &&  (VT1 <= 420) && (VT1_retc!=0))
      begin
        outfile=$fopen(errFileName,"a");
        $strobe("cdmmh5t       VT1     entering SOCA ( -420.000 V .. 420.000 V ) at %7.4r  %M", $abstime );
        $fwrite(outfile,"cdmmh5t       VT1     entering SOCA ( -420.000 V .. 420.000 V ) at %7.4r  %M\n", $abstime );
        VT1_retc=0;
        VT1_cnt=VT1_cnt-1;
        $fclose(outfile);
      end
      if((VT1 > 420) &&  (VT1_retc!=1))
      begin
        outfile=$fopen(errFileName,"a");
        $strobe("cdmmh5t       VT1     leaving   OCA ( 420.000 V ..  ) at %7.4r  %M", $abstime );
        $fwrite(outfile,"cdmmh5t       VT1     leaving   OCA ( 420.000 V ..  ) at %7.4r  %M\n", $abstime );
        VT1_retc=1;
        VT1_cnt=VT1_cnt-1;
        $fclose(outfile);
      end
   end
   else
   begin
      if(VT1_cnt==0)
      begin
        outfile=$fopen(errFileName,"a");
        $strobe("cdmmh5t       VT1     error limit ( %d ) reached at %7.4r  %M", maxEv, $abstime );
        $fwrite(outfile,"cdmmh5t       VT1     error limit ( %d ) reached at %7.4r  %M\n", maxEv, $abstime );
        VT1_cnt=VT1_cnt-1;
        $fclose(outfile);
      end
   end

//      VT2
   VT2 = V_T2;
   if((VT2_cnt>0) || ( maxEv_flg==0 ))   begin
      if( (VT2 < -420) && (VT2_retc!=-1))
      begin
        outfile=$fopen(errFileName,"a");
        $strobe("cdmmh5t       VT2     leaving   OCA (  .. -420.000 V ) at %7.4r  %M", $abstime );
        $fwrite(outfile,"cdmmh5t       VT2     leaving   OCA (  .. -420.000 V ) at %7.4r  %M\n", $abstime );
        VT2_retc=-1;
        VT2_cnt=VT2_cnt-1;
        $fclose(outfile);
      end
      if((VT2 >= -420) &&  (VT2 <= 420) && (VT2_retc!=0))
      begin
        outfile=$fopen(errFileName,"a");
        $strobe("cdmmh5t       VT2     entering SOCA ( -420.000 V .. 420.000 V ) at %7.4r  %M", $abstime );
        $fwrite(outfile,"cdmmh5t       VT2     entering SOCA ( -420.000 V .. 420.000 V ) at %7.4r  %M\n", $abstime );
        VT2_retc=0;
        VT2_cnt=VT2_cnt-1;
        $fclose(outfile);
      end
      if((VT2 > 420) &&  (VT2_retc!=1))
      begin
        outfile=$fopen(errFileName,"a");
        $strobe("cdmmh5t       VT2     leaving   OCA ( 420.000 V ..  ) at %7.4r  %M", $abstime );
        $fwrite(outfile,"cdmmh5t       VT2     leaving   OCA ( 420.000 V ..  ) at %7.4r  %M\n", $abstime );
        VT2_retc=1;
        VT2_cnt=VT2_cnt-1;
        $fclose(outfile);
      end
   end
   else
   begin
      if(VT2_cnt==0)
      begin
        outfile=$fopen(errFileName,"a");
        $strobe("cdmmh5t       VT2     error limit ( %d ) reached at %7.4r  %M", maxEv, $abstime );
        $fwrite(outfile,"cdmmh5t       VT2     error limit ( %d ) reached at %7.4r  %M\n", maxEv, $abstime );
        VT2_cnt=VT2_cnt-1;
        $fclose(outfile);
      end
   end

//      VT1T2
   VT1T2 = V_T1_T2;
   if((VT1T2_cnt>0) || ( maxEv_flg==0 ))   begin
      if( (VT1T2 < -5.5) && (VT1T2_retc!=-1))
      begin
        outfile=$fopen(errFileName,"a");
        $strobe("cdmmh5t       VT1T2   leaving   OCA (  .. -5.500 V ) at %7.4r  %M", $abstime );
        $fwrite(outfile,"cdmmh5t       VT1T2   leaving   OCA (  .. -5.500 V ) at %7.4r  %M\n", $abstime );
        VT1T2_retc=-1;
        VT1T2_cnt=VT1T2_cnt-1;
        $fclose(outfile);
      end
      if((VT1T2 >= -5.5) &&  (VT1T2 <= 5.5) && (VT1T2_retc!=0))
      begin
        outfile=$fopen(errFileName,"a");
        $strobe("cdmmh5t       VT1T2   entering SOCA ( -5.500 V .. 5.500 V ) at %7.4r  %M", $abstime );
        $fwrite(outfile,"cdmmh5t       VT1T2   entering SOCA ( -5.500 V .. 5.500 V ) at %7.4r  %M\n", $abstime );
        VT1T2_retc=0;
        VT1T2_cnt=VT1T2_cnt-1;
        $fclose(outfile);
      end
      if((VT1T2 > 5.5) &&  (VT1T2_retc!=1))
      begin
        outfile=$fopen(errFileName,"a");
        $strobe("cdmmh5t       VT1T2   leaving   OCA ( 5.500 V ..  ) at %7.4r  %M", $abstime );
        $fwrite(outfile,"cdmmh5t       VT1T2   leaving   OCA ( 5.500 V ..  ) at %7.4r  %M\n", $abstime );
        VT1T2_retc=1;
        VT1T2_cnt=VT1T2_cnt-1;
        $fclose(outfile);
      end
   end
   else
   begin
      if(VT1T2_cnt==0)
      begin
        outfile=$fopen(errFileName,"a");
        $strobe("cdmmh5t       VT1T2   error limit ( %d ) reached at %7.4r  %M", maxEv, $abstime );
        $fwrite(outfile,"cdmmh5t       VT1T2   error limit ( %d ) reached at %7.4r  %M\n", maxEv, $abstime );
        VT1T2_cnt=VT1T2_cnt-1;
        $fclose(outfile);
      end
   end

end // analog
endmodule // cdmmh5t

// Verilog-A OC Watch for device ctmmh5 Parameters  VT1 VT2 VT1T2
module ctmmh5_ahdl(T1,T2);
parameter tstep_occ=100n;
parameter errFileName="./occ.err";
parameter maxEv = 25;
parameter maxEv_flg = 0;
inout T1,T2;
electrical T1,T2;

integer outfile;
real V_T1_T2;
real V_T2;
real V_T1;
real VT1;
integer VT1_retc;
integer VT1_cnt;
real VT2;
integer VT2_retc;
integer VT2_cnt;
real VT1T2;
integer VT1T2_retc;
integer VT1T2_cnt;

analog begin
   $bound_step( tstep_occ );
   @(initial_step) begin
      VT1_retc=0;
      VT1_cnt = maxEv;
      VT2_retc=0;
      VT2_cnt = maxEv;
      VT1T2_retc=0;
      VT1T2_cnt = maxEv;
   end
   V_T1_T2 = V(T1,T2);
   V_T2 = V(T2);
   V_T1 = V(T1);

//      VT1
   VT1 = V_T1;
   if((VT1_cnt>0) || ( maxEv_flg==0 ))   begin
      if( (VT1 < -420) && (VT1_retc!=-1))
      begin
        outfile=$fopen(errFileName,"a");
        $strobe("ctmmh5        VT1     leaving   OCA (  .. -420.000 V ) at %7.4r  %M", $abstime );
        $fwrite(outfile,"ctmmh5        VT1     leaving   OCA (  .. -420.000 V ) at %7.4r  %M\n", $abstime );
        VT1_retc=-1;
        VT1_cnt=VT1_cnt-1;
        $fclose(outfile);
      end
      if((VT1 >= -420) &&  (VT1 <= 420) && (VT1_retc!=0))
      begin
        outfile=$fopen(errFileName,"a");
        $strobe("ctmmh5        VT1     entering SOCA ( -420.000 V .. 420.000 V ) at %7.4r  %M", $abstime );
        $fwrite(outfile,"ctmmh5        VT1     entering SOCA ( -420.000 V .. 420.000 V ) at %7.4r  %M\n", $abstime );
        VT1_retc=0;
        VT1_cnt=VT1_cnt-1;
        $fclose(outfile);
      end
      if((VT1 > 420) &&  (VT1_retc!=1))
      begin
        outfile=$fopen(errFileName,"a");
        $strobe("ctmmh5        VT1     leaving   OCA ( 420.000 V ..  ) at %7.4r  %M", $abstime );
        $fwrite(outfile,"ctmmh5        VT1     leaving   OCA ( 420.000 V ..  ) at %7.4r  %M\n", $abstime );
        VT1_retc=1;
        VT1_cnt=VT1_cnt-1;
        $fclose(outfile);
      end
   end
   else
   begin
      if(VT1_cnt==0)
      begin
        outfile=$fopen(errFileName,"a");
        $strobe("ctmmh5        VT1     error limit ( %d ) reached at %7.4r  %M", maxEv, $abstime );
        $fwrite(outfile,"ctmmh5        VT1     error limit ( %d ) reached at %7.4r  %M\n", maxEv, $abstime );
        VT1_cnt=VT1_cnt-1;
        $fclose(outfile);
      end
   end

//      VT2
   VT2 = V_T2;
   if((VT2_cnt>0) || ( maxEv_flg==0 ))   begin
      if( (VT2 < -420) && (VT2_retc!=-1))
      begin
        outfile=$fopen(errFileName,"a");
        $strobe("ctmmh5        VT2     leaving   OCA (  .. -420.000 V ) at %7.4r  %M", $abstime );
        $fwrite(outfile,"ctmmh5        VT2     leaving   OCA (  .. -420.000 V ) at %7.4r  %M\n", $abstime );
        VT2_retc=-1;
        VT2_cnt=VT2_cnt-1;
        $fclose(outfile);
      end
      if((VT2 >= -420) &&  (VT2 <= 420) && (VT2_retc!=0))
      begin
        outfile=$fopen(errFileName,"a");
        $strobe("ctmmh5        VT2     entering SOCA ( -420.000 V .. 420.000 V ) at %7.4r  %M", $abstime );
        $fwrite(outfile,"ctmmh5        VT2     entering SOCA ( -420.000 V .. 420.000 V ) at %7.4r  %M\n", $abstime );
        VT2_retc=0;
        VT2_cnt=VT2_cnt-1;
        $fclose(outfile);
      end
      if((VT2 > 420) &&  (VT2_retc!=1))
      begin
        outfile=$fopen(errFileName,"a");
        $strobe("ctmmh5        VT2     leaving   OCA ( 420.000 V ..  ) at %7.4r  %M", $abstime );
        $fwrite(outfile,"ctmmh5        VT2     leaving   OCA ( 420.000 V ..  ) at %7.4r  %M\n", $abstime );
        VT2_retc=1;
        VT2_cnt=VT2_cnt-1;
        $fclose(outfile);
      end
   end
   else
   begin
      if(VT2_cnt==0)
      begin
        outfile=$fopen(errFileName,"a");
        $strobe("ctmmh5        VT2     error limit ( %d ) reached at %7.4r  %M", maxEv, $abstime );
        $fwrite(outfile,"ctmmh5        VT2     error limit ( %d ) reached at %7.4r  %M\n", maxEv, $abstime );
        VT2_cnt=VT2_cnt-1;
        $fclose(outfile);
      end
   end

//      VT1T2
   VT1T2 = V_T1_T2;
   if((VT1T2_cnt>0) || ( maxEv_flg==0 ))   begin
      if( (VT1T2 < -5.5) && (VT1T2_retc!=-1))
      begin
        outfile=$fopen(errFileName,"a");
        $strobe("ctmmh5        VT1T2   leaving   OCA (  .. -5.500 V ) at %7.4r  %M", $abstime );
        $fwrite(outfile,"ctmmh5        VT1T2   leaving   OCA (  .. -5.500 V ) at %7.4r  %M\n", $abstime );
        VT1T2_retc=-1;
        VT1T2_cnt=VT1T2_cnt-1;
        $fclose(outfile);
      end
      if((VT1T2 >= -5.5) &&  (VT1T2 <= 5.5) && (VT1T2_retc!=0))
      begin
        outfile=$fopen(errFileName,"a");
        $strobe("ctmmh5        VT1T2   entering SOCA ( -5.500 V .. 5.500 V ) at %7.4r  %M", $abstime );
        $fwrite(outfile,"ctmmh5        VT1T2   entering SOCA ( -5.500 V .. 5.500 V ) at %7.4r  %M\n", $abstime );
        VT1T2_retc=0;
        VT1T2_cnt=VT1T2_cnt-1;
        $fclose(outfile);
      end
      if((VT1T2 > 5.5) &&  (VT1T2_retc!=1))
      begin
        outfile=$fopen(errFileName,"a");
        $strobe("ctmmh5        VT1T2   leaving   OCA ( 5.500 V ..  ) at %7.4r  %M", $abstime );
        $fwrite(outfile,"ctmmh5        VT1T2   leaving   OCA ( 5.500 V ..  ) at %7.4r  %M\n", $abstime );
        VT1T2_retc=1;
        VT1T2_cnt=VT1T2_cnt-1;
        $fclose(outfile);
      end
   end
   else
   begin
      if(VT1T2_cnt==0)
      begin
        outfile=$fopen(errFileName,"a");
        $strobe("ctmmh5        VT1T2   error limit ( %d ) reached at %7.4r  %M", maxEv, $abstime );
        $fwrite(outfile,"ctmmh5        VT1T2   error limit ( %d ) reached at %7.4r  %M\n", maxEv, $abstime );
        VT1T2_cnt=VT1T2_cnt-1;
        $fclose(outfile);
      end
   end

end // analog
endmodule // ctmmh5

// Verilog-A OC Watch for device ctmmh5t Parameters  VT1 VT2 VT1T2
module ctmmh5t_ahdl(T1,T2);
parameter tstep_occ=100n;
parameter errFileName="./occ.err";
parameter maxEv = 25;
parameter maxEv_flg = 0;
inout T1,T2;
electrical T1,T2;

integer outfile;
real V_T1_T2;
real V_T2;
real V_T1;
real VT1;
integer VT1_retc;
integer VT1_cnt;
real VT2;
integer VT2_retc;
integer VT2_cnt;
real VT1T2;
integer VT1T2_retc;
integer VT1T2_cnt;

analog begin
   $bound_step( tstep_occ );
   @(initial_step) begin
      VT1_retc=0;
      VT1_cnt = maxEv;
      VT2_retc=0;
      VT2_cnt = maxEv;
      VT1T2_retc=0;
      VT1T2_cnt = maxEv;
   end
   V_T1_T2 = V(T1,T2);
   V_T2 = V(T2);
   V_T1 = V(T1);

//      VT1
   VT1 = V_T1;
   if((VT1_cnt>0) || ( maxEv_flg==0 ))   begin
      if( (VT1 < -420) && (VT1_retc!=-1))
      begin
        outfile=$fopen(errFileName,"a");
        $strobe("ctmmh5t       VT1     leaving   OCA (  .. -420.000 V ) at %7.4r  %M", $abstime );
        $fwrite(outfile,"ctmmh5t       VT1     leaving   OCA (  .. -420.000 V ) at %7.4r  %M\n", $abstime );
        VT1_retc=-1;
        VT1_cnt=VT1_cnt-1;
        $fclose(outfile);
      end
      if((VT1 >= -420) &&  (VT1 <= 420) && (VT1_retc!=0))
      begin
        outfile=$fopen(errFileName,"a");
        $strobe("ctmmh5t       VT1     entering SOCA ( -420.000 V .. 420.000 V ) at %7.4r  %M", $abstime );
        $fwrite(outfile,"ctmmh5t       VT1     entering SOCA ( -420.000 V .. 420.000 V ) at %7.4r  %M\n", $abstime );
        VT1_retc=0;
        VT1_cnt=VT1_cnt-1;
        $fclose(outfile);
      end
      if((VT1 > 420) &&  (VT1_retc!=1))
      begin
        outfile=$fopen(errFileName,"a");
        $strobe("ctmmh5t       VT1     leaving   OCA ( 420.000 V ..  ) at %7.4r  %M", $abstime );
        $fwrite(outfile,"ctmmh5t       VT1     leaving   OCA ( 420.000 V ..  ) at %7.4r  %M\n", $abstime );
        VT1_retc=1;
        VT1_cnt=VT1_cnt-1;
        $fclose(outfile);
      end
   end
   else
   begin
      if(VT1_cnt==0)
      begin
        outfile=$fopen(errFileName,"a");
        $strobe("ctmmh5t       VT1     error limit ( %d ) reached at %7.4r  %M", maxEv, $abstime );
        $fwrite(outfile,"ctmmh5t       VT1     error limit ( %d ) reached at %7.4r  %M\n", maxEv, $abstime );
        VT1_cnt=VT1_cnt-1;
        $fclose(outfile);
      end
   end

//      VT2
   VT2 = V_T2;
   if((VT2_cnt>0) || ( maxEv_flg==0 ))   begin
      if( (VT2 < -420) && (VT2_retc!=-1))
      begin
        outfile=$fopen(errFileName,"a");
        $strobe("ctmmh5t       VT2     leaving   OCA (  .. -420.000 V ) at %7.4r  %M", $abstime );
        $fwrite(outfile,"ctmmh5t       VT2     leaving   OCA (  .. -420.000 V ) at %7.4r  %M\n", $abstime );
        VT2_retc=-1;
        VT2_cnt=VT2_cnt-1;
        $fclose(outfile);
      end
      if((VT2 >= -420) &&  (VT2 <= 420) && (VT2_retc!=0))
      begin
        outfile=$fopen(errFileName,"a");
        $strobe("ctmmh5t       VT2     entering SOCA ( -420.000 V .. 420.000 V ) at %7.4r  %M", $abstime );
        $fwrite(outfile,"ctmmh5t       VT2     entering SOCA ( -420.000 V .. 420.000 V ) at %7.4r  %M\n", $abstime );
        VT2_retc=0;
        VT2_cnt=VT2_cnt-1;
        $fclose(outfile);
      end
      if((VT2 > 420) &&  (VT2_retc!=1))
      begin
        outfile=$fopen(errFileName,"a");
        $strobe("ctmmh5t       VT2     leaving   OCA ( 420.000 V ..  ) at %7.4r  %M", $abstime );
        $fwrite(outfile,"ctmmh5t       VT2     leaving   OCA ( 420.000 V ..  ) at %7.4r  %M\n", $abstime );
        VT2_retc=1;
        VT2_cnt=VT2_cnt-1;
        $fclose(outfile);
      end
   end
   else
   begin
      if(VT2_cnt==0)
      begin
        outfile=$fopen(errFileName,"a");
        $strobe("ctmmh5t       VT2     error limit ( %d ) reached at %7.4r  %M", maxEv, $abstime );
        $fwrite(outfile,"ctmmh5t       VT2     error limit ( %d ) reached at %7.4r  %M\n", maxEv, $abstime );
        VT2_cnt=VT2_cnt-1;
        $fclose(outfile);
      end
   end

//      VT1T2
   VT1T2 = V_T1_T2;
   if((VT1T2_cnt>0) || ( maxEv_flg==0 ))   begin
      if( (VT1T2 < -5.5) && (VT1T2_retc!=-1))
      begin
        outfile=$fopen(errFileName,"a");
        $strobe("ctmmh5t       VT1T2   leaving   OCA (  .. -5.500 V ) at %7.4r  %M", $abstime );
        $fwrite(outfile,"ctmmh5t       VT1T2   leaving   OCA (  .. -5.500 V ) at %7.4r  %M\n", $abstime );
        VT1T2_retc=-1;
        VT1T2_cnt=VT1T2_cnt-1;
        $fclose(outfile);
      end
      if((VT1T2 >= -5.5) &&  (VT1T2 <= 5.5) && (VT1T2_retc!=0))
      begin
        outfile=$fopen(errFileName,"a");
        $strobe("ctmmh5t       VT1T2   entering SOCA ( -5.500 V .. 5.500 V ) at %7.4r  %M", $abstime );
        $fwrite(outfile,"ctmmh5t       VT1T2   entering SOCA ( -5.500 V .. 5.500 V ) at %7.4r  %M\n", $abstime );
        VT1T2_retc=0;
        VT1T2_cnt=VT1T2_cnt-1;
        $fclose(outfile);
      end
      if((VT1T2 > 5.5) &&  (VT1T2_retc!=1))
      begin
        outfile=$fopen(errFileName,"a");
        $strobe("ctmmh5t       VT1T2   leaving   OCA ( 5.500 V ..  ) at %7.4r  %M", $abstime );
        $fwrite(outfile,"ctmmh5t       VT1T2   leaving   OCA ( 5.500 V ..  ) at %7.4r  %M\n", $abstime );
        VT1T2_retc=1;
        VT1T2_cnt=VT1T2_cnt-1;
        $fclose(outfile);
      end
   end
   else
   begin
      if(VT1T2_cnt==0)
      begin
        outfile=$fopen(errFileName,"a");
        $strobe("ctmmh5t       VT1T2   error limit ( %d ) reached at %7.4r  %M", maxEv, $abstime );
        $fwrite(outfile,"ctmmh5t       VT1T2   error limit ( %d ) reached at %7.4r  %M\n", maxEv, $abstime );
        VT1T2_cnt=VT1T2_cnt-1;
        $fclose(outfile);
      end
   end

end // analog
endmodule // ctmmh5t

// Verilog-A OC Watch for device cmmh4l Parameters  VT1 VT2 VT1T2
module cmmh4l_ahdl(T1,T2);
parameter tstep_occ=100n;
parameter errFileName="./occ.err";
parameter maxEv = 25;
parameter maxEv_flg = 0;
inout T1,T2;
electrical T1,T2;

integer outfile;
real V_T1_T2;
real V_T2;
real V_T1;
real VT1;
integer VT1_retc;
integer VT1_cnt;
real VT2;
integer VT2_retc;
integer VT2_cnt;
real VT1T2;
integer VT1T2_retc;
integer VT1T2_cnt;

analog begin
   $bound_step( tstep_occ );
   @(initial_step) begin
      VT1_retc=0;
      VT1_cnt = maxEv;
      VT2_retc=0;
      VT2_cnt = maxEv;
      VT1T2_retc=0;
      VT1T2_cnt = maxEv;
   end
   V_T1_T2 = V(T1,T2);
   V_T2 = V(T2);
   V_T1 = V(T1);

//      VT1
   VT1 = V_T1;
   if((VT1_cnt>0) || ( maxEv_flg==0 ))   begin
      if( (VT1 < -420) && (VT1_retc!=-1))
      begin
        outfile=$fopen(errFileName,"a");
        $strobe("cmmh4l        VT1     leaving   OCA (  .. -420.000 V ) at %7.4r  %M", $abstime );
        $fwrite(outfile,"cmmh4l        VT1     leaving   OCA (  .. -420.000 V ) at %7.4r  %M\n", $abstime );
        VT1_retc=-1;
        VT1_cnt=VT1_cnt-1;
        $fclose(outfile);
      end
      if((VT1 >= -420) &&  (VT1 <= 420) && (VT1_retc!=0))
      begin
        outfile=$fopen(errFileName,"a");
        $strobe("cmmh4l        VT1     entering SOCA ( -420.000 V .. 420.000 V ) at %7.4r  %M", $abstime );
        $fwrite(outfile,"cmmh4l        VT1     entering SOCA ( -420.000 V .. 420.000 V ) at %7.4r  %M\n", $abstime );
        VT1_retc=0;
        VT1_cnt=VT1_cnt-1;
        $fclose(outfile);
      end
      if((VT1 > 420) &&  (VT1_retc!=1))
      begin
        outfile=$fopen(errFileName,"a");
        $strobe("cmmh4l        VT1     leaving   OCA ( 420.000 V ..  ) at %7.4r  %M", $abstime );
        $fwrite(outfile,"cmmh4l        VT1     leaving   OCA ( 420.000 V ..  ) at %7.4r  %M\n", $abstime );
        VT1_retc=1;
        VT1_cnt=VT1_cnt-1;
        $fclose(outfile);
      end
   end
   else
   begin
      if(VT1_cnt==0)
      begin
        outfile=$fopen(errFileName,"a");
        $strobe("cmmh4l        VT1     error limit ( %d ) reached at %7.4r  %M", maxEv, $abstime );
        $fwrite(outfile,"cmmh4l        VT1     error limit ( %d ) reached at %7.4r  %M\n", maxEv, $abstime );
        VT1_cnt=VT1_cnt-1;
        $fclose(outfile);
      end
   end

//      VT2
   VT2 = V_T2;
   if((VT2_cnt>0) || ( maxEv_flg==0 ))   begin
      if( (VT2 < -420) && (VT2_retc!=-1))
      begin
        outfile=$fopen(errFileName,"a");
        $strobe("cmmh4l        VT2     leaving   OCA (  .. -420.000 V ) at %7.4r  %M", $abstime );
        $fwrite(outfile,"cmmh4l        VT2     leaving   OCA (  .. -420.000 V ) at %7.4r  %M\n", $abstime );
        VT2_retc=-1;
        VT2_cnt=VT2_cnt-1;
        $fclose(outfile);
      end
      if((VT2 >= -420) &&  (VT2 <= 420) && (VT2_retc!=0))
      begin
        outfile=$fopen(errFileName,"a");
        $strobe("cmmh4l        VT2     entering SOCA ( -420.000 V .. 420.000 V ) at %7.4r  %M", $abstime );
        $fwrite(outfile,"cmmh4l        VT2     entering SOCA ( -420.000 V .. 420.000 V ) at %7.4r  %M\n", $abstime );
        VT2_retc=0;
        VT2_cnt=VT2_cnt-1;
        $fclose(outfile);
      end
      if((VT2 > 420) &&  (VT2_retc!=1))
      begin
        outfile=$fopen(errFileName,"a");
        $strobe("cmmh4l        VT2     leaving   OCA ( 420.000 V ..  ) at %7.4r  %M", $abstime );
        $fwrite(outfile,"cmmh4l        VT2     leaving   OCA ( 420.000 V ..  ) at %7.4r  %M\n", $abstime );
        VT2_retc=1;
        VT2_cnt=VT2_cnt-1;
        $fclose(outfile);
      end
   end
   else
   begin
      if(VT2_cnt==0)
      begin
        outfile=$fopen(errFileName,"a");
        $strobe("cmmh4l        VT2     error limit ( %d ) reached at %7.4r  %M", maxEv, $abstime );
        $fwrite(outfile,"cmmh4l        VT2     error limit ( %d ) reached at %7.4r  %M\n", maxEv, $abstime );
        VT2_cnt=VT2_cnt-1;
        $fclose(outfile);
      end
   end

//      VT1T2
   VT1T2 = V_T1_T2;
   if((VT1T2_cnt>0) || ( maxEv_flg==0 ))   begin
      if( (VT1T2 < -5.5) && (VT1T2_retc!=-1))
      begin
        outfile=$fopen(errFileName,"a");
        $strobe("cmmh4l        VT1T2   leaving   OCA (  .. -5.500 V ) at %7.4r  %M", $abstime );
        $fwrite(outfile,"cmmh4l        VT1T2   leaving   OCA (  .. -5.500 V ) at %7.4r  %M\n", $abstime );
        VT1T2_retc=-1;
        VT1T2_cnt=VT1T2_cnt-1;
        $fclose(outfile);
      end
      if((VT1T2 >= -5.5) &&  (VT1T2 <= 5.5) && (VT1T2_retc!=0))
      begin
        outfile=$fopen(errFileName,"a");
        $strobe("cmmh4l        VT1T2   entering SOCA ( -5.500 V .. 5.500 V ) at %7.4r  %M", $abstime );
        $fwrite(outfile,"cmmh4l        VT1T2   entering SOCA ( -5.500 V .. 5.500 V ) at %7.4r  %M\n", $abstime );
        VT1T2_retc=0;
        VT1T2_cnt=VT1T2_cnt-1;
        $fclose(outfile);
      end
      if((VT1T2 > 5.5) &&  (VT1T2_retc!=1))
      begin
        outfile=$fopen(errFileName,"a");
        $strobe("cmmh4l        VT1T2   leaving   OCA ( 5.500 V ..  ) at %7.4r  %M", $abstime );
        $fwrite(outfile,"cmmh4l        VT1T2   leaving   OCA ( 5.500 V ..  ) at %7.4r  %M\n", $abstime );
        VT1T2_retc=1;
        VT1T2_cnt=VT1T2_cnt-1;
        $fclose(outfile);
      end
   end
   else
   begin
      if(VT1T2_cnt==0)
      begin
        outfile=$fopen(errFileName,"a");
        $strobe("cmmh4l        VT1T2   error limit ( %d ) reached at %7.4r  %M", maxEv, $abstime );
        $fwrite(outfile,"cmmh4l        VT1T2   error limit ( %d ) reached at %7.4r  %M\n", maxEv, $abstime );
        VT1T2_cnt=VT1T2_cnt-1;
        $fclose(outfile);
      end
   end

end // analog
endmodule // cmmh4l

// Verilog-A OC Watch for device cmmh5l Parameters  VT1 VT2 VT1T2
module cmmh5l_ahdl(T1,T2);
parameter tstep_occ=100n;
parameter errFileName="./occ.err";
parameter maxEv = 25;
parameter maxEv_flg = 0;
inout T1,T2;
electrical T1,T2;

integer outfile;
real V_T1_T2;
real V_T2;
real V_T1;
real VT1;
integer VT1_retc;
integer VT1_cnt;
real VT2;
integer VT2_retc;
integer VT2_cnt;
real VT1T2;
integer VT1T2_retc;
integer VT1T2_cnt;

analog begin
   $bound_step( tstep_occ );
   @(initial_step) begin
      VT1_retc=0;
      VT1_cnt = maxEv;
      VT2_retc=0;
      VT2_cnt = maxEv;
      VT1T2_retc=0;
      VT1T2_cnt = maxEv;
   end
   V_T1_T2 = V(T1,T2);
   V_T2 = V(T2);
   V_T1 = V(T1);

//      VT1
   VT1 = V_T1;
   if((VT1_cnt>0) || ( maxEv_flg==0 ))   begin
      if( (VT1 < -420) && (VT1_retc!=-1))
      begin
        outfile=$fopen(errFileName,"a");
        $strobe("cmmh5l        VT1     leaving   OCA (  .. -420.000 V ) at %7.4r  %M", $abstime );
        $fwrite(outfile,"cmmh5l        VT1     leaving   OCA (  .. -420.000 V ) at %7.4r  %M\n", $abstime );
        VT1_retc=-1;
        VT1_cnt=VT1_cnt-1;
        $fclose(outfile);
      end
      if((VT1 >= -420) &&  (VT1 <= 420) && (VT1_retc!=0))
      begin
        outfile=$fopen(errFileName,"a");
        $strobe("cmmh5l        VT1     entering SOCA ( -420.000 V .. 420.000 V ) at %7.4r  %M", $abstime );
        $fwrite(outfile,"cmmh5l        VT1     entering SOCA ( -420.000 V .. 420.000 V ) at %7.4r  %M\n", $abstime );
        VT1_retc=0;
        VT1_cnt=VT1_cnt-1;
        $fclose(outfile);
      end
      if((VT1 > 420) &&  (VT1_retc!=1))
      begin
        outfile=$fopen(errFileName,"a");
        $strobe("cmmh5l        VT1     leaving   OCA ( 420.000 V ..  ) at %7.4r  %M", $abstime );
        $fwrite(outfile,"cmmh5l        VT1     leaving   OCA ( 420.000 V ..  ) at %7.4r  %M\n", $abstime );
        VT1_retc=1;
        VT1_cnt=VT1_cnt-1;
        $fclose(outfile);
      end
   end
   else
   begin
      if(VT1_cnt==0)
      begin
        outfile=$fopen(errFileName,"a");
        $strobe("cmmh5l        VT1     error limit ( %d ) reached at %7.4r  %M", maxEv, $abstime );
        $fwrite(outfile,"cmmh5l        VT1     error limit ( %d ) reached at %7.4r  %M\n", maxEv, $abstime );
        VT1_cnt=VT1_cnt-1;
        $fclose(outfile);
      end
   end

//      VT2
   VT2 = V_T2;
   if((VT2_cnt>0) || ( maxEv_flg==0 ))   begin
      if( (VT2 < -420) && (VT2_retc!=-1))
      begin
        outfile=$fopen(errFileName,"a");
        $strobe("cmmh5l        VT2     leaving   OCA (  .. -420.000 V ) at %7.4r  %M", $abstime );
        $fwrite(outfile,"cmmh5l        VT2     leaving   OCA (  .. -420.000 V ) at %7.4r  %M\n", $abstime );
        VT2_retc=-1;
        VT2_cnt=VT2_cnt-1;
        $fclose(outfile);
      end
      if((VT2 >= -420) &&  (VT2 <= 420) && (VT2_retc!=0))
      begin
        outfile=$fopen(errFileName,"a");
        $strobe("cmmh5l        VT2     entering SOCA ( -420.000 V .. 420.000 V ) at %7.4r  %M", $abstime );
        $fwrite(outfile,"cmmh5l        VT2     entering SOCA ( -420.000 V .. 420.000 V ) at %7.4r  %M\n", $abstime );
        VT2_retc=0;
        VT2_cnt=VT2_cnt-1;
        $fclose(outfile);
      end
      if((VT2 > 420) &&  (VT2_retc!=1))
      begin
        outfile=$fopen(errFileName,"a");
        $strobe("cmmh5l        VT2     leaving   OCA ( 420.000 V ..  ) at %7.4r  %M", $abstime );
        $fwrite(outfile,"cmmh5l        VT2     leaving   OCA ( 420.000 V ..  ) at %7.4r  %M\n", $abstime );
        VT2_retc=1;
        VT2_cnt=VT2_cnt-1;
        $fclose(outfile);
      end
   end
   else
   begin
      if(VT2_cnt==0)
      begin
        outfile=$fopen(errFileName,"a");
        $strobe("cmmh5l        VT2     error limit ( %d ) reached at %7.4r  %M", maxEv, $abstime );
        $fwrite(outfile,"cmmh5l        VT2     error limit ( %d ) reached at %7.4r  %M\n", maxEv, $abstime );
        VT2_cnt=VT2_cnt-1;
        $fclose(outfile);
      end
   end

//      VT1T2
   VT1T2 = V_T1_T2;
   if((VT1T2_cnt>0) || ( maxEv_flg==0 ))   begin
      if( (VT1T2 < -5.5) && (VT1T2_retc!=-1))
      begin
        outfile=$fopen(errFileName,"a");
        $strobe("cmmh5l        VT1T2   leaving   OCA (  .. -5.500 V ) at %7.4r  %M", $abstime );
        $fwrite(outfile,"cmmh5l        VT1T2   leaving   OCA (  .. -5.500 V ) at %7.4r  %M\n", $abstime );
        VT1T2_retc=-1;
        VT1T2_cnt=VT1T2_cnt-1;
        $fclose(outfile);
      end
      if((VT1T2 >= -5.5) &&  (VT1T2 <= 5.5) && (VT1T2_retc!=0))
      begin
        outfile=$fopen(errFileName,"a");
        $strobe("cmmh5l        VT1T2   entering SOCA ( -5.500 V .. 5.500 V ) at %7.4r  %M", $abstime );
        $fwrite(outfile,"cmmh5l        VT1T2   entering SOCA ( -5.500 V .. 5.500 V ) at %7.4r  %M\n", $abstime );
        VT1T2_retc=0;
        VT1T2_cnt=VT1T2_cnt-1;
        $fclose(outfile);
      end
      if((VT1T2 > 5.5) &&  (VT1T2_retc!=1))
      begin
        outfile=$fopen(errFileName,"a");
        $strobe("cmmh5l        VT1T2   leaving   OCA ( 5.500 V ..  ) at %7.4r  %M", $abstime );
        $fwrite(outfile,"cmmh5l        VT1T2   leaving   OCA ( 5.500 V ..  ) at %7.4r  %M\n", $abstime );
        VT1T2_retc=1;
        VT1T2_cnt=VT1T2_cnt-1;
        $fclose(outfile);
      end
   end
   else
   begin
      if(VT1T2_cnt==0)
      begin
        outfile=$fopen(errFileName,"a");
        $strobe("cmmh5l        VT1T2   error limit ( %d ) reached at %7.4r  %M", maxEv, $abstime );
        $fwrite(outfile,"cmmh5l        VT1T2   error limit ( %d ) reached at %7.4r  %M\n", maxEv, $abstime );
        VT1T2_cnt=VT1T2_cnt-1;
        $fclose(outfile);
      end
   end

end // analog
endmodule // cmmh5l

// Verilog-A OC Watch for device cmmh6l Parameters  VT1 VT2 VT1T2
module cmmh6l_ahdl(T1,T2);
parameter tstep_occ=100n;
parameter errFileName="./occ.err";
parameter maxEv = 25;
parameter maxEv_flg = 0;
inout T1,T2;
electrical T1,T2;

integer outfile;
real V_T1_T2;
real V_T2;
real V_T1;
real VT1;
integer VT1_retc;
integer VT1_cnt;
real VT2;
integer VT2_retc;
integer VT2_cnt;
real VT1T2;
integer VT1T2_retc;
integer VT1T2_cnt;

analog begin
   $bound_step( tstep_occ );
   @(initial_step) begin
      VT1_retc=0;
      VT1_cnt = maxEv;
      VT2_retc=0;
      VT2_cnt = maxEv;
      VT1T2_retc=0;
      VT1T2_cnt = maxEv;
   end
   V_T1_T2 = V(T1,T2);
   V_T2 = V(T2);
   V_T1 = V(T1);

//      VT1
   VT1 = V_T1;
   if((VT1_cnt>0) || ( maxEv_flg==0 ))   begin
      if( (VT1 < -420) && (VT1_retc!=-1))
      begin
        outfile=$fopen(errFileName,"a");
        $strobe("cmmh6l        VT1     leaving   OCA (  .. -420.000 V ) at %7.4r  %M", $abstime );
        $fwrite(outfile,"cmmh6l        VT1     leaving   OCA (  .. -420.000 V ) at %7.4r  %M\n", $abstime );
        VT1_retc=-1;
        VT1_cnt=VT1_cnt-1;
        $fclose(outfile);
      end
      if((VT1 >= -420) &&  (VT1 <= 420) && (VT1_retc!=0))
      begin
        outfile=$fopen(errFileName,"a");
        $strobe("cmmh6l        VT1     entering SOCA ( -420.000 V .. 420.000 V ) at %7.4r  %M", $abstime );
        $fwrite(outfile,"cmmh6l        VT1     entering SOCA ( -420.000 V .. 420.000 V ) at %7.4r  %M\n", $abstime );
        VT1_retc=0;
        VT1_cnt=VT1_cnt-1;
        $fclose(outfile);
      end
      if((VT1 > 420) &&  (VT1_retc!=1))
      begin
        outfile=$fopen(errFileName,"a");
        $strobe("cmmh6l        VT1     leaving   OCA ( 420.000 V ..  ) at %7.4r  %M", $abstime );
        $fwrite(outfile,"cmmh6l        VT1     leaving   OCA ( 420.000 V ..  ) at %7.4r  %M\n", $abstime );
        VT1_retc=1;
        VT1_cnt=VT1_cnt-1;
        $fclose(outfile);
      end
   end
   else
   begin
      if(VT1_cnt==0)
      begin
        outfile=$fopen(errFileName,"a");
        $strobe("cmmh6l        VT1     error limit ( %d ) reached at %7.4r  %M", maxEv, $abstime );
        $fwrite(outfile,"cmmh6l        VT1     error limit ( %d ) reached at %7.4r  %M\n", maxEv, $abstime );
        VT1_cnt=VT1_cnt-1;
        $fclose(outfile);
      end
   end

//      VT2
   VT2 = V_T2;
   if((VT2_cnt>0) || ( maxEv_flg==0 ))   begin
      if( (VT2 < -420) && (VT2_retc!=-1))
      begin
        outfile=$fopen(errFileName,"a");
        $strobe("cmmh6l        VT2     leaving   OCA (  .. -420.000 V ) at %7.4r  %M", $abstime );
        $fwrite(outfile,"cmmh6l        VT2     leaving   OCA (  .. -420.000 V ) at %7.4r  %M\n", $abstime );
        VT2_retc=-1;
        VT2_cnt=VT2_cnt-1;
        $fclose(outfile);
      end
      if((VT2 >= -420) &&  (VT2 <= 420) && (VT2_retc!=0))
      begin
        outfile=$fopen(errFileName,"a");
        $strobe("cmmh6l        VT2     entering SOCA ( -420.000 V .. 420.000 V ) at %7.4r  %M", $abstime );
        $fwrite(outfile,"cmmh6l        VT2     entering SOCA ( -420.000 V .. 420.000 V ) at %7.4r  %M\n", $abstime );
        VT2_retc=0;
        VT2_cnt=VT2_cnt-1;
        $fclose(outfile);
      end
      if((VT2 > 420) &&  (VT2_retc!=1))
      begin
        outfile=$fopen(errFileName,"a");
        $strobe("cmmh6l        VT2     leaving   OCA ( 420.000 V ..  ) at %7.4r  %M", $abstime );
        $fwrite(outfile,"cmmh6l        VT2     leaving   OCA ( 420.000 V ..  ) at %7.4r  %M\n", $abstime );
        VT2_retc=1;
        VT2_cnt=VT2_cnt-1;
        $fclose(outfile);
      end
   end
   else
   begin
      if(VT2_cnt==0)
      begin
        outfile=$fopen(errFileName,"a");
        $strobe("cmmh6l        VT2     error limit ( %d ) reached at %7.4r  %M", maxEv, $abstime );
        $fwrite(outfile,"cmmh6l        VT2     error limit ( %d ) reached at %7.4r  %M\n", maxEv, $abstime );
        VT2_cnt=VT2_cnt-1;
        $fclose(outfile);
      end
   end

//      VT1T2
   VT1T2 = V_T1_T2;
   if((VT1T2_cnt>0) || ( maxEv_flg==0 ))   begin
      if( (VT1T2 < -5.5) && (VT1T2_retc!=-1))
      begin
        outfile=$fopen(errFileName,"a");
        $strobe("cmmh6l        VT1T2   leaving   OCA (  .. -5.500 V ) at %7.4r  %M", $abstime );
        $fwrite(outfile,"cmmh6l        VT1T2   leaving   OCA (  .. -5.500 V ) at %7.4r  %M\n", $abstime );
        VT1T2_retc=-1;
        VT1T2_cnt=VT1T2_cnt-1;
        $fclose(outfile);
      end
      if((VT1T2 >= -5.5) &&  (VT1T2 <= 5.5) && (VT1T2_retc!=0))
      begin
        outfile=$fopen(errFileName,"a");
        $strobe("cmmh6l        VT1T2   entering SOCA ( -5.500 V .. 5.500 V ) at %7.4r  %M", $abstime );
        $fwrite(outfile,"cmmh6l        VT1T2   entering SOCA ( -5.500 V .. 5.500 V ) at %7.4r  %M\n", $abstime );
        VT1T2_retc=0;
        VT1T2_cnt=VT1T2_cnt-1;
        $fclose(outfile);
      end
      if((VT1T2 > 5.5) &&  (VT1T2_retc!=1))
      begin
        outfile=$fopen(errFileName,"a");
        $strobe("cmmh6l        VT1T2   leaving   OCA ( 5.500 V ..  ) at %7.4r  %M", $abstime );
        $fwrite(outfile,"cmmh6l        VT1T2   leaving   OCA ( 5.500 V ..  ) at %7.4r  %M\n", $abstime );
        VT1T2_retc=1;
        VT1T2_cnt=VT1T2_cnt-1;
        $fclose(outfile);
      end
   end
   else
   begin
      if(VT1T2_cnt==0)
      begin
        outfile=$fopen(errFileName,"a");
        $strobe("cmmh6l        VT1T2   error limit ( %d ) reached at %7.4r  %M", maxEv, $abstime );
        $fwrite(outfile,"cmmh6l        VT1T2   error limit ( %d ) reached at %7.4r  %M\n", maxEv, $abstime );
        VT1T2_cnt=VT1T2_cnt-1;
        $fclose(outfile);
      end
   end

end // analog
endmodule // cmmh6l

// Verilog-A OC Watch for device csandwt3 Parameters  VT1 VT2 VT1T2
module csandwt3_ahdl(T1,T2);
parameter tstep_occ=100n;
parameter errFileName="./occ.err";
parameter maxEv = 25;
parameter maxEv_flg = 0;
inout T1,T2;
electrical T1,T2;

integer outfile;
real V_T1_T2;
real V_T2;
real V_T1;
real VT1;
integer VT1_retc;
integer VT1_cnt;
real VT2;
integer VT2_retc;
integer VT2_cnt;
real VT1T2;
integer VT1T2_retc;
integer VT1T2_cnt;

analog begin
   $bound_step( tstep_occ );
   @(initial_step) begin
      VT1_retc=0;
      VT1_cnt = maxEv;
      VT2_retc=0;
      VT2_cnt = maxEv;
      VT1T2_retc=0;
      VT1T2_cnt = maxEv;
   end
   V_T1_T2 = V(T1,T2);
   V_T2 = V(T2);
   V_T1 = V(T1);

//      VT1
   VT1 = V_T1;
   if((VT1_cnt>0) || ( maxEv_flg==0 ))   begin
      if( (VT1 < -200) && (VT1_retc!=-1))
      begin
        outfile=$fopen(errFileName,"a");
        $strobe("csandwt3      VT1     leaving   OCA (  .. -200.000 V ) at %7.4r  %M", $abstime );
        $fwrite(outfile,"csandwt3      VT1     leaving   OCA (  .. -200.000 V ) at %7.4r  %M\n", $abstime );
        VT1_retc=-1;
        VT1_cnt=VT1_cnt-1;
        $fclose(outfile);
      end
      if((VT1 >= -200) &&  (VT1 <= 200) && (VT1_retc!=0))
      begin
        outfile=$fopen(errFileName,"a");
        $strobe("csandwt3      VT1     entering SOCA ( -200.000 V .. 200.000 V ) at %7.4r  %M", $abstime );
        $fwrite(outfile,"csandwt3      VT1     entering SOCA ( -200.000 V .. 200.000 V ) at %7.4r  %M\n", $abstime );
        VT1_retc=0;
        VT1_cnt=VT1_cnt-1;
        $fclose(outfile);
      end
      if((VT1 > 200) &&  (VT1_retc!=1))
      begin
        outfile=$fopen(errFileName,"a");
        $strobe("csandwt3      VT1     leaving   OCA ( 200.000 V ..  ) at %7.4r  %M", $abstime );
        $fwrite(outfile,"csandwt3      VT1     leaving   OCA ( 200.000 V ..  ) at %7.4r  %M\n", $abstime );
        VT1_retc=1;
        VT1_cnt=VT1_cnt-1;
        $fclose(outfile);
      end
   end
   else
   begin
      if(VT1_cnt==0)
      begin
        outfile=$fopen(errFileName,"a");
        $strobe("csandwt3      VT1     error limit ( %d ) reached at %7.4r  %M", maxEv, $abstime );
        $fwrite(outfile,"csandwt3      VT1     error limit ( %d ) reached at %7.4r  %M\n", maxEv, $abstime );
        VT1_cnt=VT1_cnt-1;
        $fclose(outfile);
      end
   end

//      VT2
   VT2 = V_T2;
   if((VT2_cnt>0) || ( maxEv_flg==0 ))   begin
      if( (VT2 < -100) && (VT2_retc!=-1))
      begin
        outfile=$fopen(errFileName,"a");
        $strobe("csandwt3      VT2     leaving   OCA (  .. -100.000 V ) at %7.4r  %M", $abstime );
        $fwrite(outfile,"csandwt3      VT2     leaving   OCA (  .. -100.000 V ) at %7.4r  %M\n", $abstime );
        VT2_retc=-1;
        VT2_cnt=VT2_cnt-1;
        $fclose(outfile);
      end
      if((VT2 >= -100) &&  (VT2 <= 100) && (VT2_retc!=0))
      begin
        outfile=$fopen(errFileName,"a");
        $strobe("csandwt3      VT2     entering SOCA ( -100.000 V .. 100.000 V ) at %7.4r  %M", $abstime );
        $fwrite(outfile,"csandwt3      VT2     entering SOCA ( -100.000 V .. 100.000 V ) at %7.4r  %M\n", $abstime );
        VT2_retc=0;
        VT2_cnt=VT2_cnt-1;
        $fclose(outfile);
      end
      if((VT2 > 100) &&  (VT2_retc!=1))
      begin
        outfile=$fopen(errFileName,"a");
        $strobe("csandwt3      VT2     leaving   OCA ( 100.000 V ..  ) at %7.4r  %M", $abstime );
        $fwrite(outfile,"csandwt3      VT2     leaving   OCA ( 100.000 V ..  ) at %7.4r  %M\n", $abstime );
        VT2_retc=1;
        VT2_cnt=VT2_cnt-1;
        $fclose(outfile);
      end
   end
   else
   begin
      if(VT2_cnt==0)
      begin
        outfile=$fopen(errFileName,"a");
        $strobe("csandwt3      VT2     error limit ( %d ) reached at %7.4r  %M", maxEv, $abstime );
        $fwrite(outfile,"csandwt3      VT2     error limit ( %d ) reached at %7.4r  %M\n", maxEv, $abstime );
        VT2_cnt=VT2_cnt-1;
        $fclose(outfile);
      end
   end

//      VT1T2
   VT1T2 = V_T1_T2;
   if((VT1T2_cnt>0) || ( maxEv_flg==0 ))   begin
      if( (VT1T2 < -200) && (VT1T2_retc!=-1))
      begin
        outfile=$fopen(errFileName,"a");
        $strobe("csandwt3      VT1T2   leaving   OCA (  .. -200.000 V ) at %7.4r  %M", $abstime );
        $fwrite(outfile,"csandwt3      VT1T2   leaving   OCA (  .. -200.000 V ) at %7.4r  %M\n", $abstime );
        VT1T2_retc=-1;
        VT1T2_cnt=VT1T2_cnt-1;
        $fclose(outfile);
      end
      if((VT1T2 >= -200) &&  (VT1T2 <= 200) && (VT1T2_retc!=0))
      begin
        outfile=$fopen(errFileName,"a");
        $strobe("csandwt3      VT1T2   entering SOCA ( -200.000 V .. 200.000 V ) at %7.4r  %M", $abstime );
        $fwrite(outfile,"csandwt3      VT1T2   entering SOCA ( -200.000 V .. 200.000 V ) at %7.4r  %M\n", $abstime );
        VT1T2_retc=0;
        VT1T2_cnt=VT1T2_cnt-1;
        $fclose(outfile);
      end
      if((VT1T2 > 200) &&  (VT1T2_retc!=1))
      begin
        outfile=$fopen(errFileName,"a");
        $strobe("csandwt3      VT1T2   leaving   OCA ( 200.000 V ..  ) at %7.4r  %M", $abstime );
        $fwrite(outfile,"csandwt3      VT1T2   leaving   OCA ( 200.000 V ..  ) at %7.4r  %M\n", $abstime );
        VT1T2_retc=1;
        VT1T2_cnt=VT1T2_cnt-1;
        $fclose(outfile);
      end
   end
   else
   begin
      if(VT1T2_cnt==0)
      begin
        outfile=$fopen(errFileName,"a");
        $strobe("csandwt3      VT1T2   error limit ( %d ) reached at %7.4r  %M", maxEv, $abstime );
        $fwrite(outfile,"csandwt3      VT1T2   error limit ( %d ) reached at %7.4r  %M\n", maxEv, $abstime );
        VT1T2_cnt=VT1T2_cnt-1;
        $fclose(outfile);
      end
   end

end // analog
endmodule // csandwt3

// Verilog-A OC Watch for device csandwt4 Parameters  VT1 VT2 VT1T2
module csandwt4_ahdl(T1,T2);
parameter tstep_occ=100n;
parameter errFileName="./occ.err";
parameter maxEv = 25;
parameter maxEv_flg = 0;
inout T1,T2;
electrical T1,T2;

integer outfile;
real V_T1_T2;
real V_T2;
real V_T1;
real VT1;
integer VT1_retc;
integer VT1_cnt;
real VT2;
integer VT2_retc;
integer VT2_cnt;
real VT1T2;
integer VT1T2_retc;
integer VT1T2_cnt;

analog begin
   $bound_step( tstep_occ );
   @(initial_step) begin
      VT1_retc=0;
      VT1_cnt = maxEv;
      VT2_retc=0;
      VT2_cnt = maxEv;
      VT1T2_retc=0;
      VT1T2_cnt = maxEv;
   end
   V_T1_T2 = V(T1,T2);
   V_T2 = V(T2);
   V_T1 = V(T1);

//      VT1
   VT1 = V_T1;
   if((VT1_cnt>0) || ( maxEv_flg==0 ))   begin
      if( (VT1 < -200) && (VT1_retc!=-1))
      begin
        outfile=$fopen(errFileName,"a");
        $strobe("csandwt4      VT1     leaving   OCA (  .. -200.000 V ) at %7.4r  %M", $abstime );
        $fwrite(outfile,"csandwt4      VT1     leaving   OCA (  .. -200.000 V ) at %7.4r  %M\n", $abstime );
        VT1_retc=-1;
        VT1_cnt=VT1_cnt-1;
        $fclose(outfile);
      end
      if((VT1 >= -200) &&  (VT1 <= 200) && (VT1_retc!=0))
      begin
        outfile=$fopen(errFileName,"a");
        $strobe("csandwt4      VT1     entering SOCA ( -200.000 V .. 200.000 V ) at %7.4r  %M", $abstime );
        $fwrite(outfile,"csandwt4      VT1     entering SOCA ( -200.000 V .. 200.000 V ) at %7.4r  %M\n", $abstime );
        VT1_retc=0;
        VT1_cnt=VT1_cnt-1;
        $fclose(outfile);
      end
      if((VT1 > 200) &&  (VT1_retc!=1))
      begin
        outfile=$fopen(errFileName,"a");
        $strobe("csandwt4      VT1     leaving   OCA ( 200.000 V ..  ) at %7.4r  %M", $abstime );
        $fwrite(outfile,"csandwt4      VT1     leaving   OCA ( 200.000 V ..  ) at %7.4r  %M\n", $abstime );
        VT1_retc=1;
        VT1_cnt=VT1_cnt-1;
        $fclose(outfile);
      end
   end
   else
   begin
      if(VT1_cnt==0)
      begin
        outfile=$fopen(errFileName,"a");
        $strobe("csandwt4      VT1     error limit ( %d ) reached at %7.4r  %M", maxEv, $abstime );
        $fwrite(outfile,"csandwt4      VT1     error limit ( %d ) reached at %7.4r  %M\n", maxEv, $abstime );
        VT1_cnt=VT1_cnt-1;
        $fclose(outfile);
      end
   end

//      VT2
   VT2 = V_T2;
   if((VT2_cnt>0) || ( maxEv_flg==0 ))   begin
      if( (VT2 < -100) && (VT2_retc!=-1))
      begin
        outfile=$fopen(errFileName,"a");
        $strobe("csandwt4      VT2     leaving   OCA (  .. -100.000 V ) at %7.4r  %M", $abstime );
        $fwrite(outfile,"csandwt4      VT2     leaving   OCA (  .. -100.000 V ) at %7.4r  %M\n", $abstime );
        VT2_retc=-1;
        VT2_cnt=VT2_cnt-1;
        $fclose(outfile);
      end
      if((VT2 >= -100) &&  (VT2 <= 100) && (VT2_retc!=0))
      begin
        outfile=$fopen(errFileName,"a");
        $strobe("csandwt4      VT2     entering SOCA ( -100.000 V .. 100.000 V ) at %7.4r  %M", $abstime );
        $fwrite(outfile,"csandwt4      VT2     entering SOCA ( -100.000 V .. 100.000 V ) at %7.4r  %M\n", $abstime );
        VT2_retc=0;
        VT2_cnt=VT2_cnt-1;
        $fclose(outfile);
      end
      if((VT2 > 100) &&  (VT2_retc!=1))
      begin
        outfile=$fopen(errFileName,"a");
        $strobe("csandwt4      VT2     leaving   OCA ( 100.000 V ..  ) at %7.4r  %M", $abstime );
        $fwrite(outfile,"csandwt4      VT2     leaving   OCA ( 100.000 V ..  ) at %7.4r  %M\n", $abstime );
        VT2_retc=1;
        VT2_cnt=VT2_cnt-1;
        $fclose(outfile);
      end
   end
   else
   begin
      if(VT2_cnt==0)
      begin
        outfile=$fopen(errFileName,"a");
        $strobe("csandwt4      VT2     error limit ( %d ) reached at %7.4r  %M", maxEv, $abstime );
        $fwrite(outfile,"csandwt4      VT2     error limit ( %d ) reached at %7.4r  %M\n", maxEv, $abstime );
        VT2_cnt=VT2_cnt-1;
        $fclose(outfile);
      end
   end

//      VT1T2
   VT1T2 = V_T1_T2;
   if((VT1T2_cnt>0) || ( maxEv_flg==0 ))   begin
      if( (VT1T2 < -200) && (VT1T2_retc!=-1))
      begin
        outfile=$fopen(errFileName,"a");
        $strobe("csandwt4      VT1T2   leaving   OCA (  .. -200.000 V ) at %7.4r  %M", $abstime );
        $fwrite(outfile,"csandwt4      VT1T2   leaving   OCA (  .. -200.000 V ) at %7.4r  %M\n", $abstime );
        VT1T2_retc=-1;
        VT1T2_cnt=VT1T2_cnt-1;
        $fclose(outfile);
      end
      if((VT1T2 >= -200) &&  (VT1T2 <= 200) && (VT1T2_retc!=0))
      begin
        outfile=$fopen(errFileName,"a");
        $strobe("csandwt4      VT1T2   entering SOCA ( -200.000 V .. 200.000 V ) at %7.4r  %M", $abstime );
        $fwrite(outfile,"csandwt4      VT1T2   entering SOCA ( -200.000 V .. 200.000 V ) at %7.4r  %M\n", $abstime );
        VT1T2_retc=0;
        VT1T2_cnt=VT1T2_cnt-1;
        $fclose(outfile);
      end
      if((VT1T2 > 200) &&  (VT1T2_retc!=1))
      begin
        outfile=$fopen(errFileName,"a");
        $strobe("csandwt4      VT1T2   leaving   OCA ( 200.000 V ..  ) at %7.4r  %M", $abstime );
        $fwrite(outfile,"csandwt4      VT1T2   leaving   OCA ( 200.000 V ..  ) at %7.4r  %M\n", $abstime );
        VT1T2_retc=1;
        VT1T2_cnt=VT1T2_cnt-1;
        $fclose(outfile);
      end
   end
   else
   begin
      if(VT1T2_cnt==0)
      begin
        outfile=$fopen(errFileName,"a");
        $strobe("csandwt4      VT1T2   error limit ( %d ) reached at %7.4r  %M", maxEv, $abstime );
        $fwrite(outfile,"csandwt4      VT1T2   error limit ( %d ) reached at %7.4r  %M\n", maxEv, $abstime );
        VT1T2_cnt=VT1T2_cnt-1;
        $fclose(outfile);
      end
   end

end // analog
endmodule // csandwt4

// Verilog-A OC Watch for device csandwt5 Parameters  VT1 VT2 VT1T2
module csandwt5_ahdl(T1,T2);
parameter tstep_occ=100n;
parameter errFileName="./occ.err";
parameter maxEv = 25;
parameter maxEv_flg = 0;
inout T1,T2;
electrical T1,T2;

integer outfile;
real V_T1_T2;
real V_T2;
real V_T1;
real VT1;
integer VT1_retc;
integer VT1_cnt;
real VT2;
integer VT2_retc;
integer VT2_cnt;
real VT1T2;
integer VT1T2_retc;
integer VT1T2_cnt;

analog begin
   $bound_step( tstep_occ );
   @(initial_step) begin
      VT1_retc=0;
      VT1_cnt = maxEv;
      VT2_retc=0;
      VT2_cnt = maxEv;
      VT1T2_retc=0;
      VT1T2_cnt = maxEv;
   end
   V_T1_T2 = V(T1,T2);
   V_T2 = V(T2);
   V_T1 = V(T1);

//      VT1
   VT1 = V_T1;
   if((VT1_cnt>0) || ( maxEv_flg==0 ))   begin
      if( (VT1 < -200) && (VT1_retc!=-1))
      begin
        outfile=$fopen(errFileName,"a");
        $strobe("csandwt5      VT1     leaving   OCA (  .. -200.000 V ) at %7.4r  %M", $abstime );
        $fwrite(outfile,"csandwt5      VT1     leaving   OCA (  .. -200.000 V ) at %7.4r  %M\n", $abstime );
        VT1_retc=-1;
        VT1_cnt=VT1_cnt-1;
        $fclose(outfile);
      end
      if((VT1 >= -200) &&  (VT1 <= 200) && (VT1_retc!=0))
      begin
        outfile=$fopen(errFileName,"a");
        $strobe("csandwt5      VT1     entering SOCA ( -200.000 V .. 200.000 V ) at %7.4r  %M", $abstime );
        $fwrite(outfile,"csandwt5      VT1     entering SOCA ( -200.000 V .. 200.000 V ) at %7.4r  %M\n", $abstime );
        VT1_retc=0;
        VT1_cnt=VT1_cnt-1;
        $fclose(outfile);
      end
      if((VT1 > 200) &&  (VT1_retc!=1))
      begin
        outfile=$fopen(errFileName,"a");
        $strobe("csandwt5      VT1     leaving   OCA ( 200.000 V ..  ) at %7.4r  %M", $abstime );
        $fwrite(outfile,"csandwt5      VT1     leaving   OCA ( 200.000 V ..  ) at %7.4r  %M\n", $abstime );
        VT1_retc=1;
        VT1_cnt=VT1_cnt-1;
        $fclose(outfile);
      end
   end
   else
   begin
      if(VT1_cnt==0)
      begin
        outfile=$fopen(errFileName,"a");
        $strobe("csandwt5      VT1     error limit ( %d ) reached at %7.4r  %M", maxEv, $abstime );
        $fwrite(outfile,"csandwt5      VT1     error limit ( %d ) reached at %7.4r  %M\n", maxEv, $abstime );
        VT1_cnt=VT1_cnt-1;
        $fclose(outfile);
      end
   end

//      VT2
   VT2 = V_T2;
   if((VT2_cnt>0) || ( maxEv_flg==0 ))   begin
      if( (VT2 < -100) && (VT2_retc!=-1))
      begin
        outfile=$fopen(errFileName,"a");
        $strobe("csandwt5      VT2     leaving   OCA (  .. -100.000 V ) at %7.4r  %M", $abstime );
        $fwrite(outfile,"csandwt5      VT2     leaving   OCA (  .. -100.000 V ) at %7.4r  %M\n", $abstime );
        VT2_retc=-1;
        VT2_cnt=VT2_cnt-1;
        $fclose(outfile);
      end
      if((VT2 >= -100) &&  (VT2 <= 100) && (VT2_retc!=0))
      begin
        outfile=$fopen(errFileName,"a");
        $strobe("csandwt5      VT2     entering SOCA ( -100.000 V .. 100.000 V ) at %7.4r  %M", $abstime );
        $fwrite(outfile,"csandwt5      VT2     entering SOCA ( -100.000 V .. 100.000 V ) at %7.4r  %M\n", $abstime );
        VT2_retc=0;
        VT2_cnt=VT2_cnt-1;
        $fclose(outfile);
      end
      if((VT2 > 100) &&  (VT2_retc!=1))
      begin
        outfile=$fopen(errFileName,"a");
        $strobe("csandwt5      VT2     leaving   OCA ( 100.000 V ..  ) at %7.4r  %M", $abstime );
        $fwrite(outfile,"csandwt5      VT2     leaving   OCA ( 100.000 V ..  ) at %7.4r  %M\n", $abstime );
        VT2_retc=1;
        VT2_cnt=VT2_cnt-1;
        $fclose(outfile);
      end
   end
   else
   begin
      if(VT2_cnt==0)
      begin
        outfile=$fopen(errFileName,"a");
        $strobe("csandwt5      VT2     error limit ( %d ) reached at %7.4r  %M", maxEv, $abstime );
        $fwrite(outfile,"csandwt5      VT2     error limit ( %d ) reached at %7.4r  %M\n", maxEv, $abstime );
        VT2_cnt=VT2_cnt-1;
        $fclose(outfile);
      end
   end

//      VT1T2
   VT1T2 = V_T1_T2;
   if((VT1T2_cnt>0) || ( maxEv_flg==0 ))   begin
      if( (VT1T2 < -200) && (VT1T2_retc!=-1))
      begin
        outfile=$fopen(errFileName,"a");
        $strobe("csandwt5      VT1T2   leaving   OCA (  .. -200.000 V ) at %7.4r  %M", $abstime );
        $fwrite(outfile,"csandwt5      VT1T2   leaving   OCA (  .. -200.000 V ) at %7.4r  %M\n", $abstime );
        VT1T2_retc=-1;
        VT1T2_cnt=VT1T2_cnt-1;
        $fclose(outfile);
      end
      if((VT1T2 >= -200) &&  (VT1T2 <= 200) && (VT1T2_retc!=0))
      begin
        outfile=$fopen(errFileName,"a");
        $strobe("csandwt5      VT1T2   entering SOCA ( -200.000 V .. 200.000 V ) at %7.4r  %M", $abstime );
        $fwrite(outfile,"csandwt5      VT1T2   entering SOCA ( -200.000 V .. 200.000 V ) at %7.4r  %M\n", $abstime );
        VT1T2_retc=0;
        VT1T2_cnt=VT1T2_cnt-1;
        $fclose(outfile);
      end
      if((VT1T2 > 200) &&  (VT1T2_retc!=1))
      begin
        outfile=$fopen(errFileName,"a");
        $strobe("csandwt5      VT1T2   leaving   OCA ( 200.000 V ..  ) at %7.4r  %M", $abstime );
        $fwrite(outfile,"csandwt5      VT1T2   leaving   OCA ( 200.000 V ..  ) at %7.4r  %M\n", $abstime );
        VT1T2_retc=1;
        VT1T2_cnt=VT1T2_cnt-1;
        $fclose(outfile);
      end
   end
   else
   begin
      if(VT1T2_cnt==0)
      begin
        outfile=$fopen(errFileName,"a");
        $strobe("csandwt5      VT1T2   error limit ( %d ) reached at %7.4r  %M", maxEv, $abstime );
        $fwrite(outfile,"csandwt5      VT1T2   error limit ( %d ) reached at %7.4r  %M\n", maxEv, $abstime );
        VT1T2_cnt=VT1T2_cnt-1;
        $fclose(outfile);
      end
   end

end // analog
endmodule // csandwt5

// Verilog-A OC Watch for device csf2p Parameters  VT1 VT2 VT1T2
module csf2p_ahdl(T1,T2);
parameter tstep_occ=100n;
parameter errFileName="./occ.err";
parameter maxEv = 25;
parameter maxEv_flg = 0;
inout T1,T2;
electrical T1,T2;

integer outfile;
real V_T1_T2;
real V_T2;
real V_T1;
real VT1;
integer VT1_retc;
integer VT1_cnt;
real VT2;
integer VT2_retc;
integer VT2_cnt;
real VT1T2;
integer VT1T2_retc;
integer VT1T2_cnt;

analog begin
   $bound_step( tstep_occ );
   @(initial_step) begin
      VT1_retc=0;
      VT1_cnt = maxEv;
      VT2_retc=0;
      VT2_cnt = maxEv;
      VT1T2_retc=0;
      VT1T2_cnt = maxEv;
   end
   V_T1_T2 = V(T1,T2);
   V_T2 = V(T2);
   V_T1 = V(T1);

//      VT1
   VT1 = V_T1;
   if((VT1_cnt>0) || ( maxEv_flg==0 ))   begin
      if( (VT1 < -100) && (VT1_retc!=-1))
      begin
        outfile=$fopen(errFileName,"a");
        $strobe("csf2p         VT1     leaving   OCA (  .. -100.000 V ) at %7.4r  %M", $abstime );
        $fwrite(outfile,"csf2p         VT1     leaving   OCA (  .. -100.000 V ) at %7.4r  %M\n", $abstime );
        VT1_retc=-1;
        VT1_cnt=VT1_cnt-1;
        $fclose(outfile);
      end
      if((VT1 >= -100) &&  (VT1 <= 100) && (VT1_retc!=0))
      begin
        outfile=$fopen(errFileName,"a");
        $strobe("csf2p         VT1     entering SOCA ( -100.000 V .. 100.000 V ) at %7.4r  %M", $abstime );
        $fwrite(outfile,"csf2p         VT1     entering SOCA ( -100.000 V .. 100.000 V ) at %7.4r  %M\n", $abstime );
        VT1_retc=0;
        VT1_cnt=VT1_cnt-1;
        $fclose(outfile);
      end
      if((VT1 > 100) &&  (VT1_retc!=1))
      begin
        outfile=$fopen(errFileName,"a");
        $strobe("csf2p         VT1     leaving   OCA ( 100.000 V ..  ) at %7.4r  %M", $abstime );
        $fwrite(outfile,"csf2p         VT1     leaving   OCA ( 100.000 V ..  ) at %7.4r  %M\n", $abstime );
        VT1_retc=1;
        VT1_cnt=VT1_cnt-1;
        $fclose(outfile);
      end
   end
   else
   begin
      if(VT1_cnt==0)
      begin
        outfile=$fopen(errFileName,"a");
        $strobe("csf2p         VT1     error limit ( %d ) reached at %7.4r  %M", maxEv, $abstime );
        $fwrite(outfile,"csf2p         VT1     error limit ( %d ) reached at %7.4r  %M\n", maxEv, $abstime );
        VT1_cnt=VT1_cnt-1;
        $fclose(outfile);
      end
   end

//      VT2
   VT2 = V_T2;
   if((VT2_cnt>0) || ( maxEv_flg==0 ))   begin
      if( (VT2 < -100) && (VT2_retc!=-1))
      begin
        outfile=$fopen(errFileName,"a");
        $strobe("csf2p         VT2     leaving   OCA (  .. -100.000 V ) at %7.4r  %M", $abstime );
        $fwrite(outfile,"csf2p         VT2     leaving   OCA (  .. -100.000 V ) at %7.4r  %M\n", $abstime );
        VT2_retc=-1;
        VT2_cnt=VT2_cnt-1;
        $fclose(outfile);
      end
      if((VT2 >= -100) &&  (VT2 <= 100) && (VT2_retc!=0))
      begin
        outfile=$fopen(errFileName,"a");
        $strobe("csf2p         VT2     entering SOCA ( -100.000 V .. 100.000 V ) at %7.4r  %M", $abstime );
        $fwrite(outfile,"csf2p         VT2     entering SOCA ( -100.000 V .. 100.000 V ) at %7.4r  %M\n", $abstime );
        VT2_retc=0;
        VT2_cnt=VT2_cnt-1;
        $fclose(outfile);
      end
      if((VT2 > 100) &&  (VT2_retc!=1))
      begin
        outfile=$fopen(errFileName,"a");
        $strobe("csf2p         VT2     leaving   OCA ( 100.000 V ..  ) at %7.4r  %M", $abstime );
        $fwrite(outfile,"csf2p         VT2     leaving   OCA ( 100.000 V ..  ) at %7.4r  %M\n", $abstime );
        VT2_retc=1;
        VT2_cnt=VT2_cnt-1;
        $fclose(outfile);
      end
   end
   else
   begin
      if(VT2_cnt==0)
      begin
        outfile=$fopen(errFileName,"a");
        $strobe("csf2p         VT2     error limit ( %d ) reached at %7.4r  %M", maxEv, $abstime );
        $fwrite(outfile,"csf2p         VT2     error limit ( %d ) reached at %7.4r  %M\n", maxEv, $abstime );
        VT2_cnt=VT2_cnt-1;
        $fclose(outfile);
      end
   end

//      VT1T2
   VT1T2 = V_T1_T2;
   if((VT1T2_cnt>0) || ( maxEv_flg==0 ))   begin
      if( (VT1T2 < -5.5) && (VT1T2_retc!=-1))
      begin
        outfile=$fopen(errFileName,"a");
        $strobe("csf2p         VT1T2   leaving   OCA (  .. -5.500 V ) at %7.4r  %M", $abstime );
        $fwrite(outfile,"csf2p         VT1T2   leaving   OCA (  .. -5.500 V ) at %7.4r  %M\n", $abstime );
        VT1T2_retc=-1;
        VT1T2_cnt=VT1T2_cnt-1;
        $fclose(outfile);
      end
      if((VT1T2 >= -5.5) &&  (VT1T2 <= 5.5) && (VT1T2_retc!=0))
      begin
        outfile=$fopen(errFileName,"a");
        $strobe("csf2p         VT1T2   entering SOCA ( -5.500 V .. 5.500 V ) at %7.4r  %M", $abstime );
        $fwrite(outfile,"csf2p         VT1T2   entering SOCA ( -5.500 V .. 5.500 V ) at %7.4r  %M\n", $abstime );
        VT1T2_retc=0;
        VT1T2_cnt=VT1T2_cnt-1;
        $fclose(outfile);
      end
      if((VT1T2 > 5.5) &&  (VT1T2_retc!=1))
      begin
        outfile=$fopen(errFileName,"a");
        $strobe("csf2p         VT1T2   leaving   OCA ( 5.500 V ..  ) at %7.4r  %M", $abstime );
        $fwrite(outfile,"csf2p         VT1T2   leaving   OCA ( 5.500 V ..  ) at %7.4r  %M\n", $abstime );
        VT1T2_retc=1;
        VT1T2_cnt=VT1T2_cnt-1;
        $fclose(outfile);
      end
   end
   else
   begin
      if(VT1T2_cnt==0)
      begin
        outfile=$fopen(errFileName,"a");
        $strobe("csf2p         VT1T2   error limit ( %d ) reached at %7.4r  %M", maxEv, $abstime );
        $fwrite(outfile,"csf2p         VT1T2   error limit ( %d ) reached at %7.4r  %M\n", maxEv, $abstime );
        VT1T2_cnt=VT1T2_cnt-1;
        $fclose(outfile);
      end
   end

end // analog
endmodule // csf2p

// Verilog-A OC Watch for device csf3p Parameters  VT1 VT2 VT1T2
module csf3p_ahdl(T1,T2);
parameter tstep_occ=100n;
parameter errFileName="./occ.err";
parameter maxEv = 25;
parameter maxEv_flg = 0;
inout T1,T2;
electrical T1,T2;

integer outfile;
real V_T1_T2;
real V_T2;
real V_T1;
real VT1;
integer VT1_retc;
integer VT1_cnt;
real VT2;
integer VT2_retc;
integer VT2_cnt;
real VT1T2;
integer VT1T2_retc;
integer VT1T2_cnt;

analog begin
   $bound_step( tstep_occ );
   @(initial_step) begin
      VT1_retc=0;
      VT1_cnt = maxEv;
      VT2_retc=0;
      VT2_cnt = maxEv;
      VT1T2_retc=0;
      VT1T2_cnt = maxEv;
   end
   V_T1_T2 = V(T1,T2);
   V_T2 = V(T2);
   V_T1 = V(T1);

//      VT1
   VT1 = V_T1;
   if((VT1_cnt>0) || ( maxEv_flg==0 ))   begin
      if( (VT1 < -100) && (VT1_retc!=-1))
      begin
        outfile=$fopen(errFileName,"a");
        $strobe("csf3p         VT1     leaving   OCA (  .. -100.000 V ) at %7.4r  %M", $abstime );
        $fwrite(outfile,"csf3p         VT1     leaving   OCA (  .. -100.000 V ) at %7.4r  %M\n", $abstime );
        VT1_retc=-1;
        VT1_cnt=VT1_cnt-1;
        $fclose(outfile);
      end
      if((VT1 >= -100) &&  (VT1 <= 100) && (VT1_retc!=0))
      begin
        outfile=$fopen(errFileName,"a");
        $strobe("csf3p         VT1     entering SOCA ( -100.000 V .. 100.000 V ) at %7.4r  %M", $abstime );
        $fwrite(outfile,"csf3p         VT1     entering SOCA ( -100.000 V .. 100.000 V ) at %7.4r  %M\n", $abstime );
        VT1_retc=0;
        VT1_cnt=VT1_cnt-1;
        $fclose(outfile);
      end
      if((VT1 > 100) &&  (VT1_retc!=1))
      begin
        outfile=$fopen(errFileName,"a");
        $strobe("csf3p         VT1     leaving   OCA ( 100.000 V ..  ) at %7.4r  %M", $abstime );
        $fwrite(outfile,"csf3p         VT1     leaving   OCA ( 100.000 V ..  ) at %7.4r  %M\n", $abstime );
        VT1_retc=1;
        VT1_cnt=VT1_cnt-1;
        $fclose(outfile);
      end
   end
   else
   begin
      if(VT1_cnt==0)
      begin
        outfile=$fopen(errFileName,"a");
        $strobe("csf3p         VT1     error limit ( %d ) reached at %7.4r  %M", maxEv, $abstime );
        $fwrite(outfile,"csf3p         VT1     error limit ( %d ) reached at %7.4r  %M\n", maxEv, $abstime );
        VT1_cnt=VT1_cnt-1;
        $fclose(outfile);
      end
   end

//      VT2
   VT2 = V_T2;
   if((VT2_cnt>0) || ( maxEv_flg==0 ))   begin
      if( (VT2 < -100) && (VT2_retc!=-1))
      begin
        outfile=$fopen(errFileName,"a");
        $strobe("csf3p         VT2     leaving   OCA (  .. -100.000 V ) at %7.4r  %M", $abstime );
        $fwrite(outfile,"csf3p         VT2     leaving   OCA (  .. -100.000 V ) at %7.4r  %M\n", $abstime );
        VT2_retc=-1;
        VT2_cnt=VT2_cnt-1;
        $fclose(outfile);
      end
      if((VT2 >= -100) &&  (VT2 <= 100) && (VT2_retc!=0))
      begin
        outfile=$fopen(errFileName,"a");
        $strobe("csf3p         VT2     entering SOCA ( -100.000 V .. 100.000 V ) at %7.4r  %M", $abstime );
        $fwrite(outfile,"csf3p         VT2     entering SOCA ( -100.000 V .. 100.000 V ) at %7.4r  %M\n", $abstime );
        VT2_retc=0;
        VT2_cnt=VT2_cnt-1;
        $fclose(outfile);
      end
      if((VT2 > 100) &&  (VT2_retc!=1))
      begin
        outfile=$fopen(errFileName,"a");
        $strobe("csf3p         VT2     leaving   OCA ( 100.000 V ..  ) at %7.4r  %M", $abstime );
        $fwrite(outfile,"csf3p         VT2     leaving   OCA ( 100.000 V ..  ) at %7.4r  %M\n", $abstime );
        VT2_retc=1;
        VT2_cnt=VT2_cnt-1;
        $fclose(outfile);
      end
   end
   else
   begin
      if(VT2_cnt==0)
      begin
        outfile=$fopen(errFileName,"a");
        $strobe("csf3p         VT2     error limit ( %d ) reached at %7.4r  %M", maxEv, $abstime );
        $fwrite(outfile,"csf3p         VT2     error limit ( %d ) reached at %7.4r  %M\n", maxEv, $abstime );
        VT2_cnt=VT2_cnt-1;
        $fclose(outfile);
      end
   end

//      VT1T2
   VT1T2 = V_T1_T2;
   if((VT1T2_cnt>0) || ( maxEv_flg==0 ))   begin
      if( (VT1T2 < -5.5) && (VT1T2_retc!=-1))
      begin
        outfile=$fopen(errFileName,"a");
        $strobe("csf3p         VT1T2   leaving   OCA (  .. -5.500 V ) at %7.4r  %M", $abstime );
        $fwrite(outfile,"csf3p         VT1T2   leaving   OCA (  .. -5.500 V ) at %7.4r  %M\n", $abstime );
        VT1T2_retc=-1;
        VT1T2_cnt=VT1T2_cnt-1;
        $fclose(outfile);
      end
      if((VT1T2 >= -5.5) &&  (VT1T2 <= 5.5) && (VT1T2_retc!=0))
      begin
        outfile=$fopen(errFileName,"a");
        $strobe("csf3p         VT1T2   entering SOCA ( -5.500 V .. 5.500 V ) at %7.4r  %M", $abstime );
        $fwrite(outfile,"csf3p         VT1T2   entering SOCA ( -5.500 V .. 5.500 V ) at %7.4r  %M\n", $abstime );
        VT1T2_retc=0;
        VT1T2_cnt=VT1T2_cnt-1;
        $fclose(outfile);
      end
      if((VT1T2 > 5.5) &&  (VT1T2_retc!=1))
      begin
        outfile=$fopen(errFileName,"a");
        $strobe("csf3p         VT1T2   leaving   OCA ( 5.500 V ..  ) at %7.4r  %M", $abstime );
        $fwrite(outfile,"csf3p         VT1T2   leaving   OCA ( 5.500 V ..  ) at %7.4r  %M\n", $abstime );
        VT1T2_retc=1;
        VT1T2_cnt=VT1T2_cnt-1;
        $fclose(outfile);
      end
   end
   else
   begin
      if(VT1T2_cnt==0)
      begin
        outfile=$fopen(errFileName,"a");
        $strobe("csf3p         VT1T2   error limit ( %d ) reached at %7.4r  %M", maxEv, $abstime );
        $fwrite(outfile,"csf3p         VT1T2   error limit ( %d ) reached at %7.4r  %M\n", maxEv, $abstime );
        VT1T2_cnt=VT1T2_cnt-1;
        $fclose(outfile);
      end
   end

end // analog
endmodule // csf3p

// Verilog-A OC Watch for device csf3 Parameters  VT1 VT2 VT1T2
module csf3_ahdl(T1,T2);
parameter tstep_occ=100n;
parameter errFileName="./occ.err";
parameter maxEv = 25;
parameter maxEv_flg = 0;
inout T1,T2;
electrical T1,T2;

integer outfile;
real V_T1_T2;
real V_T2;
real V_T1;
real VT1;
integer VT1_retc;
integer VT1_cnt;
real VT2;
integer VT2_retc;
integer VT2_cnt;
real VT1T2;
integer VT1T2_retc;
integer VT1T2_cnt;

analog begin
   $bound_step( tstep_occ );
   @(initial_step) begin
      VT1_retc=0;
      VT1_cnt = maxEv;
      VT2_retc=0;
      VT2_cnt = maxEv;
      VT1T2_retc=0;
      VT1T2_cnt = maxEv;
   end
   V_T1_T2 = V(T1,T2);
   V_T2 = V(T2);
   V_T1 = V(T1);

//      VT1
   VT1 = V_T1;
   if((VT1_cnt>0) || ( maxEv_flg==0 ))   begin
      if( (VT1 < -200) && (VT1_retc!=-1))
      begin
        outfile=$fopen(errFileName,"a");
        $strobe("csf3          VT1     leaving   OCA (  .. -200.000 V ) at %7.4r  %M", $abstime );
        $fwrite(outfile,"csf3          VT1     leaving   OCA (  .. -200.000 V ) at %7.4r  %M\n", $abstime );
        VT1_retc=-1;
        VT1_cnt=VT1_cnt-1;
        $fclose(outfile);
      end
      if((VT1 >= -200) &&  (VT1 <= 200) && (VT1_retc!=0))
      begin
        outfile=$fopen(errFileName,"a");
        $strobe("csf3          VT1     entering SOCA ( -200.000 V .. 200.000 V ) at %7.4r  %M", $abstime );
        $fwrite(outfile,"csf3          VT1     entering SOCA ( -200.000 V .. 200.000 V ) at %7.4r  %M\n", $abstime );
        VT1_retc=0;
        VT1_cnt=VT1_cnt-1;
        $fclose(outfile);
      end
      if((VT1 > 200) &&  (VT1_retc!=1))
      begin
        outfile=$fopen(errFileName,"a");
        $strobe("csf3          VT1     leaving   OCA ( 200.000 V ..  ) at %7.4r  %M", $abstime );
        $fwrite(outfile,"csf3          VT1     leaving   OCA ( 200.000 V ..  ) at %7.4r  %M\n", $abstime );
        VT1_retc=1;
        VT1_cnt=VT1_cnt-1;
        $fclose(outfile);
      end
   end
   else
   begin
      if(VT1_cnt==0)
      begin
        outfile=$fopen(errFileName,"a");
        $strobe("csf3          VT1     error limit ( %d ) reached at %7.4r  %M", maxEv, $abstime );
        $fwrite(outfile,"csf3          VT1     error limit ( %d ) reached at %7.4r  %M\n", maxEv, $abstime );
        VT1_cnt=VT1_cnt-1;
        $fclose(outfile);
      end
   end

//      VT2
   VT2 = V_T2;
   if((VT2_cnt>0) || ( maxEv_flg==0 ))   begin
      if( (VT2 < -200) && (VT2_retc!=-1))
      begin
        outfile=$fopen(errFileName,"a");
        $strobe("csf3          VT2     leaving   OCA (  .. -200.000 V ) at %7.4r  %M", $abstime );
        $fwrite(outfile,"csf3          VT2     leaving   OCA (  .. -200.000 V ) at %7.4r  %M\n", $abstime );
        VT2_retc=-1;
        VT2_cnt=VT2_cnt-1;
        $fclose(outfile);
      end
      if((VT2 >= -200) &&  (VT2 <= 200) && (VT2_retc!=0))
      begin
        outfile=$fopen(errFileName,"a");
        $strobe("csf3          VT2     entering SOCA ( -200.000 V .. 200.000 V ) at %7.4r  %M", $abstime );
        $fwrite(outfile,"csf3          VT2     entering SOCA ( -200.000 V .. 200.000 V ) at %7.4r  %M\n", $abstime );
        VT2_retc=0;
        VT2_cnt=VT2_cnt-1;
        $fclose(outfile);
      end
      if((VT2 > 200) &&  (VT2_retc!=1))
      begin
        outfile=$fopen(errFileName,"a");
        $strobe("csf3          VT2     leaving   OCA ( 200.000 V ..  ) at %7.4r  %M", $abstime );
        $fwrite(outfile,"csf3          VT2     leaving   OCA ( 200.000 V ..  ) at %7.4r  %M\n", $abstime );
        VT2_retc=1;
        VT2_cnt=VT2_cnt-1;
        $fclose(outfile);
      end
   end
   else
   begin
      if(VT2_cnt==0)
      begin
        outfile=$fopen(errFileName,"a");
        $strobe("csf3          VT2     error limit ( %d ) reached at %7.4r  %M", maxEv, $abstime );
        $fwrite(outfile,"csf3          VT2     error limit ( %d ) reached at %7.4r  %M\n", maxEv, $abstime );
        VT2_cnt=VT2_cnt-1;
        $fclose(outfile);
      end
   end

//      VT1T2
   VT1T2 = V_T1_T2;
   if((VT1T2_cnt>0) || ( maxEv_flg==0 ))   begin
      if( (VT1T2 < -10) && (VT1T2_retc!=-1))
      begin
        outfile=$fopen(errFileName,"a");
        $strobe("csf3          VT1T2   leaving   OCA (  .. -10.000 V ) at %7.4r  %M", $abstime );
        $fwrite(outfile,"csf3          VT1T2   leaving   OCA (  .. -10.000 V ) at %7.4r  %M\n", $abstime );
        VT1T2_retc=-1;
        VT1T2_cnt=VT1T2_cnt-1;
        $fclose(outfile);
      end
      if((VT1T2 >= -10) &&  (VT1T2 <= 10) && (VT1T2_retc!=0))
      begin
        outfile=$fopen(errFileName,"a");
        $strobe("csf3          VT1T2   entering SOCA ( -10.000 V .. 10.000 V ) at %7.4r  %M", $abstime );
        $fwrite(outfile,"csf3          VT1T2   entering SOCA ( -10.000 V .. 10.000 V ) at %7.4r  %M\n", $abstime );
        VT1T2_retc=0;
        VT1T2_cnt=VT1T2_cnt-1;
        $fclose(outfile);
      end
      if((VT1T2 > 10) &&  (VT1T2_retc!=1))
      begin
        outfile=$fopen(errFileName,"a");
        $strobe("csf3          VT1T2   leaving   OCA ( 10.000 V ..  ) at %7.4r  %M", $abstime );
        $fwrite(outfile,"csf3          VT1T2   leaving   OCA ( 10.000 V ..  ) at %7.4r  %M\n", $abstime );
        VT1T2_retc=1;
        VT1T2_cnt=VT1T2_cnt-1;
        $fclose(outfile);
      end
   end
   else
   begin
      if(VT1T2_cnt==0)
      begin
        outfile=$fopen(errFileName,"a");
        $strobe("csf3          VT1T2   error limit ( %d ) reached at %7.4r  %M", maxEv, $abstime );
        $fwrite(outfile,"csf3          VT1T2   error limit ( %d ) reached at %7.4r  %M\n", maxEv, $abstime );
        VT1T2_cnt=VT1T2_cnt-1;
        $fclose(outfile);
      end
   end

end // analog
endmodule // csf3

// Verilog-A OC Watch for device csf4 Parameters  VT1 VT2 VT1T2
module csf4_ahdl(T1,T2);
parameter tstep_occ=100n;
parameter errFileName="./occ.err";
parameter maxEv = 25;
parameter maxEv_flg = 0;
inout T1,T2;
electrical T1,T2;

integer outfile;
real V_T1_T2;
real V_T2;
real V_T1;
real VT1;
integer VT1_retc;
integer VT1_cnt;
real VT2;
integer VT2_retc;
integer VT2_cnt;
real VT1T2;
integer VT1T2_retc;
integer VT1T2_cnt;

analog begin
   $bound_step( tstep_occ );
   @(initial_step) begin
      VT1_retc=0;
      VT1_cnt = maxEv;
      VT2_retc=0;
      VT2_cnt = maxEv;
      VT1T2_retc=0;
      VT1T2_cnt = maxEv;
   end
   V_T1_T2 = V(T1,T2);
   V_T2 = V(T2);
   V_T1 = V(T1);

//      VT1
   VT1 = V_T1;
   if((VT1_cnt>0) || ( maxEv_flg==0 ))   begin
      if( (VT1 < -200) && (VT1_retc!=-1))
      begin
        outfile=$fopen(errFileName,"a");
        $strobe("csf4          VT1     leaving   OCA (  .. -200.000 V ) at %7.4r  %M", $abstime );
        $fwrite(outfile,"csf4          VT1     leaving   OCA (  .. -200.000 V ) at %7.4r  %M\n", $abstime );
        VT1_retc=-1;
        VT1_cnt=VT1_cnt-1;
        $fclose(outfile);
      end
      if((VT1 >= -200) &&  (VT1 <= 200) && (VT1_retc!=0))
      begin
        outfile=$fopen(errFileName,"a");
        $strobe("csf4          VT1     entering SOCA ( -200.000 V .. 200.000 V ) at %7.4r  %M", $abstime );
        $fwrite(outfile,"csf4          VT1     entering SOCA ( -200.000 V .. 200.000 V ) at %7.4r  %M\n", $abstime );
        VT1_retc=0;
        VT1_cnt=VT1_cnt-1;
        $fclose(outfile);
      end
      if((VT1 > 200) &&  (VT1_retc!=1))
      begin
        outfile=$fopen(errFileName,"a");
        $strobe("csf4          VT1     leaving   OCA ( 200.000 V ..  ) at %7.4r  %M", $abstime );
        $fwrite(outfile,"csf4          VT1     leaving   OCA ( 200.000 V ..  ) at %7.4r  %M\n", $abstime );
        VT1_retc=1;
        VT1_cnt=VT1_cnt-1;
        $fclose(outfile);
      end
   end
   else
   begin
      if(VT1_cnt==0)
      begin
        outfile=$fopen(errFileName,"a");
        $strobe("csf4          VT1     error limit ( %d ) reached at %7.4r  %M", maxEv, $abstime );
        $fwrite(outfile,"csf4          VT1     error limit ( %d ) reached at %7.4r  %M\n", maxEv, $abstime );
        VT1_cnt=VT1_cnt-1;
        $fclose(outfile);
      end
   end

//      VT2
   VT2 = V_T2;
   if((VT2_cnt>0) || ( maxEv_flg==0 ))   begin
      if( (VT2 < -200) && (VT2_retc!=-1))
      begin
        outfile=$fopen(errFileName,"a");
        $strobe("csf4          VT2     leaving   OCA (  .. -200.000 V ) at %7.4r  %M", $abstime );
        $fwrite(outfile,"csf4          VT2     leaving   OCA (  .. -200.000 V ) at %7.4r  %M\n", $abstime );
        VT2_retc=-1;
        VT2_cnt=VT2_cnt-1;
        $fclose(outfile);
      end
      if((VT2 >= -200) &&  (VT2 <= 200) && (VT2_retc!=0))
      begin
        outfile=$fopen(errFileName,"a");
        $strobe("csf4          VT2     entering SOCA ( -200.000 V .. 200.000 V ) at %7.4r  %M", $abstime );
        $fwrite(outfile,"csf4          VT2     entering SOCA ( -200.000 V .. 200.000 V ) at %7.4r  %M\n", $abstime );
        VT2_retc=0;
        VT2_cnt=VT2_cnt-1;
        $fclose(outfile);
      end
      if((VT2 > 200) &&  (VT2_retc!=1))
      begin
        outfile=$fopen(errFileName,"a");
        $strobe("csf4          VT2     leaving   OCA ( 200.000 V ..  ) at %7.4r  %M", $abstime );
        $fwrite(outfile,"csf4          VT2     leaving   OCA ( 200.000 V ..  ) at %7.4r  %M\n", $abstime );
        VT2_retc=1;
        VT2_cnt=VT2_cnt-1;
        $fclose(outfile);
      end
   end
   else
   begin
      if(VT2_cnt==0)
      begin
        outfile=$fopen(errFileName,"a");
        $strobe("csf4          VT2     error limit ( %d ) reached at %7.4r  %M", maxEv, $abstime );
        $fwrite(outfile,"csf4          VT2     error limit ( %d ) reached at %7.4r  %M\n", maxEv, $abstime );
        VT2_cnt=VT2_cnt-1;
        $fclose(outfile);
      end
   end

//      VT1T2
   VT1T2 = V_T1_T2;
   if((VT1T2_cnt>0) || ( maxEv_flg==0 ))   begin
      if( (VT1T2 < -10) && (VT1T2_retc!=-1))
      begin
        outfile=$fopen(errFileName,"a");
        $strobe("csf4          VT1T2   leaving   OCA (  .. -10.000 V ) at %7.4r  %M", $abstime );
        $fwrite(outfile,"csf4          VT1T2   leaving   OCA (  .. -10.000 V ) at %7.4r  %M\n", $abstime );
        VT1T2_retc=-1;
        VT1T2_cnt=VT1T2_cnt-1;
        $fclose(outfile);
      end
      if((VT1T2 >= -10) &&  (VT1T2 <= 10) && (VT1T2_retc!=0))
      begin
        outfile=$fopen(errFileName,"a");
        $strobe("csf4          VT1T2   entering SOCA ( -10.000 V .. 10.000 V ) at %7.4r  %M", $abstime );
        $fwrite(outfile,"csf4          VT1T2   entering SOCA ( -10.000 V .. 10.000 V ) at %7.4r  %M\n", $abstime );
        VT1T2_retc=0;
        VT1T2_cnt=VT1T2_cnt-1;
        $fclose(outfile);
      end
      if((VT1T2 > 10) &&  (VT1T2_retc!=1))
      begin
        outfile=$fopen(errFileName,"a");
        $strobe("csf4          VT1T2   leaving   OCA ( 10.000 V ..  ) at %7.4r  %M", $abstime );
        $fwrite(outfile,"csf4          VT1T2   leaving   OCA ( 10.000 V ..  ) at %7.4r  %M\n", $abstime );
        VT1T2_retc=1;
        VT1T2_cnt=VT1T2_cnt-1;
        $fclose(outfile);
      end
   end
   else
   begin
      if(VT1T2_cnt==0)
      begin
        outfile=$fopen(errFileName,"a");
        $strobe("csf4          VT1T2   error limit ( %d ) reached at %7.4r  %M", maxEv, $abstime );
        $fwrite(outfile,"csf4          VT1T2   error limit ( %d ) reached at %7.4r  %M\n", maxEv, $abstime );
        VT1T2_cnt=VT1T2_cnt-1;
        $fclose(outfile);
      end
   end

end // analog
endmodule // csf4

// Verilog-A OC Watch for device csf5 Parameters  VT1 VT2 VT1T2
module csf5_ahdl(T1,T2);
parameter tstep_occ=100n;
parameter errFileName="./occ.err";
parameter maxEv = 25;
parameter maxEv_flg = 0;
inout T1,T2;
electrical T1,T2;

integer outfile;
real V_T1_T2;
real V_T2;
real V_T1;
real VT1;
integer VT1_retc;
integer VT1_cnt;
real VT2;
integer VT2_retc;
integer VT2_cnt;
real VT1T2;
integer VT1T2_retc;
integer VT1T2_cnt;

analog begin
   $bound_step( tstep_occ );
   @(initial_step) begin
      VT1_retc=0;
      VT1_cnt = maxEv;
      VT2_retc=0;
      VT2_cnt = maxEv;
      VT1T2_retc=0;
      VT1T2_cnt = maxEv;
   end
   V_T1_T2 = V(T1,T2);
   V_T2 = V(T2);
   V_T1 = V(T1);

//      VT1
   VT1 = V_T1;
   if((VT1_cnt>0) || ( maxEv_flg==0 ))   begin
      if( (VT1 < -200) && (VT1_retc!=-1))
      begin
        outfile=$fopen(errFileName,"a");
        $strobe("csf5          VT1     leaving   OCA (  .. -200.000 V ) at %7.4r  %M", $abstime );
        $fwrite(outfile,"csf5          VT1     leaving   OCA (  .. -200.000 V ) at %7.4r  %M\n", $abstime );
        VT1_retc=-1;
        VT1_cnt=VT1_cnt-1;
        $fclose(outfile);
      end
      if((VT1 >= -200) &&  (VT1 <= 200) && (VT1_retc!=0))
      begin
        outfile=$fopen(errFileName,"a");
        $strobe("csf5          VT1     entering SOCA ( -200.000 V .. 200.000 V ) at %7.4r  %M", $abstime );
        $fwrite(outfile,"csf5          VT1     entering SOCA ( -200.000 V .. 200.000 V ) at %7.4r  %M\n", $abstime );
        VT1_retc=0;
        VT1_cnt=VT1_cnt-1;
        $fclose(outfile);
      end
      if((VT1 > 200) &&  (VT1_retc!=1))
      begin
        outfile=$fopen(errFileName,"a");
        $strobe("csf5          VT1     leaving   OCA ( 200.000 V ..  ) at %7.4r  %M", $abstime );
        $fwrite(outfile,"csf5          VT1     leaving   OCA ( 200.000 V ..  ) at %7.4r  %M\n", $abstime );
        VT1_retc=1;
        VT1_cnt=VT1_cnt-1;
        $fclose(outfile);
      end
   end
   else
   begin
      if(VT1_cnt==0)
      begin
        outfile=$fopen(errFileName,"a");
        $strobe("csf5          VT1     error limit ( %d ) reached at %7.4r  %M", maxEv, $abstime );
        $fwrite(outfile,"csf5          VT1     error limit ( %d ) reached at %7.4r  %M\n", maxEv, $abstime );
        VT1_cnt=VT1_cnt-1;
        $fclose(outfile);
      end
   end

//      VT2
   VT2 = V_T2;
   if((VT2_cnt>0) || ( maxEv_flg==0 ))   begin
      if( (VT2 < -200) && (VT2_retc!=-1))
      begin
        outfile=$fopen(errFileName,"a");
        $strobe("csf5          VT2     leaving   OCA (  .. -200.000 V ) at %7.4r  %M", $abstime );
        $fwrite(outfile,"csf5          VT2     leaving   OCA (  .. -200.000 V ) at %7.4r  %M\n", $abstime );
        VT2_retc=-1;
        VT2_cnt=VT2_cnt-1;
        $fclose(outfile);
      end
      if((VT2 >= -200) &&  (VT2 <= 200) && (VT2_retc!=0))
      begin
        outfile=$fopen(errFileName,"a");
        $strobe("csf5          VT2     entering SOCA ( -200.000 V .. 200.000 V ) at %7.4r  %M", $abstime );
        $fwrite(outfile,"csf5          VT2     entering SOCA ( -200.000 V .. 200.000 V ) at %7.4r  %M\n", $abstime );
        VT2_retc=0;
        VT2_cnt=VT2_cnt-1;
        $fclose(outfile);
      end
      if((VT2 > 200) &&  (VT2_retc!=1))
      begin
        outfile=$fopen(errFileName,"a");
        $strobe("csf5          VT2     leaving   OCA ( 200.000 V ..  ) at %7.4r  %M", $abstime );
        $fwrite(outfile,"csf5          VT2     leaving   OCA ( 200.000 V ..  ) at %7.4r  %M\n", $abstime );
        VT2_retc=1;
        VT2_cnt=VT2_cnt-1;
        $fclose(outfile);
      end
   end
   else
   begin
      if(VT2_cnt==0)
      begin
        outfile=$fopen(errFileName,"a");
        $strobe("csf5          VT2     error limit ( %d ) reached at %7.4r  %M", maxEv, $abstime );
        $fwrite(outfile,"csf5          VT2     error limit ( %d ) reached at %7.4r  %M\n", maxEv, $abstime );
        VT2_cnt=VT2_cnt-1;
        $fclose(outfile);
      end
   end

//      VT1T2
   VT1T2 = V_T1_T2;
   if((VT1T2_cnt>0) || ( maxEv_flg==0 ))   begin
      if( (VT1T2 < -10) && (VT1T2_retc!=-1))
      begin
        outfile=$fopen(errFileName,"a");
        $strobe("csf5          VT1T2   leaving   OCA (  .. -10.000 V ) at %7.4r  %M", $abstime );
        $fwrite(outfile,"csf5          VT1T2   leaving   OCA (  .. -10.000 V ) at %7.4r  %M\n", $abstime );
        VT1T2_retc=-1;
        VT1T2_cnt=VT1T2_cnt-1;
        $fclose(outfile);
      end
      if((VT1T2 >= -10) &&  (VT1T2 <= 10) && (VT1T2_retc!=0))
      begin
        outfile=$fopen(errFileName,"a");
        $strobe("csf5          VT1T2   entering SOCA ( -10.000 V .. 10.000 V ) at %7.4r  %M", $abstime );
        $fwrite(outfile,"csf5          VT1T2   entering SOCA ( -10.000 V .. 10.000 V ) at %7.4r  %M\n", $abstime );
        VT1T2_retc=0;
        VT1T2_cnt=VT1T2_cnt-1;
        $fclose(outfile);
      end
      if((VT1T2 > 10) &&  (VT1T2_retc!=1))
      begin
        outfile=$fopen(errFileName,"a");
        $strobe("csf5          VT1T2   leaving   OCA ( 10.000 V ..  ) at %7.4r  %M", $abstime );
        $fwrite(outfile,"csf5          VT1T2   leaving   OCA ( 10.000 V ..  ) at %7.4r  %M\n", $abstime );
        VT1T2_retc=1;
        VT1T2_cnt=VT1T2_cnt-1;
        $fclose(outfile);
      end
   end
   else
   begin
      if(VT1T2_cnt==0)
      begin
        outfile=$fopen(errFileName,"a");
        $strobe("csf5          VT1T2   error limit ( %d ) reached at %7.4r  %M", maxEv, $abstime );
        $fwrite(outfile,"csf5          VT1T2   error limit ( %d ) reached at %7.4r  %M\n", maxEv, $abstime );
        VT1T2_cnt=VT1T2_cnt-1;
        $fclose(outfile);
      end
   end

end // analog
endmodule // csf5

// Verilog-A OC Watch for device csft4 Parameters  VT1 VT2 VT1T2
module csft4_ahdl(T1,T2);
parameter tstep_occ=100n;
parameter errFileName="./occ.err";
parameter maxEv = 25;
parameter maxEv_flg = 0;
inout T1,T2;
electrical T1,T2;

integer outfile;
real V_T1_T2;
real V_T2;
real V_T1;
real VT1;
integer VT1_retc;
integer VT1_cnt;
real VT2;
integer VT2_retc;
integer VT2_cnt;
real VT1T2;
integer VT1T2_retc;
integer VT1T2_cnt;

analog begin
   $bound_step( tstep_occ );
   @(initial_step) begin
      VT1_retc=0;
      VT1_cnt = maxEv;
      VT2_retc=0;
      VT2_cnt = maxEv;
      VT1T2_retc=0;
      VT1T2_cnt = maxEv;
   end
   V_T1_T2 = V(T1,T2);
   V_T2 = V(T2);
   V_T1 = V(T1);

//      VT1
   VT1 = V_T1;
   if((VT1_cnt>0) || ( maxEv_flg==0 ))   begin
      if( (VT1 < -200) && (VT1_retc!=-1))
      begin
        outfile=$fopen(errFileName,"a");
        $strobe("csft4         VT1     leaving   OCA (  .. -200.000 V ) at %7.4r  %M", $abstime );
        $fwrite(outfile,"csft4         VT1     leaving   OCA (  .. -200.000 V ) at %7.4r  %M\n", $abstime );
        VT1_retc=-1;
        VT1_cnt=VT1_cnt-1;
        $fclose(outfile);
      end
      if((VT1 >= -200) &&  (VT1 <= 200) && (VT1_retc!=0))
      begin
        outfile=$fopen(errFileName,"a");
        $strobe("csft4         VT1     entering SOCA ( -200.000 V .. 200.000 V ) at %7.4r  %M", $abstime );
        $fwrite(outfile,"csft4         VT1     entering SOCA ( -200.000 V .. 200.000 V ) at %7.4r  %M\n", $abstime );
        VT1_retc=0;
        VT1_cnt=VT1_cnt-1;
        $fclose(outfile);
      end
      if((VT1 > 200) &&  (VT1_retc!=1))
      begin
        outfile=$fopen(errFileName,"a");
        $strobe("csft4         VT1     leaving   OCA ( 200.000 V ..  ) at %7.4r  %M", $abstime );
        $fwrite(outfile,"csft4         VT1     leaving   OCA ( 200.000 V ..  ) at %7.4r  %M\n", $abstime );
        VT1_retc=1;
        VT1_cnt=VT1_cnt-1;
        $fclose(outfile);
      end
   end
   else
   begin
      if(VT1_cnt==0)
      begin
        outfile=$fopen(errFileName,"a");
        $strobe("csft4         VT1     error limit ( %d ) reached at %7.4r  %M", maxEv, $abstime );
        $fwrite(outfile,"csft4         VT1     error limit ( %d ) reached at %7.4r  %M\n", maxEv, $abstime );
        VT1_cnt=VT1_cnt-1;
        $fclose(outfile);
      end
   end

//      VT2
   VT2 = V_T2;
   if((VT2_cnt>0) || ( maxEv_flg==0 ))   begin
      if( (VT2 < -200) && (VT2_retc!=-1))
      begin
        outfile=$fopen(errFileName,"a");
        $strobe("csft4         VT2     leaving   OCA (  .. -200.000 V ) at %7.4r  %M", $abstime );
        $fwrite(outfile,"csft4         VT2     leaving   OCA (  .. -200.000 V ) at %7.4r  %M\n", $abstime );
        VT2_retc=-1;
        VT2_cnt=VT2_cnt-1;
        $fclose(outfile);
      end
      if((VT2 >= -200) &&  (VT2 <= 200) && (VT2_retc!=0))
      begin
        outfile=$fopen(errFileName,"a");
        $strobe("csft4         VT2     entering SOCA ( -200.000 V .. 200.000 V ) at %7.4r  %M", $abstime );
        $fwrite(outfile,"csft4         VT2     entering SOCA ( -200.000 V .. 200.000 V ) at %7.4r  %M\n", $abstime );
        VT2_retc=0;
        VT2_cnt=VT2_cnt-1;
        $fclose(outfile);
      end
      if((VT2 > 200) &&  (VT2_retc!=1))
      begin
        outfile=$fopen(errFileName,"a");
        $strobe("csft4         VT2     leaving   OCA ( 200.000 V ..  ) at %7.4r  %M", $abstime );
        $fwrite(outfile,"csft4         VT2     leaving   OCA ( 200.000 V ..  ) at %7.4r  %M\n", $abstime );
        VT2_retc=1;
        VT2_cnt=VT2_cnt-1;
        $fclose(outfile);
      end
   end
   else
   begin
      if(VT2_cnt==0)
      begin
        outfile=$fopen(errFileName,"a");
        $strobe("csft4         VT2     error limit ( %d ) reached at %7.4r  %M", maxEv, $abstime );
        $fwrite(outfile,"csft4         VT2     error limit ( %d ) reached at %7.4r  %M\n", maxEv, $abstime );
        VT2_cnt=VT2_cnt-1;
        $fclose(outfile);
      end
   end

//      VT1T2
   VT1T2 = V_T1_T2;
   if((VT1T2_cnt>0) || ( maxEv_flg==0 ))   begin
      if( (VT1T2 < -10) && (VT1T2_retc!=-1))
      begin
        outfile=$fopen(errFileName,"a");
        $strobe("csft4         VT1T2   leaving   OCA (  .. -10.000 V ) at %7.4r  %M", $abstime );
        $fwrite(outfile,"csft4         VT1T2   leaving   OCA (  .. -10.000 V ) at %7.4r  %M\n", $abstime );
        VT1T2_retc=-1;
        VT1T2_cnt=VT1T2_cnt-1;
        $fclose(outfile);
      end
      if((VT1T2 >= -10) &&  (VT1T2 <= 10) && (VT1T2_retc!=0))
      begin
        outfile=$fopen(errFileName,"a");
        $strobe("csft4         VT1T2   entering SOCA ( -10.000 V .. 10.000 V ) at %7.4r  %M", $abstime );
        $fwrite(outfile,"csft4         VT1T2   entering SOCA ( -10.000 V .. 10.000 V ) at %7.4r  %M\n", $abstime );
        VT1T2_retc=0;
        VT1T2_cnt=VT1T2_cnt-1;
        $fclose(outfile);
      end
      if((VT1T2 > 10) &&  (VT1T2_retc!=1))
      begin
        outfile=$fopen(errFileName,"a");
        $strobe("csft4         VT1T2   leaving   OCA ( 10.000 V ..  ) at %7.4r  %M", $abstime );
        $fwrite(outfile,"csft4         VT1T2   leaving   OCA ( 10.000 V ..  ) at %7.4r  %M\n", $abstime );
        VT1T2_retc=1;
        VT1T2_cnt=VT1T2_cnt-1;
        $fclose(outfile);
      end
   end
   else
   begin
      if(VT1T2_cnt==0)
      begin
        outfile=$fopen(errFileName,"a");
        $strobe("csft4         VT1T2   error limit ( %d ) reached at %7.4r  %M", maxEv, $abstime );
        $fwrite(outfile,"csft4         VT1T2   error limit ( %d ) reached at %7.4r  %M\n", maxEv, $abstime );
        VT1T2_cnt=VT1T2_cnt-1;
        $fclose(outfile);
      end
   end

end // analog
endmodule // csft4

// Verilog-A OC Watch for device csft5 Parameters  VT1 VT2 VT1T2
module csft5_ahdl(T1,T2);
parameter tstep_occ=100n;
parameter errFileName="./occ.err";
parameter maxEv = 25;
parameter maxEv_flg = 0;
inout T1,T2;
electrical T1,T2;

integer outfile;
real V_T1_T2;
real V_T2;
real V_T1;
real VT1;
integer VT1_retc;
integer VT1_cnt;
real VT2;
integer VT2_retc;
integer VT2_cnt;
real VT1T2;
integer VT1T2_retc;
integer VT1T2_cnt;

analog begin
   $bound_step( tstep_occ );
   @(initial_step) begin
      VT1_retc=0;
      VT1_cnt = maxEv;
      VT2_retc=0;
      VT2_cnt = maxEv;
      VT1T2_retc=0;
      VT1T2_cnt = maxEv;
   end
   V_T1_T2 = V(T1,T2);
   V_T2 = V(T2);
   V_T1 = V(T1);

//      VT1
   VT1 = V_T1;
   if((VT1_cnt>0) || ( maxEv_flg==0 ))   begin
      if( (VT1 < -200) && (VT1_retc!=-1))
      begin
        outfile=$fopen(errFileName,"a");
        $strobe("csft5         VT1     leaving   OCA (  .. -200.000 V ) at %7.4r  %M", $abstime );
        $fwrite(outfile,"csft5         VT1     leaving   OCA (  .. -200.000 V ) at %7.4r  %M\n", $abstime );
        VT1_retc=-1;
        VT1_cnt=VT1_cnt-1;
        $fclose(outfile);
      end
      if((VT1 >= -200) &&  (VT1 <= 200) && (VT1_retc!=0))
      begin
        outfile=$fopen(errFileName,"a");
        $strobe("csft5         VT1     entering SOCA ( -200.000 V .. 200.000 V ) at %7.4r  %M", $abstime );
        $fwrite(outfile,"csft5         VT1     entering SOCA ( -200.000 V .. 200.000 V ) at %7.4r  %M\n", $abstime );
        VT1_retc=0;
        VT1_cnt=VT1_cnt-1;
        $fclose(outfile);
      end
      if((VT1 > 200) &&  (VT1_retc!=1))
      begin
        outfile=$fopen(errFileName,"a");
        $strobe("csft5         VT1     leaving   OCA ( 200.000 V ..  ) at %7.4r  %M", $abstime );
        $fwrite(outfile,"csft5         VT1     leaving   OCA ( 200.000 V ..  ) at %7.4r  %M\n", $abstime );
        VT1_retc=1;
        VT1_cnt=VT1_cnt-1;
        $fclose(outfile);
      end
   end
   else
   begin
      if(VT1_cnt==0)
      begin
        outfile=$fopen(errFileName,"a");
        $strobe("csft5         VT1     error limit ( %d ) reached at %7.4r  %M", maxEv, $abstime );
        $fwrite(outfile,"csft5         VT1     error limit ( %d ) reached at %7.4r  %M\n", maxEv, $abstime );
        VT1_cnt=VT1_cnt-1;
        $fclose(outfile);
      end
   end

//      VT2
   VT2 = V_T2;
   if((VT2_cnt>0) || ( maxEv_flg==0 ))   begin
      if( (VT2 < -200) && (VT2_retc!=-1))
      begin
        outfile=$fopen(errFileName,"a");
        $strobe("csft5         VT2     leaving   OCA (  .. -200.000 V ) at %7.4r  %M", $abstime );
        $fwrite(outfile,"csft5         VT2     leaving   OCA (  .. -200.000 V ) at %7.4r  %M\n", $abstime );
        VT2_retc=-1;
        VT2_cnt=VT2_cnt-1;
        $fclose(outfile);
      end
      if((VT2 >= -200) &&  (VT2 <= 200) && (VT2_retc!=0))
      begin
        outfile=$fopen(errFileName,"a");
        $strobe("csft5         VT2     entering SOCA ( -200.000 V .. 200.000 V ) at %7.4r  %M", $abstime );
        $fwrite(outfile,"csft5         VT2     entering SOCA ( -200.000 V .. 200.000 V ) at %7.4r  %M\n", $abstime );
        VT2_retc=0;
        VT2_cnt=VT2_cnt-1;
        $fclose(outfile);
      end
      if((VT2 > 200) &&  (VT2_retc!=1))
      begin
        outfile=$fopen(errFileName,"a");
        $strobe("csft5         VT2     leaving   OCA ( 200.000 V ..  ) at %7.4r  %M", $abstime );
        $fwrite(outfile,"csft5         VT2     leaving   OCA ( 200.000 V ..  ) at %7.4r  %M\n", $abstime );
        VT2_retc=1;
        VT2_cnt=VT2_cnt-1;
        $fclose(outfile);
      end
   end
   else
   begin
      if(VT2_cnt==0)
      begin
        outfile=$fopen(errFileName,"a");
        $strobe("csft5         VT2     error limit ( %d ) reached at %7.4r  %M", maxEv, $abstime );
        $fwrite(outfile,"csft5         VT2     error limit ( %d ) reached at %7.4r  %M\n", maxEv, $abstime );
        VT2_cnt=VT2_cnt-1;
        $fclose(outfile);
      end
   end

//      VT1T2
   VT1T2 = V_T1_T2;
   if((VT1T2_cnt>0) || ( maxEv_flg==0 ))   begin
      if( (VT1T2 < -10) && (VT1T2_retc!=-1))
      begin
        outfile=$fopen(errFileName,"a");
        $strobe("csft5         VT1T2   leaving   OCA (  .. -10.000 V ) at %7.4r  %M", $abstime );
        $fwrite(outfile,"csft5         VT1T2   leaving   OCA (  .. -10.000 V ) at %7.4r  %M\n", $abstime );
        VT1T2_retc=-1;
        VT1T2_cnt=VT1T2_cnt-1;
        $fclose(outfile);
      end
      if((VT1T2 >= -10) &&  (VT1T2 <= 10) && (VT1T2_retc!=0))
      begin
        outfile=$fopen(errFileName,"a");
        $strobe("csft5         VT1T2   entering SOCA ( -10.000 V .. 10.000 V ) at %7.4r  %M", $abstime );
        $fwrite(outfile,"csft5         VT1T2   entering SOCA ( -10.000 V .. 10.000 V ) at %7.4r  %M\n", $abstime );
        VT1T2_retc=0;
        VT1T2_cnt=VT1T2_cnt-1;
        $fclose(outfile);
      end
      if((VT1T2 > 10) &&  (VT1T2_retc!=1))
      begin
        outfile=$fopen(errFileName,"a");
        $strobe("csft5         VT1T2   leaving   OCA ( 10.000 V ..  ) at %7.4r  %M", $abstime );
        $fwrite(outfile,"csft5         VT1T2   leaving   OCA ( 10.000 V ..  ) at %7.4r  %M\n", $abstime );
        VT1T2_retc=1;
        VT1T2_cnt=VT1T2_cnt-1;
        $fclose(outfile);
      end
   end
   else
   begin
      if(VT1T2_cnt==0)
      begin
        outfile=$fopen(errFileName,"a");
        $strobe("csft5         VT1T2   error limit ( %d ) reached at %7.4r  %M", maxEv, $abstime );
        $fwrite(outfile,"csft5         VT1T2   error limit ( %d ) reached at %7.4r  %M\n", maxEv, $abstime );
        VT1T2_cnt=VT1T2_cnt-1;
        $fclose(outfile);
      end
   end

end // analog
endmodule // csft5

// Verilog-A OC Watch for device csft6 Parameters  VT1 VT2 VT1T2
module csft6_ahdl(T1,T2);
parameter tstep_occ=100n;
parameter errFileName="./occ.err";
parameter maxEv = 25;
parameter maxEv_flg = 0;
inout T1,T2;
electrical T1,T2;

integer outfile;
real V_T1_T2;
real V_T2;
real V_T1;
real VT1;
integer VT1_retc;
integer VT1_cnt;
real VT2;
integer VT2_retc;
integer VT2_cnt;
real VT1T2;
integer VT1T2_retc;
integer VT1T2_cnt;

analog begin
   $bound_step( tstep_occ );
   @(initial_step) begin
      VT1_retc=0;
      VT1_cnt = maxEv;
      VT2_retc=0;
      VT2_cnt = maxEv;
      VT1T2_retc=0;
      VT1T2_cnt = maxEv;
   end
   V_T1_T2 = V(T1,T2);
   V_T2 = V(T2);
   V_T1 = V(T1);

//      VT1
   VT1 = V_T1;
   if((VT1_cnt>0) || ( maxEv_flg==0 ))   begin
      if( (VT1 < -200) && (VT1_retc!=-1))
      begin
        outfile=$fopen(errFileName,"a");
        $strobe("csft6         VT1     leaving   OCA (  .. -200.000 V ) at %7.4r  %M", $abstime );
        $fwrite(outfile,"csft6         VT1     leaving   OCA (  .. -200.000 V ) at %7.4r  %M\n", $abstime );
        VT1_retc=-1;
        VT1_cnt=VT1_cnt-1;
        $fclose(outfile);
      end
      if((VT1 >= -200) &&  (VT1 <= 200) && (VT1_retc!=0))
      begin
        outfile=$fopen(errFileName,"a");
        $strobe("csft6         VT1     entering SOCA ( -200.000 V .. 200.000 V ) at %7.4r  %M", $abstime );
        $fwrite(outfile,"csft6         VT1     entering SOCA ( -200.000 V .. 200.000 V ) at %7.4r  %M\n", $abstime );
        VT1_retc=0;
        VT1_cnt=VT1_cnt-1;
        $fclose(outfile);
      end
      if((VT1 > 200) &&  (VT1_retc!=1))
      begin
        outfile=$fopen(errFileName,"a");
        $strobe("csft6         VT1     leaving   OCA ( 200.000 V ..  ) at %7.4r  %M", $abstime );
        $fwrite(outfile,"csft6         VT1     leaving   OCA ( 200.000 V ..  ) at %7.4r  %M\n", $abstime );
        VT1_retc=1;
        VT1_cnt=VT1_cnt-1;
        $fclose(outfile);
      end
   end
   else
   begin
      if(VT1_cnt==0)
      begin
        outfile=$fopen(errFileName,"a");
        $strobe("csft6         VT1     error limit ( %d ) reached at %7.4r  %M", maxEv, $abstime );
        $fwrite(outfile,"csft6         VT1     error limit ( %d ) reached at %7.4r  %M\n", maxEv, $abstime );
        VT1_cnt=VT1_cnt-1;
        $fclose(outfile);
      end
   end

//      VT2
   VT2 = V_T2;
   if((VT2_cnt>0) || ( maxEv_flg==0 ))   begin
      if( (VT2 < -200) && (VT2_retc!=-1))
      begin
        outfile=$fopen(errFileName,"a");
        $strobe("csft6         VT2     leaving   OCA (  .. -200.000 V ) at %7.4r  %M", $abstime );
        $fwrite(outfile,"csft6         VT2     leaving   OCA (  .. -200.000 V ) at %7.4r  %M\n", $abstime );
        VT2_retc=-1;
        VT2_cnt=VT2_cnt-1;
        $fclose(outfile);
      end
      if((VT2 >= -200) &&  (VT2 <= 200) && (VT2_retc!=0))
      begin
        outfile=$fopen(errFileName,"a");
        $strobe("csft6         VT2     entering SOCA ( -200.000 V .. 200.000 V ) at %7.4r  %M", $abstime );
        $fwrite(outfile,"csft6         VT2     entering SOCA ( -200.000 V .. 200.000 V ) at %7.4r  %M\n", $abstime );
        VT2_retc=0;
        VT2_cnt=VT2_cnt-1;
        $fclose(outfile);
      end
      if((VT2 > 200) &&  (VT2_retc!=1))
      begin
        outfile=$fopen(errFileName,"a");
        $strobe("csft6         VT2     leaving   OCA ( 200.000 V ..  ) at %7.4r  %M", $abstime );
        $fwrite(outfile,"csft6         VT2     leaving   OCA ( 200.000 V ..  ) at %7.4r  %M\n", $abstime );
        VT2_retc=1;
        VT2_cnt=VT2_cnt-1;
        $fclose(outfile);
      end
   end
   else
   begin
      if(VT2_cnt==0)
      begin
        outfile=$fopen(errFileName,"a");
        $strobe("csft6         VT2     error limit ( %d ) reached at %7.4r  %M", maxEv, $abstime );
        $fwrite(outfile,"csft6         VT2     error limit ( %d ) reached at %7.4r  %M\n", maxEv, $abstime );
        VT2_cnt=VT2_cnt-1;
        $fclose(outfile);
      end
   end

//      VT1T2
   VT1T2 = V_T1_T2;
   if((VT1T2_cnt>0) || ( maxEv_flg==0 ))   begin
      if( (VT1T2 < -10) && (VT1T2_retc!=-1))
      begin
        outfile=$fopen(errFileName,"a");
        $strobe("csft6         VT1T2   leaving   OCA (  .. -10.000 V ) at %7.4r  %M", $abstime );
        $fwrite(outfile,"csft6         VT1T2   leaving   OCA (  .. -10.000 V ) at %7.4r  %M\n", $abstime );
        VT1T2_retc=-1;
        VT1T2_cnt=VT1T2_cnt-1;
        $fclose(outfile);
      end
      if((VT1T2 >= -10) &&  (VT1T2 <= 10) && (VT1T2_retc!=0))
      begin
        outfile=$fopen(errFileName,"a");
        $strobe("csft6         VT1T2   entering SOCA ( -10.000 V .. 10.000 V ) at %7.4r  %M", $abstime );
        $fwrite(outfile,"csft6         VT1T2   entering SOCA ( -10.000 V .. 10.000 V ) at %7.4r  %M\n", $abstime );
        VT1T2_retc=0;
        VT1T2_cnt=VT1T2_cnt-1;
        $fclose(outfile);
      end
      if((VT1T2 > 10) &&  (VT1T2_retc!=1))
      begin
        outfile=$fopen(errFileName,"a");
        $strobe("csft6         VT1T2   leaving   OCA ( 10.000 V ..  ) at %7.4r  %M", $abstime );
        $fwrite(outfile,"csft6         VT1T2   leaving   OCA ( 10.000 V ..  ) at %7.4r  %M\n", $abstime );
        VT1T2_retc=1;
        VT1T2_cnt=VT1T2_cnt-1;
        $fclose(outfile);
      end
   end
   else
   begin
      if(VT1T2_cnt==0)
      begin
        outfile=$fopen(errFileName,"a");
        $strobe("csft6         VT1T2   error limit ( %d ) reached at %7.4r  %M", maxEv, $abstime );
        $fwrite(outfile,"csft6         VT1T2   error limit ( %d ) reached at %7.4r  %M\n", maxEv, $abstime );
        VT1T2_cnt=VT1T2_cnt-1;
        $fclose(outfile);
      end
   end

end // analog
endmodule // csft6

// Verilog-A OC Watch for device csf3a Parameters  VT1 VT2 VT1T2
module csf3a_ahdl(T1,T2);
parameter tstep_occ=100n;
parameter errFileName="./occ.err";
parameter maxEv = 25;
parameter maxEv_flg = 0;
inout T1,T2;
electrical T1,T2;

integer outfile;
real V_T1_T2;
real V_T2;
real V_T1;
real VT1;
integer VT1_retc;
integer VT1_cnt;
real VT2;
integer VT2_retc;
integer VT2_cnt;
real VT1T2;
integer VT1T2_retc;
integer VT1T2_cnt;

analog begin
   $bound_step( tstep_occ );
   @(initial_step) begin
      VT1_retc=0;
      VT1_cnt = maxEv;
      VT2_retc=0;
      VT2_cnt = maxEv;
      VT1T2_retc=0;
      VT1T2_cnt = maxEv;
   end
   V_T1_T2 = V(T1,T2);
   V_T2 = V(T2);
   V_T1 = V(T1);

//      VT1
   VT1 = V_T1;
   if((VT1_cnt>0) || ( maxEv_flg==0 ))   begin
      if( (VT1 < -200) && (VT1_retc!=-1))
      begin
        outfile=$fopen(errFileName,"a");
        $strobe("csf3a         VT1     leaving   OCA (  .. -200.000 V ) at %7.4r  %M", $abstime );
        $fwrite(outfile,"csf3a         VT1     leaving   OCA (  .. -200.000 V ) at %7.4r  %M\n", $abstime );
        VT1_retc=-1;
        VT1_cnt=VT1_cnt-1;
        $fclose(outfile);
      end
      if((VT1 >= -200) &&  (VT1 <= 200) && (VT1_retc!=0))
      begin
        outfile=$fopen(errFileName,"a");
        $strobe("csf3a         VT1     entering SOCA ( -200.000 V .. 200.000 V ) at %7.4r  %M", $abstime );
        $fwrite(outfile,"csf3a         VT1     entering SOCA ( -200.000 V .. 200.000 V ) at %7.4r  %M\n", $abstime );
        VT1_retc=0;
        VT1_cnt=VT1_cnt-1;
        $fclose(outfile);
      end
      if((VT1 > 200) &&  (VT1_retc!=1))
      begin
        outfile=$fopen(errFileName,"a");
        $strobe("csf3a         VT1     leaving   OCA ( 200.000 V ..  ) at %7.4r  %M", $abstime );
        $fwrite(outfile,"csf3a         VT1     leaving   OCA ( 200.000 V ..  ) at %7.4r  %M\n", $abstime );
        VT1_retc=1;
        VT1_cnt=VT1_cnt-1;
        $fclose(outfile);
      end
   end
   else
   begin
      if(VT1_cnt==0)
      begin
        outfile=$fopen(errFileName,"a");
        $strobe("csf3a         VT1     error limit ( %d ) reached at %7.4r  %M", maxEv, $abstime );
        $fwrite(outfile,"csf3a         VT1     error limit ( %d ) reached at %7.4r  %M\n", maxEv, $abstime );
        VT1_cnt=VT1_cnt-1;
        $fclose(outfile);
      end
   end

//      VT2
   VT2 = V_T2;
   if((VT2_cnt>0) || ( maxEv_flg==0 ))   begin
      if( (VT2 < -200) && (VT2_retc!=-1))
      begin
        outfile=$fopen(errFileName,"a");
        $strobe("csf3a         VT2     leaving   OCA (  .. -200.000 V ) at %7.4r  %M", $abstime );
        $fwrite(outfile,"csf3a         VT2     leaving   OCA (  .. -200.000 V ) at %7.4r  %M\n", $abstime );
        VT2_retc=-1;
        VT2_cnt=VT2_cnt-1;
        $fclose(outfile);
      end
      if((VT2 >= -200) &&  (VT2 <= 200) && (VT2_retc!=0))
      begin
        outfile=$fopen(errFileName,"a");
        $strobe("csf3a         VT2     entering SOCA ( -200.000 V .. 200.000 V ) at %7.4r  %M", $abstime );
        $fwrite(outfile,"csf3a         VT2     entering SOCA ( -200.000 V .. 200.000 V ) at %7.4r  %M\n", $abstime );
        VT2_retc=0;
        VT2_cnt=VT2_cnt-1;
        $fclose(outfile);
      end
      if((VT2 > 200) &&  (VT2_retc!=1))
      begin
        outfile=$fopen(errFileName,"a");
        $strobe("csf3a         VT2     leaving   OCA ( 200.000 V ..  ) at %7.4r  %M", $abstime );
        $fwrite(outfile,"csf3a         VT2     leaving   OCA ( 200.000 V ..  ) at %7.4r  %M\n", $abstime );
        VT2_retc=1;
        VT2_cnt=VT2_cnt-1;
        $fclose(outfile);
      end
   end
   else
   begin
      if(VT2_cnt==0)
      begin
        outfile=$fopen(errFileName,"a");
        $strobe("csf3a         VT2     error limit ( %d ) reached at %7.4r  %M", maxEv, $abstime );
        $fwrite(outfile,"csf3a         VT2     error limit ( %d ) reached at %7.4r  %M\n", maxEv, $abstime );
        VT2_cnt=VT2_cnt-1;
        $fclose(outfile);
      end
   end

//      VT1T2
   VT1T2 = V_T1_T2;
   if((VT1T2_cnt>0) || ( maxEv_flg==0 ))   begin
      if( (VT1T2 < -60) && (VT1T2_retc!=-1))
      begin
        outfile=$fopen(errFileName,"a");
        $strobe("csf3a         VT1T2   leaving   OCA (  .. -60.000 V ) at %7.4r  %M", $abstime );
        $fwrite(outfile,"csf3a         VT1T2   leaving   OCA (  .. -60.000 V ) at %7.4r  %M\n", $abstime );
        VT1T2_retc=-1;
        VT1T2_cnt=VT1T2_cnt-1;
        $fclose(outfile);
      end
      if((VT1T2 >= -60) &&  (VT1T2 <= 60) && (VT1T2_retc!=0))
      begin
        outfile=$fopen(errFileName,"a");
        $strobe("csf3a         VT1T2   entering SOCA ( -60.000 V .. 60.000 V ) at %7.4r  %M", $abstime );
        $fwrite(outfile,"csf3a         VT1T2   entering SOCA ( -60.000 V .. 60.000 V ) at %7.4r  %M\n", $abstime );
        VT1T2_retc=0;
        VT1T2_cnt=VT1T2_cnt-1;
        $fclose(outfile);
      end
      if((VT1T2 > 60) &&  (VT1T2_retc!=1))
      begin
        outfile=$fopen(errFileName,"a");
        $strobe("csf3a         VT1T2   leaving   OCA ( 60.000 V ..  ) at %7.4r  %M", $abstime );
        $fwrite(outfile,"csf3a         VT1T2   leaving   OCA ( 60.000 V ..  ) at %7.4r  %M\n", $abstime );
        VT1T2_retc=1;
        VT1T2_cnt=VT1T2_cnt-1;
        $fclose(outfile);
      end
   end
   else
   begin
      if(VT1T2_cnt==0)
      begin
        outfile=$fopen(errFileName,"a");
        $strobe("csf3a         VT1T2   error limit ( %d ) reached at %7.4r  %M", maxEv, $abstime );
        $fwrite(outfile,"csf3a         VT1T2   error limit ( %d ) reached at %7.4r  %M\n", maxEv, $abstime );
        VT1T2_cnt=VT1T2_cnt-1;
        $fclose(outfile);
      end
   end

end // analog
endmodule // csf3a

// Verilog-A OC Watch for device csf4a Parameters  VT1 VT2 VT1T2
module csf4a_ahdl(T1,T2);
parameter tstep_occ=100n;
parameter errFileName="./occ.err";
parameter maxEv = 25;
parameter maxEv_flg = 0;
inout T1,T2;
electrical T1,T2;

integer outfile;
real V_T1_T2;
real V_T2;
real V_T1;
real VT1;
integer VT1_retc;
integer VT1_cnt;
real VT2;
integer VT2_retc;
integer VT2_cnt;
real VT1T2;
integer VT1T2_retc;
integer VT1T2_cnt;

analog begin
   $bound_step( tstep_occ );
   @(initial_step) begin
      VT1_retc=0;
      VT1_cnt = maxEv;
      VT2_retc=0;
      VT2_cnt = maxEv;
      VT1T2_retc=0;
      VT1T2_cnt = maxEv;
   end
   V_T1_T2 = V(T1,T2);
   V_T2 = V(T2);
   V_T1 = V(T1);

//      VT1
   VT1 = V_T1;
   if((VT1_cnt>0) || ( maxEv_flg==0 ))   begin
      if( (VT1 < -200) && (VT1_retc!=-1))
      begin
        outfile=$fopen(errFileName,"a");
        $strobe("csf4a         VT1     leaving   OCA (  .. -200.000 V ) at %7.4r  %M", $abstime );
        $fwrite(outfile,"csf4a         VT1     leaving   OCA (  .. -200.000 V ) at %7.4r  %M\n", $abstime );
        VT1_retc=-1;
        VT1_cnt=VT1_cnt-1;
        $fclose(outfile);
      end
      if((VT1 >= -200) &&  (VT1 <= 200) && (VT1_retc!=0))
      begin
        outfile=$fopen(errFileName,"a");
        $strobe("csf4a         VT1     entering SOCA ( -200.000 V .. 200.000 V ) at %7.4r  %M", $abstime );
        $fwrite(outfile,"csf4a         VT1     entering SOCA ( -200.000 V .. 200.000 V ) at %7.4r  %M\n", $abstime );
        VT1_retc=0;
        VT1_cnt=VT1_cnt-1;
        $fclose(outfile);
      end
      if((VT1 > 200) &&  (VT1_retc!=1))
      begin
        outfile=$fopen(errFileName,"a");
        $strobe("csf4a         VT1     leaving   OCA ( 200.000 V ..  ) at %7.4r  %M", $abstime );
        $fwrite(outfile,"csf4a         VT1     leaving   OCA ( 200.000 V ..  ) at %7.4r  %M\n", $abstime );
        VT1_retc=1;
        VT1_cnt=VT1_cnt-1;
        $fclose(outfile);
      end
   end
   else
   begin
      if(VT1_cnt==0)
      begin
        outfile=$fopen(errFileName,"a");
        $strobe("csf4a         VT1     error limit ( %d ) reached at %7.4r  %M", maxEv, $abstime );
        $fwrite(outfile,"csf4a         VT1     error limit ( %d ) reached at %7.4r  %M\n", maxEv, $abstime );
        VT1_cnt=VT1_cnt-1;
        $fclose(outfile);
      end
   end

//      VT2
   VT2 = V_T2;
   if((VT2_cnt>0) || ( maxEv_flg==0 ))   begin
      if( (VT2 < -200) && (VT2_retc!=-1))
      begin
        outfile=$fopen(errFileName,"a");
        $strobe("csf4a         VT2     leaving   OCA (  .. -200.000 V ) at %7.4r  %M", $abstime );
        $fwrite(outfile,"csf4a         VT2     leaving   OCA (  .. -200.000 V ) at %7.4r  %M\n", $abstime );
        VT2_retc=-1;
        VT2_cnt=VT2_cnt-1;
        $fclose(outfile);
      end
      if((VT2 >= -200) &&  (VT2 <= 200) && (VT2_retc!=0))
      begin
        outfile=$fopen(errFileName,"a");
        $strobe("csf4a         VT2     entering SOCA ( -200.000 V .. 200.000 V ) at %7.4r  %M", $abstime );
        $fwrite(outfile,"csf4a         VT2     entering SOCA ( -200.000 V .. 200.000 V ) at %7.4r  %M\n", $abstime );
        VT2_retc=0;
        VT2_cnt=VT2_cnt-1;
        $fclose(outfile);
      end
      if((VT2 > 200) &&  (VT2_retc!=1))
      begin
        outfile=$fopen(errFileName,"a");
        $strobe("csf4a         VT2     leaving   OCA ( 200.000 V ..  ) at %7.4r  %M", $abstime );
        $fwrite(outfile,"csf4a         VT2     leaving   OCA ( 200.000 V ..  ) at %7.4r  %M\n", $abstime );
        VT2_retc=1;
        VT2_cnt=VT2_cnt-1;
        $fclose(outfile);
      end
   end
   else
   begin
      if(VT2_cnt==0)
      begin
        outfile=$fopen(errFileName,"a");
        $strobe("csf4a         VT2     error limit ( %d ) reached at %7.4r  %M", maxEv, $abstime );
        $fwrite(outfile,"csf4a         VT2     error limit ( %d ) reached at %7.4r  %M\n", maxEv, $abstime );
        VT2_cnt=VT2_cnt-1;
        $fclose(outfile);
      end
   end

//      VT1T2
   VT1T2 = V_T1_T2;
   if((VT1T2_cnt>0) || ( maxEv_flg==0 ))   begin
      if( (VT1T2 < -60) && (VT1T2_retc!=-1))
      begin
        outfile=$fopen(errFileName,"a");
        $strobe("csf4a         VT1T2   leaving   OCA (  .. -60.000 V ) at %7.4r  %M", $abstime );
        $fwrite(outfile,"csf4a         VT1T2   leaving   OCA (  .. -60.000 V ) at %7.4r  %M\n", $abstime );
        VT1T2_retc=-1;
        VT1T2_cnt=VT1T2_cnt-1;
        $fclose(outfile);
      end
      if((VT1T2 >= -60) &&  (VT1T2 <= 60) && (VT1T2_retc!=0))
      begin
        outfile=$fopen(errFileName,"a");
        $strobe("csf4a         VT1T2   entering SOCA ( -60.000 V .. 60.000 V ) at %7.4r  %M", $abstime );
        $fwrite(outfile,"csf4a         VT1T2   entering SOCA ( -60.000 V .. 60.000 V ) at %7.4r  %M\n", $abstime );
        VT1T2_retc=0;
        VT1T2_cnt=VT1T2_cnt-1;
        $fclose(outfile);
      end
      if((VT1T2 > 60) &&  (VT1T2_retc!=1))
      begin
        outfile=$fopen(errFileName,"a");
        $strobe("csf4a         VT1T2   leaving   OCA ( 60.000 V ..  ) at %7.4r  %M", $abstime );
        $fwrite(outfile,"csf4a         VT1T2   leaving   OCA ( 60.000 V ..  ) at %7.4r  %M\n", $abstime );
        VT1T2_retc=1;
        VT1T2_cnt=VT1T2_cnt-1;
        $fclose(outfile);
      end
   end
   else
   begin
      if(VT1T2_cnt==0)
      begin
        outfile=$fopen(errFileName,"a");
        $strobe("csf4a         VT1T2   error limit ( %d ) reached at %7.4r  %M", maxEv, $abstime );
        $fwrite(outfile,"csf4a         VT1T2   error limit ( %d ) reached at %7.4r  %M\n", maxEv, $abstime );
        VT1T2_cnt=VT1T2_cnt-1;
        $fclose(outfile);
      end
   end

end // analog
endmodule // csf4a

// Verilog-A OC Watch for device csf5a Parameters  VT1 VT2 VT1T2
module csf5a_ahdl(T1,T2);
parameter tstep_occ=100n;
parameter errFileName="./occ.err";
parameter maxEv = 25;
parameter maxEv_flg = 0;
inout T1,T2;
electrical T1,T2;

integer outfile;
real V_T1_T2;
real V_T2;
real V_T1;
real VT1;
integer VT1_retc;
integer VT1_cnt;
real VT2;
integer VT2_retc;
integer VT2_cnt;
real VT1T2;
integer VT1T2_retc;
integer VT1T2_cnt;

analog begin
   $bound_step( tstep_occ );
   @(initial_step) begin
      VT1_retc=0;
      VT1_cnt = maxEv;
      VT2_retc=0;
      VT2_cnt = maxEv;
      VT1T2_retc=0;
      VT1T2_cnt = maxEv;
   end
   V_T1_T2 = V(T1,T2);
   V_T2 = V(T2);
   V_T1 = V(T1);

//      VT1
   VT1 = V_T1;
   if((VT1_cnt>0) || ( maxEv_flg==0 ))   begin
      if( (VT1 < -200) && (VT1_retc!=-1))
      begin
        outfile=$fopen(errFileName,"a");
        $strobe("csf5a         VT1     leaving   OCA (  .. -200.000 V ) at %7.4r  %M", $abstime );
        $fwrite(outfile,"csf5a         VT1     leaving   OCA (  .. -200.000 V ) at %7.4r  %M\n", $abstime );
        VT1_retc=-1;
        VT1_cnt=VT1_cnt-1;
        $fclose(outfile);
      end
      if((VT1 >= -200) &&  (VT1 <= 200) && (VT1_retc!=0))
      begin
        outfile=$fopen(errFileName,"a");
        $strobe("csf5a         VT1     entering SOCA ( -200.000 V .. 200.000 V ) at %7.4r  %M", $abstime );
        $fwrite(outfile,"csf5a         VT1     entering SOCA ( -200.000 V .. 200.000 V ) at %7.4r  %M\n", $abstime );
        VT1_retc=0;
        VT1_cnt=VT1_cnt-1;
        $fclose(outfile);
      end
      if((VT1 > 200) &&  (VT1_retc!=1))
      begin
        outfile=$fopen(errFileName,"a");
        $strobe("csf5a         VT1     leaving   OCA ( 200.000 V ..  ) at %7.4r  %M", $abstime );
        $fwrite(outfile,"csf5a         VT1     leaving   OCA ( 200.000 V ..  ) at %7.4r  %M\n", $abstime );
        VT1_retc=1;
        VT1_cnt=VT1_cnt-1;
        $fclose(outfile);
      end
   end
   else
   begin
      if(VT1_cnt==0)
      begin
        outfile=$fopen(errFileName,"a");
        $strobe("csf5a         VT1     error limit ( %d ) reached at %7.4r  %M", maxEv, $abstime );
        $fwrite(outfile,"csf5a         VT1     error limit ( %d ) reached at %7.4r  %M\n", maxEv, $abstime );
        VT1_cnt=VT1_cnt-1;
        $fclose(outfile);
      end
   end

//      VT2
   VT2 = V_T2;
   if((VT2_cnt>0) || ( maxEv_flg==0 ))   begin
      if( (VT2 < -200) && (VT2_retc!=-1))
      begin
        outfile=$fopen(errFileName,"a");
        $strobe("csf5a         VT2     leaving   OCA (  .. -200.000 V ) at %7.4r  %M", $abstime );
        $fwrite(outfile,"csf5a         VT2     leaving   OCA (  .. -200.000 V ) at %7.4r  %M\n", $abstime );
        VT2_retc=-1;
        VT2_cnt=VT2_cnt-1;
        $fclose(outfile);
      end
      if((VT2 >= -200) &&  (VT2 <= 200) && (VT2_retc!=0))
      begin
        outfile=$fopen(errFileName,"a");
        $strobe("csf5a         VT2     entering SOCA ( -200.000 V .. 200.000 V ) at %7.4r  %M", $abstime );
        $fwrite(outfile,"csf5a         VT2     entering SOCA ( -200.000 V .. 200.000 V ) at %7.4r  %M\n", $abstime );
        VT2_retc=0;
        VT2_cnt=VT2_cnt-1;
        $fclose(outfile);
      end
      if((VT2 > 200) &&  (VT2_retc!=1))
      begin
        outfile=$fopen(errFileName,"a");
        $strobe("csf5a         VT2     leaving   OCA ( 200.000 V ..  ) at %7.4r  %M", $abstime );
        $fwrite(outfile,"csf5a         VT2     leaving   OCA ( 200.000 V ..  ) at %7.4r  %M\n", $abstime );
        VT2_retc=1;
        VT2_cnt=VT2_cnt-1;
        $fclose(outfile);
      end
   end
   else
   begin
      if(VT2_cnt==0)
      begin
        outfile=$fopen(errFileName,"a");
        $strobe("csf5a         VT2     error limit ( %d ) reached at %7.4r  %M", maxEv, $abstime );
        $fwrite(outfile,"csf5a         VT2     error limit ( %d ) reached at %7.4r  %M\n", maxEv, $abstime );
        VT2_cnt=VT2_cnt-1;
        $fclose(outfile);
      end
   end

//      VT1T2
   VT1T2 = V_T1_T2;
   if((VT1T2_cnt>0) || ( maxEv_flg==0 ))   begin
      if( (VT1T2 < -60) && (VT1T2_retc!=-1))
      begin
        outfile=$fopen(errFileName,"a");
        $strobe("csf5a         VT1T2   leaving   OCA (  .. -60.000 V ) at %7.4r  %M", $abstime );
        $fwrite(outfile,"csf5a         VT1T2   leaving   OCA (  .. -60.000 V ) at %7.4r  %M\n", $abstime );
        VT1T2_retc=-1;
        VT1T2_cnt=VT1T2_cnt-1;
        $fclose(outfile);
      end
      if((VT1T2 >= -60) &&  (VT1T2 <= 60) && (VT1T2_retc!=0))
      begin
        outfile=$fopen(errFileName,"a");
        $strobe("csf5a         VT1T2   entering SOCA ( -60.000 V .. 60.000 V ) at %7.4r  %M", $abstime );
        $fwrite(outfile,"csf5a         VT1T2   entering SOCA ( -60.000 V .. 60.000 V ) at %7.4r  %M\n", $abstime );
        VT1T2_retc=0;
        VT1T2_cnt=VT1T2_cnt-1;
        $fclose(outfile);
      end
      if((VT1T2 > 60) &&  (VT1T2_retc!=1))
      begin
        outfile=$fopen(errFileName,"a");
        $strobe("csf5a         VT1T2   leaving   OCA ( 60.000 V ..  ) at %7.4r  %M", $abstime );
        $fwrite(outfile,"csf5a         VT1T2   leaving   OCA ( 60.000 V ..  ) at %7.4r  %M\n", $abstime );
        VT1T2_retc=1;
        VT1T2_cnt=VT1T2_cnt-1;
        $fclose(outfile);
      end
   end
   else
   begin
      if(VT1T2_cnt==0)
      begin
        outfile=$fopen(errFileName,"a");
        $strobe("csf5a         VT1T2   error limit ( %d ) reached at %7.4r  %M", maxEv, $abstime );
        $fwrite(outfile,"csf5a         VT1T2   error limit ( %d ) reached at %7.4r  %M\n", maxEv, $abstime );
        VT1T2_cnt=VT1T2_cnt-1;
        $fclose(outfile);
      end
   end

end // analog
endmodule // csf5a

// Verilog-A OC Watch for device csft4a Parameters  VT1 VT2 VT1T2
module csft4a_ahdl(T1,T2);
parameter tstep_occ=100n;
parameter errFileName="./occ.err";
parameter maxEv = 25;
parameter maxEv_flg = 0;
inout T1,T2;
electrical T1,T2;

integer outfile;
real V_T1_T2;
real V_T2;
real V_T1;
real VT1;
integer VT1_retc;
integer VT1_cnt;
real VT2;
integer VT2_retc;
integer VT2_cnt;
real VT1T2;
integer VT1T2_retc;
integer VT1T2_cnt;

analog begin
   $bound_step( tstep_occ );
   @(initial_step) begin
      VT1_retc=0;
      VT1_cnt = maxEv;
      VT2_retc=0;
      VT2_cnt = maxEv;
      VT1T2_retc=0;
      VT1T2_cnt = maxEv;
   end
   V_T1_T2 = V(T1,T2);
   V_T2 = V(T2);
   V_T1 = V(T1);

//      VT1
   VT1 = V_T1;
   if((VT1_cnt>0) || ( maxEv_flg==0 ))   begin
      if( (VT1 < -200) && (VT1_retc!=-1))
      begin
        outfile=$fopen(errFileName,"a");
        $strobe("csft4a        VT1     leaving   OCA (  .. -200.000 V ) at %7.4r  %M", $abstime );
        $fwrite(outfile,"csft4a        VT1     leaving   OCA (  .. -200.000 V ) at %7.4r  %M\n", $abstime );
        VT1_retc=-1;
        VT1_cnt=VT1_cnt-1;
        $fclose(outfile);
      end
      if((VT1 >= -200) &&  (VT1 <= 200) && (VT1_retc!=0))
      begin
        outfile=$fopen(errFileName,"a");
        $strobe("csft4a        VT1     entering SOCA ( -200.000 V .. 200.000 V ) at %7.4r  %M", $abstime );
        $fwrite(outfile,"csft4a        VT1     entering SOCA ( -200.000 V .. 200.000 V ) at %7.4r  %M\n", $abstime );
        VT1_retc=0;
        VT1_cnt=VT1_cnt-1;
        $fclose(outfile);
      end
      if((VT1 > 200) &&  (VT1_retc!=1))
      begin
        outfile=$fopen(errFileName,"a");
        $strobe("csft4a        VT1     leaving   OCA ( 200.000 V ..  ) at %7.4r  %M", $abstime );
        $fwrite(outfile,"csft4a        VT1     leaving   OCA ( 200.000 V ..  ) at %7.4r  %M\n", $abstime );
        VT1_retc=1;
        VT1_cnt=VT1_cnt-1;
        $fclose(outfile);
      end
   end
   else
   begin
      if(VT1_cnt==0)
      begin
        outfile=$fopen(errFileName,"a");
        $strobe("csft4a        VT1     error limit ( %d ) reached at %7.4r  %M", maxEv, $abstime );
        $fwrite(outfile,"csft4a        VT1     error limit ( %d ) reached at %7.4r  %M\n", maxEv, $abstime );
        VT1_cnt=VT1_cnt-1;
        $fclose(outfile);
      end
   end

//      VT2
   VT2 = V_T2;
   if((VT2_cnt>0) || ( maxEv_flg==0 ))   begin
      if( (VT2 < -200) && (VT2_retc!=-1))
      begin
        outfile=$fopen(errFileName,"a");
        $strobe("csft4a        VT2     leaving   OCA (  .. -200.000 V ) at %7.4r  %M", $abstime );
        $fwrite(outfile,"csft4a        VT2     leaving   OCA (  .. -200.000 V ) at %7.4r  %M\n", $abstime );
        VT2_retc=-1;
        VT2_cnt=VT2_cnt-1;
        $fclose(outfile);
      end
      if((VT2 >= -200) &&  (VT2 <= 200) && (VT2_retc!=0))
      begin
        outfile=$fopen(errFileName,"a");
        $strobe("csft4a        VT2     entering SOCA ( -200.000 V .. 200.000 V ) at %7.4r  %M", $abstime );
        $fwrite(outfile,"csft4a        VT2     entering SOCA ( -200.000 V .. 200.000 V ) at %7.4r  %M\n", $abstime );
        VT2_retc=0;
        VT2_cnt=VT2_cnt-1;
        $fclose(outfile);
      end
      if((VT2 > 200) &&  (VT2_retc!=1))
      begin
        outfile=$fopen(errFileName,"a");
        $strobe("csft4a        VT2     leaving   OCA ( 200.000 V ..  ) at %7.4r  %M", $abstime );
        $fwrite(outfile,"csft4a        VT2     leaving   OCA ( 200.000 V ..  ) at %7.4r  %M\n", $abstime );
        VT2_retc=1;
        VT2_cnt=VT2_cnt-1;
        $fclose(outfile);
      end
   end
   else
   begin
      if(VT2_cnt==0)
      begin
        outfile=$fopen(errFileName,"a");
        $strobe("csft4a        VT2     error limit ( %d ) reached at %7.4r  %M", maxEv, $abstime );
        $fwrite(outfile,"csft4a        VT2     error limit ( %d ) reached at %7.4r  %M\n", maxEv, $abstime );
        VT2_cnt=VT2_cnt-1;
        $fclose(outfile);
      end
   end

//      VT1T2
   VT1T2 = V_T1_T2;
   if((VT1T2_cnt>0) || ( maxEv_flg==0 ))   begin
      if( (VT1T2 < -60) && (VT1T2_retc!=-1))
      begin
        outfile=$fopen(errFileName,"a");
        $strobe("csft4a        VT1T2   leaving   OCA (  .. -60.000 V ) at %7.4r  %M", $abstime );
        $fwrite(outfile,"csft4a        VT1T2   leaving   OCA (  .. -60.000 V ) at %7.4r  %M\n", $abstime );
        VT1T2_retc=-1;
        VT1T2_cnt=VT1T2_cnt-1;
        $fclose(outfile);
      end
      if((VT1T2 >= -60) &&  (VT1T2 <= 60) && (VT1T2_retc!=0))
      begin
        outfile=$fopen(errFileName,"a");
        $strobe("csft4a        VT1T2   entering SOCA ( -60.000 V .. 60.000 V ) at %7.4r  %M", $abstime );
        $fwrite(outfile,"csft4a        VT1T2   entering SOCA ( -60.000 V .. 60.000 V ) at %7.4r  %M\n", $abstime );
        VT1T2_retc=0;
        VT1T2_cnt=VT1T2_cnt-1;
        $fclose(outfile);
      end
      if((VT1T2 > 60) &&  (VT1T2_retc!=1))
      begin
        outfile=$fopen(errFileName,"a");
        $strobe("csft4a        VT1T2   leaving   OCA ( 60.000 V ..  ) at %7.4r  %M", $abstime );
        $fwrite(outfile,"csft4a        VT1T2   leaving   OCA ( 60.000 V ..  ) at %7.4r  %M\n", $abstime );
        VT1T2_retc=1;
        VT1T2_cnt=VT1T2_cnt-1;
        $fclose(outfile);
      end
   end
   else
   begin
      if(VT1T2_cnt==0)
      begin
        outfile=$fopen(errFileName,"a");
        $strobe("csft4a        VT1T2   error limit ( %d ) reached at %7.4r  %M", maxEv, $abstime );
        $fwrite(outfile,"csft4a        VT1T2   error limit ( %d ) reached at %7.4r  %M\n", maxEv, $abstime );
        VT1T2_cnt=VT1T2_cnt-1;
        $fclose(outfile);
      end
   end

end // analog
endmodule // csft4a

// Verilog-A OC Watch for device csft5a Parameters  VT1 VT2 VT1T2
module csft5a_ahdl(T1,T2);
parameter tstep_occ=100n;
parameter errFileName="./occ.err";
parameter maxEv = 25;
parameter maxEv_flg = 0;
inout T1,T2;
electrical T1,T2;

integer outfile;
real V_T1_T2;
real V_T2;
real V_T1;
real VT1;
integer VT1_retc;
integer VT1_cnt;
real VT2;
integer VT2_retc;
integer VT2_cnt;
real VT1T2;
integer VT1T2_retc;
integer VT1T2_cnt;

analog begin
   $bound_step( tstep_occ );
   @(initial_step) begin
      VT1_retc=0;
      VT1_cnt = maxEv;
      VT2_retc=0;
      VT2_cnt = maxEv;
      VT1T2_retc=0;
      VT1T2_cnt = maxEv;
   end
   V_T1_T2 = V(T1,T2);
   V_T2 = V(T2);
   V_T1 = V(T1);

//      VT1
   VT1 = V_T1;
   if((VT1_cnt>0) || ( maxEv_flg==0 ))   begin
      if( (VT1 < -200) && (VT1_retc!=-1))
      begin
        outfile=$fopen(errFileName,"a");
        $strobe("csft5a        VT1     leaving   OCA (  .. -200.000 V ) at %7.4r  %M", $abstime );
        $fwrite(outfile,"csft5a        VT1     leaving   OCA (  .. -200.000 V ) at %7.4r  %M\n", $abstime );
        VT1_retc=-1;
        VT1_cnt=VT1_cnt-1;
        $fclose(outfile);
      end
      if((VT1 >= -200) &&  (VT1 <= 200) && (VT1_retc!=0))
      begin
        outfile=$fopen(errFileName,"a");
        $strobe("csft5a        VT1     entering SOCA ( -200.000 V .. 200.000 V ) at %7.4r  %M", $abstime );
        $fwrite(outfile,"csft5a        VT1     entering SOCA ( -200.000 V .. 200.000 V ) at %7.4r  %M\n", $abstime );
        VT1_retc=0;
        VT1_cnt=VT1_cnt-1;
        $fclose(outfile);
      end
      if((VT1 > 200) &&  (VT1_retc!=1))
      begin
        outfile=$fopen(errFileName,"a");
        $strobe("csft5a        VT1     leaving   OCA ( 200.000 V ..  ) at %7.4r  %M", $abstime );
        $fwrite(outfile,"csft5a        VT1     leaving   OCA ( 200.000 V ..  ) at %7.4r  %M\n", $abstime );
        VT1_retc=1;
        VT1_cnt=VT1_cnt-1;
        $fclose(outfile);
      end
   end
   else
   begin
      if(VT1_cnt==0)
      begin
        outfile=$fopen(errFileName,"a");
        $strobe("csft5a        VT1     error limit ( %d ) reached at %7.4r  %M", maxEv, $abstime );
        $fwrite(outfile,"csft5a        VT1     error limit ( %d ) reached at %7.4r  %M\n", maxEv, $abstime );
        VT1_cnt=VT1_cnt-1;
        $fclose(outfile);
      end
   end

//      VT2
   VT2 = V_T2;
   if((VT2_cnt>0) || ( maxEv_flg==0 ))   begin
      if( (VT2 < -200) && (VT2_retc!=-1))
      begin
        outfile=$fopen(errFileName,"a");
        $strobe("csft5a        VT2     leaving   OCA (  .. -200.000 V ) at %7.4r  %M", $abstime );
        $fwrite(outfile,"csft5a        VT2     leaving   OCA (  .. -200.000 V ) at %7.4r  %M\n", $abstime );
        VT2_retc=-1;
        VT2_cnt=VT2_cnt-1;
        $fclose(outfile);
      end
      if((VT2 >= -200) &&  (VT2 <= 200) && (VT2_retc!=0))
      begin
        outfile=$fopen(errFileName,"a");
        $strobe("csft5a        VT2     entering SOCA ( -200.000 V .. 200.000 V ) at %7.4r  %M", $abstime );
        $fwrite(outfile,"csft5a        VT2     entering SOCA ( -200.000 V .. 200.000 V ) at %7.4r  %M\n", $abstime );
        VT2_retc=0;
        VT2_cnt=VT2_cnt-1;
        $fclose(outfile);
      end
      if((VT2 > 200) &&  (VT2_retc!=1))
      begin
        outfile=$fopen(errFileName,"a");
        $strobe("csft5a        VT2     leaving   OCA ( 200.000 V ..  ) at %7.4r  %M", $abstime );
        $fwrite(outfile,"csft5a        VT2     leaving   OCA ( 200.000 V ..  ) at %7.4r  %M\n", $abstime );
        VT2_retc=1;
        VT2_cnt=VT2_cnt-1;
        $fclose(outfile);
      end
   end
   else
   begin
      if(VT2_cnt==0)
      begin
        outfile=$fopen(errFileName,"a");
        $strobe("csft5a        VT2     error limit ( %d ) reached at %7.4r  %M", maxEv, $abstime );
        $fwrite(outfile,"csft5a        VT2     error limit ( %d ) reached at %7.4r  %M\n", maxEv, $abstime );
        VT2_cnt=VT2_cnt-1;
        $fclose(outfile);
      end
   end

//      VT1T2
   VT1T2 = V_T1_T2;
   if((VT1T2_cnt>0) || ( maxEv_flg==0 ))   begin
      if( (VT1T2 < -60) && (VT1T2_retc!=-1))
      begin
        outfile=$fopen(errFileName,"a");
        $strobe("csft5a        VT1T2   leaving   OCA (  .. -60.000 V ) at %7.4r  %M", $abstime );
        $fwrite(outfile,"csft5a        VT1T2   leaving   OCA (  .. -60.000 V ) at %7.4r  %M\n", $abstime );
        VT1T2_retc=-1;
        VT1T2_cnt=VT1T2_cnt-1;
        $fclose(outfile);
      end
      if((VT1T2 >= -60) &&  (VT1T2 <= 60) && (VT1T2_retc!=0))
      begin
        outfile=$fopen(errFileName,"a");
        $strobe("csft5a        VT1T2   entering SOCA ( -60.000 V .. 60.000 V ) at %7.4r  %M", $abstime );
        $fwrite(outfile,"csft5a        VT1T2   entering SOCA ( -60.000 V .. 60.000 V ) at %7.4r  %M\n", $abstime );
        VT1T2_retc=0;
        VT1T2_cnt=VT1T2_cnt-1;
        $fclose(outfile);
      end
      if((VT1T2 > 60) &&  (VT1T2_retc!=1))
      begin
        outfile=$fopen(errFileName,"a");
        $strobe("csft5a        VT1T2   leaving   OCA ( 60.000 V ..  ) at %7.4r  %M", $abstime );
        $fwrite(outfile,"csft5a        VT1T2   leaving   OCA ( 60.000 V ..  ) at %7.4r  %M\n", $abstime );
        VT1T2_retc=1;
        VT1T2_cnt=VT1T2_cnt-1;
        $fclose(outfile);
      end
   end
   else
   begin
      if(VT1T2_cnt==0)
      begin
        outfile=$fopen(errFileName,"a");
        $strobe("csft5a        VT1T2   error limit ( %d ) reached at %7.4r  %M", maxEv, $abstime );
        $fwrite(outfile,"csft5a        VT1T2   error limit ( %d ) reached at %7.4r  %M\n", maxEv, $abstime );
        VT1T2_cnt=VT1T2_cnt-1;
        $fclose(outfile);
      end
   end

end // analog
endmodule // csft5a

// Verilog-A OC Watch for device csft6a Parameters  VT1 VT2 VT1T2
module csft6a_ahdl(T1,T2);
parameter tstep_occ=100n;
parameter errFileName="./occ.err";
parameter maxEv = 25;
parameter maxEv_flg = 0;
inout T1,T2;
electrical T1,T2;

integer outfile;
real V_T1_T2;
real V_T2;
real V_T1;
real VT1;
integer VT1_retc;
integer VT1_cnt;
real VT2;
integer VT2_retc;
integer VT2_cnt;
real VT1T2;
integer VT1T2_retc;
integer VT1T2_cnt;

analog begin
   $bound_step( tstep_occ );
   @(initial_step) begin
      VT1_retc=0;
      VT1_cnt = maxEv;
      VT2_retc=0;
      VT2_cnt = maxEv;
      VT1T2_retc=0;
      VT1T2_cnt = maxEv;
   end
   V_T1_T2 = V(T1,T2);
   V_T2 = V(T2);
   V_T1 = V(T1);

//      VT1
   VT1 = V_T1;
   if((VT1_cnt>0) || ( maxEv_flg==0 ))   begin
      if( (VT1 < -200) && (VT1_retc!=-1))
      begin
        outfile=$fopen(errFileName,"a");
        $strobe("csft6a        VT1     leaving   OCA (  .. -200.000 V ) at %7.4r  %M", $abstime );
        $fwrite(outfile,"csft6a        VT1     leaving   OCA (  .. -200.000 V ) at %7.4r  %M\n", $abstime );
        VT1_retc=-1;
        VT1_cnt=VT1_cnt-1;
        $fclose(outfile);
      end
      if((VT1 >= -200) &&  (VT1 <= 200) && (VT1_retc!=0))
      begin
        outfile=$fopen(errFileName,"a");
        $strobe("csft6a        VT1     entering SOCA ( -200.000 V .. 200.000 V ) at %7.4r  %M", $abstime );
        $fwrite(outfile,"csft6a        VT1     entering SOCA ( -200.000 V .. 200.000 V ) at %7.4r  %M\n", $abstime );
        VT1_retc=0;
        VT1_cnt=VT1_cnt-1;
        $fclose(outfile);
      end
      if((VT1 > 200) &&  (VT1_retc!=1))
      begin
        outfile=$fopen(errFileName,"a");
        $strobe("csft6a        VT1     leaving   OCA ( 200.000 V ..  ) at %7.4r  %M", $abstime );
        $fwrite(outfile,"csft6a        VT1     leaving   OCA ( 200.000 V ..  ) at %7.4r  %M\n", $abstime );
        VT1_retc=1;
        VT1_cnt=VT1_cnt-1;
        $fclose(outfile);
      end
   end
   else
   begin
      if(VT1_cnt==0)
      begin
        outfile=$fopen(errFileName,"a");
        $strobe("csft6a        VT1     error limit ( %d ) reached at %7.4r  %M", maxEv, $abstime );
        $fwrite(outfile,"csft6a        VT1     error limit ( %d ) reached at %7.4r  %M\n", maxEv, $abstime );
        VT1_cnt=VT1_cnt-1;
        $fclose(outfile);
      end
   end

//      VT2
   VT2 = V_T2;
   if((VT2_cnt>0) || ( maxEv_flg==0 ))   begin
      if( (VT2 < -200) && (VT2_retc!=-1))
      begin
        outfile=$fopen(errFileName,"a");
        $strobe("csft6a        VT2     leaving   OCA (  .. -200.000 V ) at %7.4r  %M", $abstime );
        $fwrite(outfile,"csft6a        VT2     leaving   OCA (  .. -200.000 V ) at %7.4r  %M\n", $abstime );
        VT2_retc=-1;
        VT2_cnt=VT2_cnt-1;
        $fclose(outfile);
      end
      if((VT2 >= -200) &&  (VT2 <= 200) && (VT2_retc!=0))
      begin
        outfile=$fopen(errFileName,"a");
        $strobe("csft6a        VT2     entering SOCA ( -200.000 V .. 200.000 V ) at %7.4r  %M", $abstime );
        $fwrite(outfile,"csft6a        VT2     entering SOCA ( -200.000 V .. 200.000 V ) at %7.4r  %M\n", $abstime );
        VT2_retc=0;
        VT2_cnt=VT2_cnt-1;
        $fclose(outfile);
      end
      if((VT2 > 200) &&  (VT2_retc!=1))
      begin
        outfile=$fopen(errFileName,"a");
        $strobe("csft6a        VT2     leaving   OCA ( 200.000 V ..  ) at %7.4r  %M", $abstime );
        $fwrite(outfile,"csft6a        VT2     leaving   OCA ( 200.000 V ..  ) at %7.4r  %M\n", $abstime );
        VT2_retc=1;
        VT2_cnt=VT2_cnt-1;
        $fclose(outfile);
      end
   end
   else
   begin
      if(VT2_cnt==0)
      begin
        outfile=$fopen(errFileName,"a");
        $strobe("csft6a        VT2     error limit ( %d ) reached at %7.4r  %M", maxEv, $abstime );
        $fwrite(outfile,"csft6a        VT2     error limit ( %d ) reached at %7.4r  %M\n", maxEv, $abstime );
        VT2_cnt=VT2_cnt-1;
        $fclose(outfile);
      end
   end

//      VT1T2
   VT1T2 = V_T1_T2;
   if((VT1T2_cnt>0) || ( maxEv_flg==0 ))   begin
      if( (VT1T2 < -60) && (VT1T2_retc!=-1))
      begin
        outfile=$fopen(errFileName,"a");
        $strobe("csft6a        VT1T2   leaving   OCA (  .. -60.000 V ) at %7.4r  %M", $abstime );
        $fwrite(outfile,"csft6a        VT1T2   leaving   OCA (  .. -60.000 V ) at %7.4r  %M\n", $abstime );
        VT1T2_retc=-1;
        VT1T2_cnt=VT1T2_cnt-1;
        $fclose(outfile);
      end
      if((VT1T2 >= -60) &&  (VT1T2 <= 60) && (VT1T2_retc!=0))
      begin
        outfile=$fopen(errFileName,"a");
        $strobe("csft6a        VT1T2   entering SOCA ( -60.000 V .. 60.000 V ) at %7.4r  %M", $abstime );
        $fwrite(outfile,"csft6a        VT1T2   entering SOCA ( -60.000 V .. 60.000 V ) at %7.4r  %M\n", $abstime );
        VT1T2_retc=0;
        VT1T2_cnt=VT1T2_cnt-1;
        $fclose(outfile);
      end
      if((VT1T2 > 60) &&  (VT1T2_retc!=1))
      begin
        outfile=$fopen(errFileName,"a");
        $strobe("csft6a        VT1T2   leaving   OCA ( 60.000 V ..  ) at %7.4r  %M", $abstime );
        $fwrite(outfile,"csft6a        VT1T2   leaving   OCA ( 60.000 V ..  ) at %7.4r  %M\n", $abstime );
        VT1T2_retc=1;
        VT1T2_cnt=VT1T2_cnt-1;
        $fclose(outfile);
      end
   end
   else
   begin
      if(VT1T2_cnt==0)
      begin
        outfile=$fopen(errFileName,"a");
        $strobe("csft6a        VT1T2   error limit ( %d ) reached at %7.4r  %M", maxEv, $abstime );
        $fwrite(outfile,"csft6a        VT1T2   error limit ( %d ) reached at %7.4r  %M\n", maxEv, $abstime );
        VT1T2_cnt=VT1T2_cnt-1;
        $fclose(outfile);
      end
   end

end // analog
endmodule // csft6a

// Verilog-A OC Watch for device cif3 Parameters  VT1 VT2 VT1T2
module cif3_ahdl(T1,T2);
parameter tstep_occ=100n;
parameter errFileName="./occ.err";
parameter maxEv = 25;
parameter maxEv_flg = 0;
inout T1,T2;
electrical T1,T2;

integer outfile;
real V_T1_T2;
real V_T2;
real V_T1;
real VT1;
integer VT1_retc;
integer VT1_cnt;
real VT2;
integer VT2_retc;
integer VT2_cnt;
real VT1T2;
integer VT1T2_retc;
integer VT1T2_cnt;

analog begin
   $bound_step( tstep_occ );
   @(initial_step) begin
      VT1_retc=0;
      VT1_cnt = maxEv;
      VT2_retc=0;
      VT2_cnt = maxEv;
      VT1T2_retc=0;
      VT1T2_cnt = maxEv;
   end
   V_T1_T2 = V(T1,T2);
   V_T2 = V(T2);
   V_T1 = V(T1);

//      VT1
   VT1 = V_T1;
   if((VT1_cnt>0) || ( maxEv_flg==0 ))   begin
      if( (VT1 < -200) && (VT1_retc!=-1))
      begin
        outfile=$fopen(errFileName,"a");
        $strobe("cif3          VT1     leaving   OCA (  .. -200.000 V ) at %7.4r  %M", $abstime );
        $fwrite(outfile,"cif3          VT1     leaving   OCA (  .. -200.000 V ) at %7.4r  %M\n", $abstime );
        VT1_retc=-1;
        VT1_cnt=VT1_cnt-1;
        $fclose(outfile);
      end
      if((VT1 >= -200) &&  (VT1 <= 200) && (VT1_retc!=0))
      begin
        outfile=$fopen(errFileName,"a");
        $strobe("cif3          VT1     entering SOCA ( -200.000 V .. 200.000 V ) at %7.4r  %M", $abstime );
        $fwrite(outfile,"cif3          VT1     entering SOCA ( -200.000 V .. 200.000 V ) at %7.4r  %M\n", $abstime );
        VT1_retc=0;
        VT1_cnt=VT1_cnt-1;
        $fclose(outfile);
      end
      if((VT1 > 200) &&  (VT1_retc!=1))
      begin
        outfile=$fopen(errFileName,"a");
        $strobe("cif3          VT1     leaving   OCA ( 200.000 V ..  ) at %7.4r  %M", $abstime );
        $fwrite(outfile,"cif3          VT1     leaving   OCA ( 200.000 V ..  ) at %7.4r  %M\n", $abstime );
        VT1_retc=1;
        VT1_cnt=VT1_cnt-1;
        $fclose(outfile);
      end
   end
   else
   begin
      if(VT1_cnt==0)
      begin
        outfile=$fopen(errFileName,"a");
        $strobe("cif3          VT1     error limit ( %d ) reached at %7.4r  %M", maxEv, $abstime );
        $fwrite(outfile,"cif3          VT1     error limit ( %d ) reached at %7.4r  %M\n", maxEv, $abstime );
        VT1_cnt=VT1_cnt-1;
        $fclose(outfile);
      end
   end

//      VT2
   VT2 = V_T2;
   if((VT2_cnt>0) || ( maxEv_flg==0 ))   begin
      if( (VT2 < -200) && (VT2_retc!=-1))
      begin
        outfile=$fopen(errFileName,"a");
        $strobe("cif3          VT2     leaving   OCA (  .. -200.000 V ) at %7.4r  %M", $abstime );
        $fwrite(outfile,"cif3          VT2     leaving   OCA (  .. -200.000 V ) at %7.4r  %M\n", $abstime );
        VT2_retc=-1;
        VT2_cnt=VT2_cnt-1;
        $fclose(outfile);
      end
      if((VT2 >= -200) &&  (VT2 <= 200) && (VT2_retc!=0))
      begin
        outfile=$fopen(errFileName,"a");
        $strobe("cif3          VT2     entering SOCA ( -200.000 V .. 200.000 V ) at %7.4r  %M", $abstime );
        $fwrite(outfile,"cif3          VT2     entering SOCA ( -200.000 V .. 200.000 V ) at %7.4r  %M\n", $abstime );
        VT2_retc=0;
        VT2_cnt=VT2_cnt-1;
        $fclose(outfile);
      end
      if((VT2 > 200) &&  (VT2_retc!=1))
      begin
        outfile=$fopen(errFileName,"a");
        $strobe("cif3          VT2     leaving   OCA ( 200.000 V ..  ) at %7.4r  %M", $abstime );
        $fwrite(outfile,"cif3          VT2     leaving   OCA ( 200.000 V ..  ) at %7.4r  %M\n", $abstime );
        VT2_retc=1;
        VT2_cnt=VT2_cnt-1;
        $fclose(outfile);
      end
   end
   else
   begin
      if(VT2_cnt==0)
      begin
        outfile=$fopen(errFileName,"a");
        $strobe("cif3          VT2     error limit ( %d ) reached at %7.4r  %M", maxEv, $abstime );
        $fwrite(outfile,"cif3          VT2     error limit ( %d ) reached at %7.4r  %M\n", maxEv, $abstime );
        VT2_cnt=VT2_cnt-1;
        $fclose(outfile);
      end
   end

//      VT1T2
   VT1T2 = V_T1_T2;
   if((VT1T2_cnt>0) || ( maxEv_flg==0 ))   begin
      if( (VT1T2 < -100) && (VT1T2_retc!=-1))
      begin
        outfile=$fopen(errFileName,"a");
        $strobe("cif3          VT1T2   leaving   OCA (  .. -100.000 V ) at %7.4r  %M", $abstime );
        $fwrite(outfile,"cif3          VT1T2   leaving   OCA (  .. -100.000 V ) at %7.4r  %M\n", $abstime );
        VT1T2_retc=-1;
        VT1T2_cnt=VT1T2_cnt-1;
        $fclose(outfile);
      end
      if((VT1T2 >= -100) &&  (VT1T2 <= 100) && (VT1T2_retc!=0))
      begin
        outfile=$fopen(errFileName,"a");
        $strobe("cif3          VT1T2   entering SOCA ( -100.000 V .. 100.000 V ) at %7.4r  %M", $abstime );
        $fwrite(outfile,"cif3          VT1T2   entering SOCA ( -100.000 V .. 100.000 V ) at %7.4r  %M\n", $abstime );
        VT1T2_retc=0;
        VT1T2_cnt=VT1T2_cnt-1;
        $fclose(outfile);
      end
      if((VT1T2 > 100) &&  (VT1T2_retc!=1))
      begin
        outfile=$fopen(errFileName,"a");
        $strobe("cif3          VT1T2   leaving   OCA ( 100.000 V ..  ) at %7.4r  %M", $abstime );
        $fwrite(outfile,"cif3          VT1T2   leaving   OCA ( 100.000 V ..  ) at %7.4r  %M\n", $abstime );
        VT1T2_retc=1;
        VT1T2_cnt=VT1T2_cnt-1;
        $fclose(outfile);
      end
   end
   else
   begin
      if(VT1T2_cnt==0)
      begin
        outfile=$fopen(errFileName,"a");
        $strobe("cif3          VT1T2   error limit ( %d ) reached at %7.4r  %M", maxEv, $abstime );
        $fwrite(outfile,"cif3          VT1T2   error limit ( %d ) reached at %7.4r  %M\n", maxEv, $abstime );
        VT1T2_cnt=VT1T2_cnt-1;
        $fclose(outfile);
      end
   end

end // analog
endmodule // cif3

// Verilog-A OC Watch for device cif4 Parameters  VT1 VT2 VT1T2
module cif4_ahdl(T1,T2);
parameter tstep_occ=100n;
parameter errFileName="./occ.err";
parameter maxEv = 25;
parameter maxEv_flg = 0;
inout T1,T2;
electrical T1,T2;

integer outfile;
real V_T1_T2;
real V_T2;
real V_T1;
real VT1;
integer VT1_retc;
integer VT1_cnt;
real VT2;
integer VT2_retc;
integer VT2_cnt;
real VT1T2;
integer VT1T2_retc;
integer VT1T2_cnt;

analog begin
   $bound_step( tstep_occ );
   @(initial_step) begin
      VT1_retc=0;
      VT1_cnt = maxEv;
      VT2_retc=0;
      VT2_cnt = maxEv;
      VT1T2_retc=0;
      VT1T2_cnt = maxEv;
   end
   V_T1_T2 = V(T1,T2);
   V_T2 = V(T2);
   V_T1 = V(T1);

//      VT1
   VT1 = V_T1;
   if((VT1_cnt>0) || ( maxEv_flg==0 ))   begin
      if( (VT1 < -200) && (VT1_retc!=-1))
      begin
        outfile=$fopen(errFileName,"a");
        $strobe("cif4          VT1     leaving   OCA (  .. -200.000 V ) at %7.4r  %M", $abstime );
        $fwrite(outfile,"cif4          VT1     leaving   OCA (  .. -200.000 V ) at %7.4r  %M\n", $abstime );
        VT1_retc=-1;
        VT1_cnt=VT1_cnt-1;
        $fclose(outfile);
      end
      if((VT1 >= -200) &&  (VT1 <= 200) && (VT1_retc!=0))
      begin
        outfile=$fopen(errFileName,"a");
        $strobe("cif4          VT1     entering SOCA ( -200.000 V .. 200.000 V ) at %7.4r  %M", $abstime );
        $fwrite(outfile,"cif4          VT1     entering SOCA ( -200.000 V .. 200.000 V ) at %7.4r  %M\n", $abstime );
        VT1_retc=0;
        VT1_cnt=VT1_cnt-1;
        $fclose(outfile);
      end
      if((VT1 > 200) &&  (VT1_retc!=1))
      begin
        outfile=$fopen(errFileName,"a");
        $strobe("cif4          VT1     leaving   OCA ( 200.000 V ..  ) at %7.4r  %M", $abstime );
        $fwrite(outfile,"cif4          VT1     leaving   OCA ( 200.000 V ..  ) at %7.4r  %M\n", $abstime );
        VT1_retc=1;
        VT1_cnt=VT1_cnt-1;
        $fclose(outfile);
      end
   end
   else
   begin
      if(VT1_cnt==0)
      begin
        outfile=$fopen(errFileName,"a");
        $strobe("cif4          VT1     error limit ( %d ) reached at %7.4r  %M", maxEv, $abstime );
        $fwrite(outfile,"cif4          VT1     error limit ( %d ) reached at %7.4r  %M\n", maxEv, $abstime );
        VT1_cnt=VT1_cnt-1;
        $fclose(outfile);
      end
   end

//      VT2
   VT2 = V_T2;
   if((VT2_cnt>0) || ( maxEv_flg==0 ))   begin
      if( (VT2 < -200) && (VT2_retc!=-1))
      begin
        outfile=$fopen(errFileName,"a");
        $strobe("cif4          VT2     leaving   OCA (  .. -200.000 V ) at %7.4r  %M", $abstime );
        $fwrite(outfile,"cif4          VT2     leaving   OCA (  .. -200.000 V ) at %7.4r  %M\n", $abstime );
        VT2_retc=-1;
        VT2_cnt=VT2_cnt-1;
        $fclose(outfile);
      end
      if((VT2 >= -200) &&  (VT2 <= 200) && (VT2_retc!=0))
      begin
        outfile=$fopen(errFileName,"a");
        $strobe("cif4          VT2     entering SOCA ( -200.000 V .. 200.000 V ) at %7.4r  %M", $abstime );
        $fwrite(outfile,"cif4          VT2     entering SOCA ( -200.000 V .. 200.000 V ) at %7.4r  %M\n", $abstime );
        VT2_retc=0;
        VT2_cnt=VT2_cnt-1;
        $fclose(outfile);
      end
      if((VT2 > 200) &&  (VT2_retc!=1))
      begin
        outfile=$fopen(errFileName,"a");
        $strobe("cif4          VT2     leaving   OCA ( 200.000 V ..  ) at %7.4r  %M", $abstime );
        $fwrite(outfile,"cif4          VT2     leaving   OCA ( 200.000 V ..  ) at %7.4r  %M\n", $abstime );
        VT2_retc=1;
        VT2_cnt=VT2_cnt-1;
        $fclose(outfile);
      end
   end
   else
   begin
      if(VT2_cnt==0)
      begin
        outfile=$fopen(errFileName,"a");
        $strobe("cif4          VT2     error limit ( %d ) reached at %7.4r  %M", maxEv, $abstime );
        $fwrite(outfile,"cif4          VT2     error limit ( %d ) reached at %7.4r  %M\n", maxEv, $abstime );
        VT2_cnt=VT2_cnt-1;
        $fclose(outfile);
      end
   end

//      VT1T2
   VT1T2 = V_T1_T2;
   if((VT1T2_cnt>0) || ( maxEv_flg==0 ))   begin
      if( (VT1T2 < -100) && (VT1T2_retc!=-1))
      begin
        outfile=$fopen(errFileName,"a");
        $strobe("cif4          VT1T2   leaving   OCA (  .. -100.000 V ) at %7.4r  %M", $abstime );
        $fwrite(outfile,"cif4          VT1T2   leaving   OCA (  .. -100.000 V ) at %7.4r  %M\n", $abstime );
        VT1T2_retc=-1;
        VT1T2_cnt=VT1T2_cnt-1;
        $fclose(outfile);
      end
      if((VT1T2 >= -100) &&  (VT1T2 <= 100) && (VT1T2_retc!=0))
      begin
        outfile=$fopen(errFileName,"a");
        $strobe("cif4          VT1T2   entering SOCA ( -100.000 V .. 100.000 V ) at %7.4r  %M", $abstime );
        $fwrite(outfile,"cif4          VT1T2   entering SOCA ( -100.000 V .. 100.000 V ) at %7.4r  %M\n", $abstime );
        VT1T2_retc=0;
        VT1T2_cnt=VT1T2_cnt-1;
        $fclose(outfile);
      end
      if((VT1T2 > 100) &&  (VT1T2_retc!=1))
      begin
        outfile=$fopen(errFileName,"a");
        $strobe("cif4          VT1T2   leaving   OCA ( 100.000 V ..  ) at %7.4r  %M", $abstime );
        $fwrite(outfile,"cif4          VT1T2   leaving   OCA ( 100.000 V ..  ) at %7.4r  %M\n", $abstime );
        VT1T2_retc=1;
        VT1T2_cnt=VT1T2_cnt-1;
        $fclose(outfile);
      end
   end
   else
   begin
      if(VT1T2_cnt==0)
      begin
        outfile=$fopen(errFileName,"a");
        $strobe("cif4          VT1T2   error limit ( %d ) reached at %7.4r  %M", maxEv, $abstime );
        $fwrite(outfile,"cif4          VT1T2   error limit ( %d ) reached at %7.4r  %M\n", maxEv, $abstime );
        VT1T2_cnt=VT1T2_cnt-1;
        $fclose(outfile);
      end
   end

end // analog
endmodule // cif4

// Verilog-A OC Watch for device cif5 Parameters  VT1 VT2 VT1T2
module cif5_ahdl(T1,T2);
parameter tstep_occ=100n;
parameter errFileName="./occ.err";
parameter maxEv = 25;
parameter maxEv_flg = 0;
inout T1,T2;
electrical T1,T2;

integer outfile;
real V_T1_T2;
real V_T2;
real V_T1;
real VT1;
integer VT1_retc;
integer VT1_cnt;
real VT2;
integer VT2_retc;
integer VT2_cnt;
real VT1T2;
integer VT1T2_retc;
integer VT1T2_cnt;

analog begin
   $bound_step( tstep_occ );
   @(initial_step) begin
      VT1_retc=0;
      VT1_cnt = maxEv;
      VT2_retc=0;
      VT2_cnt = maxEv;
      VT1T2_retc=0;
      VT1T2_cnt = maxEv;
   end
   V_T1_T2 = V(T1,T2);
   V_T2 = V(T2);
   V_T1 = V(T1);

//      VT1
   VT1 = V_T1;
   if((VT1_cnt>0) || ( maxEv_flg==0 ))   begin
      if( (VT1 < -200) && (VT1_retc!=-1))
      begin
        outfile=$fopen(errFileName,"a");
        $strobe("cif5          VT1     leaving   OCA (  .. -200.000 V ) at %7.4r  %M", $abstime );
        $fwrite(outfile,"cif5          VT1     leaving   OCA (  .. -200.000 V ) at %7.4r  %M\n", $abstime );
        VT1_retc=-1;
        VT1_cnt=VT1_cnt-1;
        $fclose(outfile);
      end
      if((VT1 >= -200) &&  (VT1 <= 200) && (VT1_retc!=0))
      begin
        outfile=$fopen(errFileName,"a");
        $strobe("cif5          VT1     entering SOCA ( -200.000 V .. 200.000 V ) at %7.4r  %M", $abstime );
        $fwrite(outfile,"cif5          VT1     entering SOCA ( -200.000 V .. 200.000 V ) at %7.4r  %M\n", $abstime );
        VT1_retc=0;
        VT1_cnt=VT1_cnt-1;
        $fclose(outfile);
      end
      if((VT1 > 200) &&  (VT1_retc!=1))
      begin
        outfile=$fopen(errFileName,"a");
        $strobe("cif5          VT1     leaving   OCA ( 200.000 V ..  ) at %7.4r  %M", $abstime );
        $fwrite(outfile,"cif5          VT1     leaving   OCA ( 200.000 V ..  ) at %7.4r  %M\n", $abstime );
        VT1_retc=1;
        VT1_cnt=VT1_cnt-1;
        $fclose(outfile);
      end
   end
   else
   begin
      if(VT1_cnt==0)
      begin
        outfile=$fopen(errFileName,"a");
        $strobe("cif5          VT1     error limit ( %d ) reached at %7.4r  %M", maxEv, $abstime );
        $fwrite(outfile,"cif5          VT1     error limit ( %d ) reached at %7.4r  %M\n", maxEv, $abstime );
        VT1_cnt=VT1_cnt-1;
        $fclose(outfile);
      end
   end

//      VT2
   VT2 = V_T2;
   if((VT2_cnt>0) || ( maxEv_flg==0 ))   begin
      if( (VT2 < -200) && (VT2_retc!=-1))
      begin
        outfile=$fopen(errFileName,"a");
        $strobe("cif5          VT2     leaving   OCA (  .. -200.000 V ) at %7.4r  %M", $abstime );
        $fwrite(outfile,"cif5          VT2     leaving   OCA (  .. -200.000 V ) at %7.4r  %M\n", $abstime );
        VT2_retc=-1;
        VT2_cnt=VT2_cnt-1;
        $fclose(outfile);
      end
      if((VT2 >= -200) &&  (VT2 <= 200) && (VT2_retc!=0))
      begin
        outfile=$fopen(errFileName,"a");
        $strobe("cif5          VT2     entering SOCA ( -200.000 V .. 200.000 V ) at %7.4r  %M", $abstime );
        $fwrite(outfile,"cif5          VT2     entering SOCA ( -200.000 V .. 200.000 V ) at %7.4r  %M\n", $abstime );
        VT2_retc=0;
        VT2_cnt=VT2_cnt-1;
        $fclose(outfile);
      end
      if((VT2 > 200) &&  (VT2_retc!=1))
      begin
        outfile=$fopen(errFileName,"a");
        $strobe("cif5          VT2     leaving   OCA ( 200.000 V ..  ) at %7.4r  %M", $abstime );
        $fwrite(outfile,"cif5          VT2     leaving   OCA ( 200.000 V ..  ) at %7.4r  %M\n", $abstime );
        VT2_retc=1;
        VT2_cnt=VT2_cnt-1;
        $fclose(outfile);
      end
   end
   else
   begin
      if(VT2_cnt==0)
      begin
        outfile=$fopen(errFileName,"a");
        $strobe("cif5          VT2     error limit ( %d ) reached at %7.4r  %M", maxEv, $abstime );
        $fwrite(outfile,"cif5          VT2     error limit ( %d ) reached at %7.4r  %M\n", maxEv, $abstime );
        VT2_cnt=VT2_cnt-1;
        $fclose(outfile);
      end
   end

//      VT1T2
   VT1T2 = V_T1_T2;
   if((VT1T2_cnt>0) || ( maxEv_flg==0 ))   begin
      if( (VT1T2 < -100) && (VT1T2_retc!=-1))
      begin
        outfile=$fopen(errFileName,"a");
        $strobe("cif5          VT1T2   leaving   OCA (  .. -100.000 V ) at %7.4r  %M", $abstime );
        $fwrite(outfile,"cif5          VT1T2   leaving   OCA (  .. -100.000 V ) at %7.4r  %M\n", $abstime );
        VT1T2_retc=-1;
        VT1T2_cnt=VT1T2_cnt-1;
        $fclose(outfile);
      end
      if((VT1T2 >= -100) &&  (VT1T2 <= 100) && (VT1T2_retc!=0))
      begin
        outfile=$fopen(errFileName,"a");
        $strobe("cif5          VT1T2   entering SOCA ( -100.000 V .. 100.000 V ) at %7.4r  %M", $abstime );
        $fwrite(outfile,"cif5          VT1T2   entering SOCA ( -100.000 V .. 100.000 V ) at %7.4r  %M\n", $abstime );
        VT1T2_retc=0;
        VT1T2_cnt=VT1T2_cnt-1;
        $fclose(outfile);
      end
      if((VT1T2 > 100) &&  (VT1T2_retc!=1))
      begin
        outfile=$fopen(errFileName,"a");
        $strobe("cif5          VT1T2   leaving   OCA ( 100.000 V ..  ) at %7.4r  %M", $abstime );
        $fwrite(outfile,"cif5          VT1T2   leaving   OCA ( 100.000 V ..  ) at %7.4r  %M\n", $abstime );
        VT1T2_retc=1;
        VT1T2_cnt=VT1T2_cnt-1;
        $fclose(outfile);
      end
   end
   else
   begin
      if(VT1T2_cnt==0)
      begin
        outfile=$fopen(errFileName,"a");
        $strobe("cif5          VT1T2   error limit ( %d ) reached at %7.4r  %M", maxEv, $abstime );
        $fwrite(outfile,"cif5          VT1T2   error limit ( %d ) reached at %7.4r  %M\n", maxEv, $abstime );
        VT1T2_cnt=VT1T2_cnt-1;
        $fclose(outfile);
      end
   end

end // analog
endmodule // cif5

// Verilog-A OC Watch for device cift4 Parameters  VT1 VT2 VT1T2
module cift4_ahdl(T1,T2);
parameter tstep_occ=100n;
parameter errFileName="./occ.err";
parameter maxEv = 25;
parameter maxEv_flg = 0;
inout T1,T2;
electrical T1,T2;

integer outfile;
real V_T1_T2;
real V_T2;
real V_T1;
real VT1;
integer VT1_retc;
integer VT1_cnt;
real VT2;
integer VT2_retc;
integer VT2_cnt;
real VT1T2;
integer VT1T2_retc;
integer VT1T2_cnt;

analog begin
   $bound_step( tstep_occ );
   @(initial_step) begin
      VT1_retc=0;
      VT1_cnt = maxEv;
      VT2_retc=0;
      VT2_cnt = maxEv;
      VT1T2_retc=0;
      VT1T2_cnt = maxEv;
   end
   V_T1_T2 = V(T1,T2);
   V_T2 = V(T2);
   V_T1 = V(T1);

//      VT1
   VT1 = V_T1;
   if((VT1_cnt>0) || ( maxEv_flg==0 ))   begin
      if( (VT1 < -200) && (VT1_retc!=-1))
      begin
        outfile=$fopen(errFileName,"a");
        $strobe("cift4         VT1     leaving   OCA (  .. -200.000 V ) at %7.4r  %M", $abstime );
        $fwrite(outfile,"cift4         VT1     leaving   OCA (  .. -200.000 V ) at %7.4r  %M\n", $abstime );
        VT1_retc=-1;
        VT1_cnt=VT1_cnt-1;
        $fclose(outfile);
      end
      if((VT1 >= -200) &&  (VT1 <= 200) && (VT1_retc!=0))
      begin
        outfile=$fopen(errFileName,"a");
        $strobe("cift4         VT1     entering SOCA ( -200.000 V .. 200.000 V ) at %7.4r  %M", $abstime );
        $fwrite(outfile,"cift4         VT1     entering SOCA ( -200.000 V .. 200.000 V ) at %7.4r  %M\n", $abstime );
        VT1_retc=0;
        VT1_cnt=VT1_cnt-1;
        $fclose(outfile);
      end
      if((VT1 > 200) &&  (VT1_retc!=1))
      begin
        outfile=$fopen(errFileName,"a");
        $strobe("cift4         VT1     leaving   OCA ( 200.000 V ..  ) at %7.4r  %M", $abstime );
        $fwrite(outfile,"cift4         VT1     leaving   OCA ( 200.000 V ..  ) at %7.4r  %M\n", $abstime );
        VT1_retc=1;
        VT1_cnt=VT1_cnt-1;
        $fclose(outfile);
      end
   end
   else
   begin
      if(VT1_cnt==0)
      begin
        outfile=$fopen(errFileName,"a");
        $strobe("cift4         VT1     error limit ( %d ) reached at %7.4r  %M", maxEv, $abstime );
        $fwrite(outfile,"cift4         VT1     error limit ( %d ) reached at %7.4r  %M\n", maxEv, $abstime );
        VT1_cnt=VT1_cnt-1;
        $fclose(outfile);
      end
   end

//      VT2
   VT2 = V_T2;
   if((VT2_cnt>0) || ( maxEv_flg==0 ))   begin
      if( (VT2 < -200) && (VT2_retc!=-1))
      begin
        outfile=$fopen(errFileName,"a");
        $strobe("cift4         VT2     leaving   OCA (  .. -200.000 V ) at %7.4r  %M", $abstime );
        $fwrite(outfile,"cift4         VT2     leaving   OCA (  .. -200.000 V ) at %7.4r  %M\n", $abstime );
        VT2_retc=-1;
        VT2_cnt=VT2_cnt-1;
        $fclose(outfile);
      end
      if((VT2 >= -200) &&  (VT2 <= 200) && (VT2_retc!=0))
      begin
        outfile=$fopen(errFileName,"a");
        $strobe("cift4         VT2     entering SOCA ( -200.000 V .. 200.000 V ) at %7.4r  %M", $abstime );
        $fwrite(outfile,"cift4         VT2     entering SOCA ( -200.000 V .. 200.000 V ) at %7.4r  %M\n", $abstime );
        VT2_retc=0;
        VT2_cnt=VT2_cnt-1;
        $fclose(outfile);
      end
      if((VT2 > 200) &&  (VT2_retc!=1))
      begin
        outfile=$fopen(errFileName,"a");
        $strobe("cift4         VT2     leaving   OCA ( 200.000 V ..  ) at %7.4r  %M", $abstime );
        $fwrite(outfile,"cift4         VT2     leaving   OCA ( 200.000 V ..  ) at %7.4r  %M\n", $abstime );
        VT2_retc=1;
        VT2_cnt=VT2_cnt-1;
        $fclose(outfile);
      end
   end
   else
   begin
      if(VT2_cnt==0)
      begin
        outfile=$fopen(errFileName,"a");
        $strobe("cift4         VT2     error limit ( %d ) reached at %7.4r  %M", maxEv, $abstime );
        $fwrite(outfile,"cift4         VT2     error limit ( %d ) reached at %7.4r  %M\n", maxEv, $abstime );
        VT2_cnt=VT2_cnt-1;
        $fclose(outfile);
      end
   end

//      VT1T2
   VT1T2 = V_T1_T2;
   if((VT1T2_cnt>0) || ( maxEv_flg==0 ))   begin
      if( (VT1T2 < -100) && (VT1T2_retc!=-1))
      begin
        outfile=$fopen(errFileName,"a");
        $strobe("cift4         VT1T2   leaving   OCA (  .. -100.000 V ) at %7.4r  %M", $abstime );
        $fwrite(outfile,"cift4         VT1T2   leaving   OCA (  .. -100.000 V ) at %7.4r  %M\n", $abstime );
        VT1T2_retc=-1;
        VT1T2_cnt=VT1T2_cnt-1;
        $fclose(outfile);
      end
      if((VT1T2 >= -100) &&  (VT1T2 <= 100) && (VT1T2_retc!=0))
      begin
        outfile=$fopen(errFileName,"a");
        $strobe("cift4         VT1T2   entering SOCA ( -100.000 V .. 100.000 V ) at %7.4r  %M", $abstime );
        $fwrite(outfile,"cift4         VT1T2   entering SOCA ( -100.000 V .. 100.000 V ) at %7.4r  %M\n", $abstime );
        VT1T2_retc=0;
        VT1T2_cnt=VT1T2_cnt-1;
        $fclose(outfile);
      end
      if((VT1T2 > 100) &&  (VT1T2_retc!=1))
      begin
        outfile=$fopen(errFileName,"a");
        $strobe("cift4         VT1T2   leaving   OCA ( 100.000 V ..  ) at %7.4r  %M", $abstime );
        $fwrite(outfile,"cift4         VT1T2   leaving   OCA ( 100.000 V ..  ) at %7.4r  %M\n", $abstime );
        VT1T2_retc=1;
        VT1T2_cnt=VT1T2_cnt-1;
        $fclose(outfile);
      end
   end
   else
   begin
      if(VT1T2_cnt==0)
      begin
        outfile=$fopen(errFileName,"a");
        $strobe("cift4         VT1T2   error limit ( %d ) reached at %7.4r  %M", maxEv, $abstime );
        $fwrite(outfile,"cift4         VT1T2   error limit ( %d ) reached at %7.4r  %M\n", maxEv, $abstime );
        VT1T2_cnt=VT1T2_cnt-1;
        $fclose(outfile);
      end
   end

end // analog
endmodule // cift4

// Verilog-A OC Watch for device cift5 Parameters  VT1 VT2 VT1T2
module cift5_ahdl(T1,T2);
parameter tstep_occ=100n;
parameter errFileName="./occ.err";
parameter maxEv = 25;
parameter maxEv_flg = 0;
inout T1,T2;
electrical T1,T2;

integer outfile;
real V_T1_T2;
real V_T2;
real V_T1;
real VT1;
integer VT1_retc;
integer VT1_cnt;
real VT2;
integer VT2_retc;
integer VT2_cnt;
real VT1T2;
integer VT1T2_retc;
integer VT1T2_cnt;

analog begin
   $bound_step( tstep_occ );
   @(initial_step) begin
      VT1_retc=0;
      VT1_cnt = maxEv;
      VT2_retc=0;
      VT2_cnt = maxEv;
      VT1T2_retc=0;
      VT1T2_cnt = maxEv;
   end
   V_T1_T2 = V(T1,T2);
   V_T2 = V(T2);
   V_T1 = V(T1);

//      VT1
   VT1 = V_T1;
   if((VT1_cnt>0) || ( maxEv_flg==0 ))   begin
      if( (VT1 < -200) && (VT1_retc!=-1))
      begin
        outfile=$fopen(errFileName,"a");
        $strobe("cift5         VT1     leaving   OCA (  .. -200.000 V ) at %7.4r  %M", $abstime );
        $fwrite(outfile,"cift5         VT1     leaving   OCA (  .. -200.000 V ) at %7.4r  %M\n", $abstime );
        VT1_retc=-1;
        VT1_cnt=VT1_cnt-1;
        $fclose(outfile);
      end
      if((VT1 >= -200) &&  (VT1 <= 200) && (VT1_retc!=0))
      begin
        outfile=$fopen(errFileName,"a");
        $strobe("cift5         VT1     entering SOCA ( -200.000 V .. 200.000 V ) at %7.4r  %M", $abstime );
        $fwrite(outfile,"cift5         VT1     entering SOCA ( -200.000 V .. 200.000 V ) at %7.4r  %M\n", $abstime );
        VT1_retc=0;
        VT1_cnt=VT1_cnt-1;
        $fclose(outfile);
      end
      if((VT1 > 200) &&  (VT1_retc!=1))
      begin
        outfile=$fopen(errFileName,"a");
        $strobe("cift5         VT1     leaving   OCA ( 200.000 V ..  ) at %7.4r  %M", $abstime );
        $fwrite(outfile,"cift5         VT1     leaving   OCA ( 200.000 V ..  ) at %7.4r  %M\n", $abstime );
        VT1_retc=1;
        VT1_cnt=VT1_cnt-1;
        $fclose(outfile);
      end
   end
   else
   begin
      if(VT1_cnt==0)
      begin
        outfile=$fopen(errFileName,"a");
        $strobe("cift5         VT1     error limit ( %d ) reached at %7.4r  %M", maxEv, $abstime );
        $fwrite(outfile,"cift5         VT1     error limit ( %d ) reached at %7.4r  %M\n", maxEv, $abstime );
        VT1_cnt=VT1_cnt-1;
        $fclose(outfile);
      end
   end

//      VT2
   VT2 = V_T2;
   if((VT2_cnt>0) || ( maxEv_flg==0 ))   begin
      if( (VT2 < -200) && (VT2_retc!=-1))
      begin
        outfile=$fopen(errFileName,"a");
        $strobe("cift5         VT2     leaving   OCA (  .. -200.000 V ) at %7.4r  %M", $abstime );
        $fwrite(outfile,"cift5         VT2     leaving   OCA (  .. -200.000 V ) at %7.4r  %M\n", $abstime );
        VT2_retc=-1;
        VT2_cnt=VT2_cnt-1;
        $fclose(outfile);
      end
      if((VT2 >= -200) &&  (VT2 <= 200) && (VT2_retc!=0))
      begin
        outfile=$fopen(errFileName,"a");
        $strobe("cift5         VT2     entering SOCA ( -200.000 V .. 200.000 V ) at %7.4r  %M", $abstime );
        $fwrite(outfile,"cift5         VT2     entering SOCA ( -200.000 V .. 200.000 V ) at %7.4r  %M\n", $abstime );
        VT2_retc=0;
        VT2_cnt=VT2_cnt-1;
        $fclose(outfile);
      end
      if((VT2 > 200) &&  (VT2_retc!=1))
      begin
        outfile=$fopen(errFileName,"a");
        $strobe("cift5         VT2     leaving   OCA ( 200.000 V ..  ) at %7.4r  %M", $abstime );
        $fwrite(outfile,"cift5         VT2     leaving   OCA ( 200.000 V ..  ) at %7.4r  %M\n", $abstime );
        VT2_retc=1;
        VT2_cnt=VT2_cnt-1;
        $fclose(outfile);
      end
   end
   else
   begin
      if(VT2_cnt==0)
      begin
        outfile=$fopen(errFileName,"a");
        $strobe("cift5         VT2     error limit ( %d ) reached at %7.4r  %M", maxEv, $abstime );
        $fwrite(outfile,"cift5         VT2     error limit ( %d ) reached at %7.4r  %M\n", maxEv, $abstime );
        VT2_cnt=VT2_cnt-1;
        $fclose(outfile);
      end
   end

//      VT1T2
   VT1T2 = V_T1_T2;
   if((VT1T2_cnt>0) || ( maxEv_flg==0 ))   begin
      if( (VT1T2 < -100) && (VT1T2_retc!=-1))
      begin
        outfile=$fopen(errFileName,"a");
        $strobe("cift5         VT1T2   leaving   OCA (  .. -100.000 V ) at %7.4r  %M", $abstime );
        $fwrite(outfile,"cift5         VT1T2   leaving   OCA (  .. -100.000 V ) at %7.4r  %M\n", $abstime );
        VT1T2_retc=-1;
        VT1T2_cnt=VT1T2_cnt-1;
        $fclose(outfile);
      end
      if((VT1T2 >= -100) &&  (VT1T2 <= 100) && (VT1T2_retc!=0))
      begin
        outfile=$fopen(errFileName,"a");
        $strobe("cift5         VT1T2   entering SOCA ( -100.000 V .. 100.000 V ) at %7.4r  %M", $abstime );
        $fwrite(outfile,"cift5         VT1T2   entering SOCA ( -100.000 V .. 100.000 V ) at %7.4r  %M\n", $abstime );
        VT1T2_retc=0;
        VT1T2_cnt=VT1T2_cnt-1;
        $fclose(outfile);
      end
      if((VT1T2 > 100) &&  (VT1T2_retc!=1))
      begin
        outfile=$fopen(errFileName,"a");
        $strobe("cift5         VT1T2   leaving   OCA ( 100.000 V ..  ) at %7.4r  %M", $abstime );
        $fwrite(outfile,"cift5         VT1T2   leaving   OCA ( 100.000 V ..  ) at %7.4r  %M\n", $abstime );
        VT1T2_retc=1;
        VT1T2_cnt=VT1T2_cnt-1;
        $fclose(outfile);
      end
   end
   else
   begin
      if(VT1T2_cnt==0)
      begin
        outfile=$fopen(errFileName,"a");
        $strobe("cift5         VT1T2   error limit ( %d ) reached at %7.4r  %M", maxEv, $abstime );
        $fwrite(outfile,"cift5         VT1T2   error limit ( %d ) reached at %7.4r  %M\n", maxEv, $abstime );
        VT1T2_cnt=VT1T2_cnt-1;
        $fclose(outfile);
      end
   end

end // analog
endmodule // cift5

// Verilog-A OC Watch for device cift6 Parameters  VT1 VT2 VT1T2
module cift6_ahdl(T1,T2);
parameter tstep_occ=100n;
parameter errFileName="./occ.err";
parameter maxEv = 25;
parameter maxEv_flg = 0;
inout T1,T2;
electrical T1,T2;

integer outfile;
real V_T1_T2;
real V_T2;
real V_T1;
real VT1;
integer VT1_retc;
integer VT1_cnt;
real VT2;
integer VT2_retc;
integer VT2_cnt;
real VT1T2;
integer VT1T2_retc;
integer VT1T2_cnt;

analog begin
   $bound_step( tstep_occ );
   @(initial_step) begin
      VT1_retc=0;
      VT1_cnt = maxEv;
      VT2_retc=0;
      VT2_cnt = maxEv;
      VT1T2_retc=0;
      VT1T2_cnt = maxEv;
   end
   V_T1_T2 = V(T1,T2);
   V_T2 = V(T2);
   V_T1 = V(T1);

//      VT1
   VT1 = V_T1;
   if((VT1_cnt>0) || ( maxEv_flg==0 ))   begin
      if( (VT1 < -200) && (VT1_retc!=-1))
      begin
        outfile=$fopen(errFileName,"a");
        $strobe("cift6         VT1     leaving   OCA (  .. -200.000 V ) at %7.4r  %M", $abstime );
        $fwrite(outfile,"cift6         VT1     leaving   OCA (  .. -200.000 V ) at %7.4r  %M\n", $abstime );
        VT1_retc=-1;
        VT1_cnt=VT1_cnt-1;
        $fclose(outfile);
      end
      if((VT1 >= -200) &&  (VT1 <= 200) && (VT1_retc!=0))
      begin
        outfile=$fopen(errFileName,"a");
        $strobe("cift6         VT1     entering SOCA ( -200.000 V .. 200.000 V ) at %7.4r  %M", $abstime );
        $fwrite(outfile,"cift6         VT1     entering SOCA ( -200.000 V .. 200.000 V ) at %7.4r  %M\n", $abstime );
        VT1_retc=0;
        VT1_cnt=VT1_cnt-1;
        $fclose(outfile);
      end
      if((VT1 > 200) &&  (VT1_retc!=1))
      begin
        outfile=$fopen(errFileName,"a");
        $strobe("cift6         VT1     leaving   OCA ( 200.000 V ..  ) at %7.4r  %M", $abstime );
        $fwrite(outfile,"cift6         VT1     leaving   OCA ( 200.000 V ..  ) at %7.4r  %M\n", $abstime );
        VT1_retc=1;
        VT1_cnt=VT1_cnt-1;
        $fclose(outfile);
      end
   end
   else
   begin
      if(VT1_cnt==0)
      begin
        outfile=$fopen(errFileName,"a");
        $strobe("cift6         VT1     error limit ( %d ) reached at %7.4r  %M", maxEv, $abstime );
        $fwrite(outfile,"cift6         VT1     error limit ( %d ) reached at %7.4r  %M\n", maxEv, $abstime );
        VT1_cnt=VT1_cnt-1;
        $fclose(outfile);
      end
   end

//      VT2
   VT2 = V_T2;
   if((VT2_cnt>0) || ( maxEv_flg==0 ))   begin
      if( (VT2 < -200) && (VT2_retc!=-1))
      begin
        outfile=$fopen(errFileName,"a");
        $strobe("cift6         VT2     leaving   OCA (  .. -200.000 V ) at %7.4r  %M", $abstime );
        $fwrite(outfile,"cift6         VT2     leaving   OCA (  .. -200.000 V ) at %7.4r  %M\n", $abstime );
        VT2_retc=-1;
        VT2_cnt=VT2_cnt-1;
        $fclose(outfile);
      end
      if((VT2 >= -200) &&  (VT2 <= 200) && (VT2_retc!=0))
      begin
        outfile=$fopen(errFileName,"a");
        $strobe("cift6         VT2     entering SOCA ( -200.000 V .. 200.000 V ) at %7.4r  %M", $abstime );
        $fwrite(outfile,"cift6         VT2     entering SOCA ( -200.000 V .. 200.000 V ) at %7.4r  %M\n", $abstime );
        VT2_retc=0;
        VT2_cnt=VT2_cnt-1;
        $fclose(outfile);
      end
      if((VT2 > 200) &&  (VT2_retc!=1))
      begin
        outfile=$fopen(errFileName,"a");
        $strobe("cift6         VT2     leaving   OCA ( 200.000 V ..  ) at %7.4r  %M", $abstime );
        $fwrite(outfile,"cift6         VT2     leaving   OCA ( 200.000 V ..  ) at %7.4r  %M\n", $abstime );
        VT2_retc=1;
        VT2_cnt=VT2_cnt-1;
        $fclose(outfile);
      end
   end
   else
   begin
      if(VT2_cnt==0)
      begin
        outfile=$fopen(errFileName,"a");
        $strobe("cift6         VT2     error limit ( %d ) reached at %7.4r  %M", maxEv, $abstime );
        $fwrite(outfile,"cift6         VT2     error limit ( %d ) reached at %7.4r  %M\n", maxEv, $abstime );
        VT2_cnt=VT2_cnt-1;
        $fclose(outfile);
      end
   end

//      VT1T2
   VT1T2 = V_T1_T2;
   if((VT1T2_cnt>0) || ( maxEv_flg==0 ))   begin
      if( (VT1T2 < -100) && (VT1T2_retc!=-1))
      begin
        outfile=$fopen(errFileName,"a");
        $strobe("cift6         VT1T2   leaving   OCA (  .. -100.000 V ) at %7.4r  %M", $abstime );
        $fwrite(outfile,"cift6         VT1T2   leaving   OCA (  .. -100.000 V ) at %7.4r  %M\n", $abstime );
        VT1T2_retc=-1;
        VT1T2_cnt=VT1T2_cnt-1;
        $fclose(outfile);
      end
      if((VT1T2 >= -100) &&  (VT1T2 <= 100) && (VT1T2_retc!=0))
      begin
        outfile=$fopen(errFileName,"a");
        $strobe("cift6         VT1T2   entering SOCA ( -100.000 V .. 100.000 V ) at %7.4r  %M", $abstime );
        $fwrite(outfile,"cift6         VT1T2   entering SOCA ( -100.000 V .. 100.000 V ) at %7.4r  %M\n", $abstime );
        VT1T2_retc=0;
        VT1T2_cnt=VT1T2_cnt-1;
        $fclose(outfile);
      end
      if((VT1T2 > 100) &&  (VT1T2_retc!=1))
      begin
        outfile=$fopen(errFileName,"a");
        $strobe("cift6         VT1T2   leaving   OCA ( 100.000 V ..  ) at %7.4r  %M", $abstime );
        $fwrite(outfile,"cift6         VT1T2   leaving   OCA ( 100.000 V ..  ) at %7.4r  %M\n", $abstime );
        VT1T2_retc=1;
        VT1T2_cnt=VT1T2_cnt-1;
        $fclose(outfile);
      end
   end
   else
   begin
      if(VT1T2_cnt==0)
      begin
        outfile=$fopen(errFileName,"a");
        $strobe("cift6         VT1T2   error limit ( %d ) reached at %7.4r  %M", maxEv, $abstime );
        $fwrite(outfile,"cift6         VT1T2   error limit ( %d ) reached at %7.4r  %M\n", maxEv, $abstime );
        VT1T2_cnt=VT1T2_cnt-1;
        $fclose(outfile);
      end
   end

end // analog
endmodule // cift6

// Verilog-A OC Watch for device cif3a Parameters  VT1 VT2 VT1T2
module cif3a_ahdl(T1,T2);
parameter tstep_occ=100n;
parameter errFileName="./occ.err";
parameter maxEv = 25;
parameter maxEv_flg = 0;
inout T1,T2;
electrical T1,T2;

integer outfile;
real V_T1_T2;
real V_T2;
real V_T1;
real VT1;
integer VT1_retc;
integer VT1_cnt;
real VT2;
integer VT2_retc;
integer VT2_cnt;
real VT1T2;
integer VT1T2_retc;
integer VT1T2_cnt;

analog begin
   $bound_step( tstep_occ );
   @(initial_step) begin
      VT1_retc=0;
      VT1_cnt = maxEv;
      VT2_retc=0;
      VT2_cnt = maxEv;
      VT1T2_retc=0;
      VT1T2_cnt = maxEv;
   end
   V_T1_T2 = V(T1,T2);
   V_T2 = V(T2);
   V_T1 = V(T1);

//      VT1
   VT1 = V_T1;
   if((VT1_cnt>0) || ( maxEv_flg==0 ))   begin
      if( (VT1 < -45) && (VT1_retc!=-1))
      begin
        outfile=$fopen(errFileName,"a");
        $strobe("cif3a         VT1     leaving   OCA (  .. -45.000 V ) at %7.4r  %M", $abstime );
        $fwrite(outfile,"cif3a         VT1     leaving   OCA (  .. -45.000 V ) at %7.4r  %M\n", $abstime );
        VT1_retc=-1;
        VT1_cnt=VT1_cnt-1;
        $fclose(outfile);
      end
      if((VT1 >= -45) &&  (VT1 <= 45) && (VT1_retc!=0))
      begin
        outfile=$fopen(errFileName,"a");
        $strobe("cif3a         VT1     entering SOCA ( -45.000 V .. 45.000 V ) at %7.4r  %M", $abstime );
        $fwrite(outfile,"cif3a         VT1     entering SOCA ( -45.000 V .. 45.000 V ) at %7.4r  %M\n", $abstime );
        VT1_retc=0;
        VT1_cnt=VT1_cnt-1;
        $fclose(outfile);
      end
      if((VT1 > 45) &&  (VT1_retc!=1))
      begin
        outfile=$fopen(errFileName,"a");
        $strobe("cif3a         VT1     leaving   OCA ( 45.000 V ..  ) at %7.4r  %M", $abstime );
        $fwrite(outfile,"cif3a         VT1     leaving   OCA ( 45.000 V ..  ) at %7.4r  %M\n", $abstime );
        VT1_retc=1;
        VT1_cnt=VT1_cnt-1;
        $fclose(outfile);
      end
   end
   else
   begin
      if(VT1_cnt==0)
      begin
        outfile=$fopen(errFileName,"a");
        $strobe("cif3a         VT1     error limit ( %d ) reached at %7.4r  %M", maxEv, $abstime );
        $fwrite(outfile,"cif3a         VT1     error limit ( %d ) reached at %7.4r  %M\n", maxEv, $abstime );
        VT1_cnt=VT1_cnt-1;
        $fclose(outfile);
      end
   end

//      VT2
   VT2 = V_T2;
   if((VT2_cnt>0) || ( maxEv_flg==0 ))   begin
      if( (VT2 < -45) && (VT2_retc!=-1))
      begin
        outfile=$fopen(errFileName,"a");
        $strobe("cif3a         VT2     leaving   OCA (  .. -45.000 V ) at %7.4r  %M", $abstime );
        $fwrite(outfile,"cif3a         VT2     leaving   OCA (  .. -45.000 V ) at %7.4r  %M\n", $abstime );
        VT2_retc=-1;
        VT2_cnt=VT2_cnt-1;
        $fclose(outfile);
      end
      if((VT2 >= -45) &&  (VT2 <= 45) && (VT2_retc!=0))
      begin
        outfile=$fopen(errFileName,"a");
        $strobe("cif3a         VT2     entering SOCA ( -45.000 V .. 45.000 V ) at %7.4r  %M", $abstime );
        $fwrite(outfile,"cif3a         VT2     entering SOCA ( -45.000 V .. 45.000 V ) at %7.4r  %M\n", $abstime );
        VT2_retc=0;
        VT2_cnt=VT2_cnt-1;
        $fclose(outfile);
      end
      if((VT2 > 45) &&  (VT2_retc!=1))
      begin
        outfile=$fopen(errFileName,"a");
        $strobe("cif3a         VT2     leaving   OCA ( 45.000 V ..  ) at %7.4r  %M", $abstime );
        $fwrite(outfile,"cif3a         VT2     leaving   OCA ( 45.000 V ..  ) at %7.4r  %M\n", $abstime );
        VT2_retc=1;
        VT2_cnt=VT2_cnt-1;
        $fclose(outfile);
      end
   end
   else
   begin
      if(VT2_cnt==0)
      begin
        outfile=$fopen(errFileName,"a");
        $strobe("cif3a         VT2     error limit ( %d ) reached at %7.4r  %M", maxEv, $abstime );
        $fwrite(outfile,"cif3a         VT2     error limit ( %d ) reached at %7.4r  %M\n", maxEv, $abstime );
        VT2_cnt=VT2_cnt-1;
        $fclose(outfile);
      end
   end

//      VT1T2
   VT1T2 = V_T1_T2;
   if((VT1T2_cnt>0) || ( maxEv_flg==0 ))   begin
      if( (VT1T2 < -30) && (VT1T2_retc!=-1))
      begin
        outfile=$fopen(errFileName,"a");
        $strobe("cif3a         VT1T2   leaving   OCA (  .. -30.000 V ) at %7.4r  %M", $abstime );
        $fwrite(outfile,"cif3a         VT1T2   leaving   OCA (  .. -30.000 V ) at %7.4r  %M\n", $abstime );
        VT1T2_retc=-1;
        VT1T2_cnt=VT1T2_cnt-1;
        $fclose(outfile);
      end
      if((VT1T2 >= -30) &&  (VT1T2 <= 30) && (VT1T2_retc!=0))
      begin
        outfile=$fopen(errFileName,"a");
        $strobe("cif3a         VT1T2   entering SOCA ( -30.000 V .. 30.000 V ) at %7.4r  %M", $abstime );
        $fwrite(outfile,"cif3a         VT1T2   entering SOCA ( -30.000 V .. 30.000 V ) at %7.4r  %M\n", $abstime );
        VT1T2_retc=0;
        VT1T2_cnt=VT1T2_cnt-1;
        $fclose(outfile);
      end
      if((VT1T2 > 30) &&  (VT1T2_retc!=1))
      begin
        outfile=$fopen(errFileName,"a");
        $strobe("cif3a         VT1T2   leaving   OCA ( 30.000 V ..  ) at %7.4r  %M", $abstime );
        $fwrite(outfile,"cif3a         VT1T2   leaving   OCA ( 30.000 V ..  ) at %7.4r  %M\n", $abstime );
        VT1T2_retc=1;
        VT1T2_cnt=VT1T2_cnt-1;
        $fclose(outfile);
      end
   end
   else
   begin
      if(VT1T2_cnt==0)
      begin
        outfile=$fopen(errFileName,"a");
        $strobe("cif3a         VT1T2   error limit ( %d ) reached at %7.4r  %M", maxEv, $abstime );
        $fwrite(outfile,"cif3a         VT1T2   error limit ( %d ) reached at %7.4r  %M\n", maxEv, $abstime );
        VT1T2_cnt=VT1T2_cnt-1;
        $fclose(outfile);
      end
   end

end // analog
endmodule // cif3a

// Verilog-A OC Watch for device cif4a Parameters  VT1 VT2 VT1T2
module cif4a_ahdl(T1,T2);
parameter tstep_occ=100n;
parameter errFileName="./occ.err";
parameter maxEv = 25;
parameter maxEv_flg = 0;
inout T1,T2;
electrical T1,T2;

integer outfile;
real V_T1_T2;
real V_T2;
real V_T1;
real VT1;
integer VT1_retc;
integer VT1_cnt;
real VT2;
integer VT2_retc;
integer VT2_cnt;
real VT1T2;
integer VT1T2_retc;
integer VT1T2_cnt;

analog begin
   $bound_step( tstep_occ );
   @(initial_step) begin
      VT1_retc=0;
      VT1_cnt = maxEv;
      VT2_retc=0;
      VT2_cnt = maxEv;
      VT1T2_retc=0;
      VT1T2_cnt = maxEv;
   end
   V_T1_T2 = V(T1,T2);
   V_T2 = V(T2);
   V_T1 = V(T1);

//      VT1
   VT1 = V_T1;
   if((VT1_cnt>0) || ( maxEv_flg==0 ))   begin
      if( (VT1 < -45) && (VT1_retc!=-1))
      begin
        outfile=$fopen(errFileName,"a");
        $strobe("cif4a         VT1     leaving   OCA (  .. -45.000 V ) at %7.4r  %M", $abstime );
        $fwrite(outfile,"cif4a         VT1     leaving   OCA (  .. -45.000 V ) at %7.4r  %M\n", $abstime );
        VT1_retc=-1;
        VT1_cnt=VT1_cnt-1;
        $fclose(outfile);
      end
      if((VT1 >= -45) &&  (VT1 <= 45) && (VT1_retc!=0))
      begin
        outfile=$fopen(errFileName,"a");
        $strobe("cif4a         VT1     entering SOCA ( -45.000 V .. 45.000 V ) at %7.4r  %M", $abstime );
        $fwrite(outfile,"cif4a         VT1     entering SOCA ( -45.000 V .. 45.000 V ) at %7.4r  %M\n", $abstime );
        VT1_retc=0;
        VT1_cnt=VT1_cnt-1;
        $fclose(outfile);
      end
      if((VT1 > 45) &&  (VT1_retc!=1))
      begin
        outfile=$fopen(errFileName,"a");
        $strobe("cif4a         VT1     leaving   OCA ( 45.000 V ..  ) at %7.4r  %M", $abstime );
        $fwrite(outfile,"cif4a         VT1     leaving   OCA ( 45.000 V ..  ) at %7.4r  %M\n", $abstime );
        VT1_retc=1;
        VT1_cnt=VT1_cnt-1;
        $fclose(outfile);
      end
   end
   else
   begin
      if(VT1_cnt==0)
      begin
        outfile=$fopen(errFileName,"a");
        $strobe("cif4a         VT1     error limit ( %d ) reached at %7.4r  %M", maxEv, $abstime );
        $fwrite(outfile,"cif4a         VT1     error limit ( %d ) reached at %7.4r  %M\n", maxEv, $abstime );
        VT1_cnt=VT1_cnt-1;
        $fclose(outfile);
      end
   end

//      VT2
   VT2 = V_T2;
   if((VT2_cnt>0) || ( maxEv_flg==0 ))   begin
      if( (VT2 < -45) && (VT2_retc!=-1))
      begin
        outfile=$fopen(errFileName,"a");
        $strobe("cif4a         VT2     leaving   OCA (  .. -45.000 V ) at %7.4r  %M", $abstime );
        $fwrite(outfile,"cif4a         VT2     leaving   OCA (  .. -45.000 V ) at %7.4r  %M\n", $abstime );
        VT2_retc=-1;
        VT2_cnt=VT2_cnt-1;
        $fclose(outfile);
      end
      if((VT2 >= -45) &&  (VT2 <= 45) && (VT2_retc!=0))
      begin
        outfile=$fopen(errFileName,"a");
        $strobe("cif4a         VT2     entering SOCA ( -45.000 V .. 45.000 V ) at %7.4r  %M", $abstime );
        $fwrite(outfile,"cif4a         VT2     entering SOCA ( -45.000 V .. 45.000 V ) at %7.4r  %M\n", $abstime );
        VT2_retc=0;
        VT2_cnt=VT2_cnt-1;
        $fclose(outfile);
      end
      if((VT2 > 45) &&  (VT2_retc!=1))
      begin
        outfile=$fopen(errFileName,"a");
        $strobe("cif4a         VT2     leaving   OCA ( 45.000 V ..  ) at %7.4r  %M", $abstime );
        $fwrite(outfile,"cif4a         VT2     leaving   OCA ( 45.000 V ..  ) at %7.4r  %M\n", $abstime );
        VT2_retc=1;
        VT2_cnt=VT2_cnt-1;
        $fclose(outfile);
      end
   end
   else
   begin
      if(VT2_cnt==0)
      begin
        outfile=$fopen(errFileName,"a");
        $strobe("cif4a         VT2     error limit ( %d ) reached at %7.4r  %M", maxEv, $abstime );
        $fwrite(outfile,"cif4a         VT2     error limit ( %d ) reached at %7.4r  %M\n", maxEv, $abstime );
        VT2_cnt=VT2_cnt-1;
        $fclose(outfile);
      end
   end

//      VT1T2
   VT1T2 = V_T1_T2;
   if((VT1T2_cnt>0) || ( maxEv_flg==0 ))   begin
      if( (VT1T2 < -30) && (VT1T2_retc!=-1))
      begin
        outfile=$fopen(errFileName,"a");
        $strobe("cif4a         VT1T2   leaving   OCA (  .. -30.000 V ) at %7.4r  %M", $abstime );
        $fwrite(outfile,"cif4a         VT1T2   leaving   OCA (  .. -30.000 V ) at %7.4r  %M\n", $abstime );
        VT1T2_retc=-1;
        VT1T2_cnt=VT1T2_cnt-1;
        $fclose(outfile);
      end
      if((VT1T2 >= -30) &&  (VT1T2 <= 30) && (VT1T2_retc!=0))
      begin
        outfile=$fopen(errFileName,"a");
        $strobe("cif4a         VT1T2   entering SOCA ( -30.000 V .. 30.000 V ) at %7.4r  %M", $abstime );
        $fwrite(outfile,"cif4a         VT1T2   entering SOCA ( -30.000 V .. 30.000 V ) at %7.4r  %M\n", $abstime );
        VT1T2_retc=0;
        VT1T2_cnt=VT1T2_cnt-1;
        $fclose(outfile);
      end
      if((VT1T2 > 30) &&  (VT1T2_retc!=1))
      begin
        outfile=$fopen(errFileName,"a");
        $strobe("cif4a         VT1T2   leaving   OCA ( 30.000 V ..  ) at %7.4r  %M", $abstime );
        $fwrite(outfile,"cif4a         VT1T2   leaving   OCA ( 30.000 V ..  ) at %7.4r  %M\n", $abstime );
        VT1T2_retc=1;
        VT1T2_cnt=VT1T2_cnt-1;
        $fclose(outfile);
      end
   end
   else
   begin
      if(VT1T2_cnt==0)
      begin
        outfile=$fopen(errFileName,"a");
        $strobe("cif4a         VT1T2   error limit ( %d ) reached at %7.4r  %M", maxEv, $abstime );
        $fwrite(outfile,"cif4a         VT1T2   error limit ( %d ) reached at %7.4r  %M\n", maxEv, $abstime );
        VT1T2_cnt=VT1T2_cnt-1;
        $fclose(outfile);
      end
   end

end // analog
endmodule // cif4a

// Verilog-A OC Watch for device cif5a Parameters  VT1 VT2 VT1T2
module cif5a_ahdl(T1,T2);
parameter tstep_occ=100n;
parameter errFileName="./occ.err";
parameter maxEv = 25;
parameter maxEv_flg = 0;
inout T1,T2;
electrical T1,T2;

integer outfile;
real V_T1_T2;
real V_T2;
real V_T1;
real VT1;
integer VT1_retc;
integer VT1_cnt;
real VT2;
integer VT2_retc;
integer VT2_cnt;
real VT1T2;
integer VT1T2_retc;
integer VT1T2_cnt;

analog begin
   $bound_step( tstep_occ );
   @(initial_step) begin
      VT1_retc=0;
      VT1_cnt = maxEv;
      VT2_retc=0;
      VT2_cnt = maxEv;
      VT1T2_retc=0;
      VT1T2_cnt = maxEv;
   end
   V_T1_T2 = V(T1,T2);
   V_T2 = V(T2);
   V_T1 = V(T1);

//      VT1
   VT1 = V_T1;
   if((VT1_cnt>0) || ( maxEv_flg==0 ))   begin
      if( (VT1 < -45) && (VT1_retc!=-1))
      begin
        outfile=$fopen(errFileName,"a");
        $strobe("cif5a         VT1     leaving   OCA (  .. -45.000 V ) at %7.4r  %M", $abstime );
        $fwrite(outfile,"cif5a         VT1     leaving   OCA (  .. -45.000 V ) at %7.4r  %M\n", $abstime );
        VT1_retc=-1;
        VT1_cnt=VT1_cnt-1;
        $fclose(outfile);
      end
      if((VT1 >= -45) &&  (VT1 <= 45) && (VT1_retc!=0))
      begin
        outfile=$fopen(errFileName,"a");
        $strobe("cif5a         VT1     entering SOCA ( -45.000 V .. 45.000 V ) at %7.4r  %M", $abstime );
        $fwrite(outfile,"cif5a         VT1     entering SOCA ( -45.000 V .. 45.000 V ) at %7.4r  %M\n", $abstime );
        VT1_retc=0;
        VT1_cnt=VT1_cnt-1;
        $fclose(outfile);
      end
      if((VT1 > 45) &&  (VT1_retc!=1))
      begin
        outfile=$fopen(errFileName,"a");
        $strobe("cif5a         VT1     leaving   OCA ( 45.000 V ..  ) at %7.4r  %M", $abstime );
        $fwrite(outfile,"cif5a         VT1     leaving   OCA ( 45.000 V ..  ) at %7.4r  %M\n", $abstime );
        VT1_retc=1;
        VT1_cnt=VT1_cnt-1;
        $fclose(outfile);
      end
   end
   else
   begin
      if(VT1_cnt==0)
      begin
        outfile=$fopen(errFileName,"a");
        $strobe("cif5a         VT1     error limit ( %d ) reached at %7.4r  %M", maxEv, $abstime );
        $fwrite(outfile,"cif5a         VT1     error limit ( %d ) reached at %7.4r  %M\n", maxEv, $abstime );
        VT1_cnt=VT1_cnt-1;
        $fclose(outfile);
      end
   end

//      VT2
   VT2 = V_T2;
   if((VT2_cnt>0) || ( maxEv_flg==0 ))   begin
      if( (VT2 < -45) && (VT2_retc!=-1))
      begin
        outfile=$fopen(errFileName,"a");
        $strobe("cif5a         VT2     leaving   OCA (  .. -45.000 V ) at %7.4r  %M", $abstime );
        $fwrite(outfile,"cif5a         VT2     leaving   OCA (  .. -45.000 V ) at %7.4r  %M\n", $abstime );
        VT2_retc=-1;
        VT2_cnt=VT2_cnt-1;
        $fclose(outfile);
      end
      if((VT2 >= -45) &&  (VT2 <= 45) && (VT2_retc!=0))
      begin
        outfile=$fopen(errFileName,"a");
        $strobe("cif5a         VT2     entering SOCA ( -45.000 V .. 45.000 V ) at %7.4r  %M", $abstime );
        $fwrite(outfile,"cif5a         VT2     entering SOCA ( -45.000 V .. 45.000 V ) at %7.4r  %M\n", $abstime );
        VT2_retc=0;
        VT2_cnt=VT2_cnt-1;
        $fclose(outfile);
      end
      if((VT2 > 45) &&  (VT2_retc!=1))
      begin
        outfile=$fopen(errFileName,"a");
        $strobe("cif5a         VT2     leaving   OCA ( 45.000 V ..  ) at %7.4r  %M", $abstime );
        $fwrite(outfile,"cif5a         VT2     leaving   OCA ( 45.000 V ..  ) at %7.4r  %M\n", $abstime );
        VT2_retc=1;
        VT2_cnt=VT2_cnt-1;
        $fclose(outfile);
      end
   end
   else
   begin
      if(VT2_cnt==0)
      begin
        outfile=$fopen(errFileName,"a");
        $strobe("cif5a         VT2     error limit ( %d ) reached at %7.4r  %M", maxEv, $abstime );
        $fwrite(outfile,"cif5a         VT2     error limit ( %d ) reached at %7.4r  %M\n", maxEv, $abstime );
        VT2_cnt=VT2_cnt-1;
        $fclose(outfile);
      end
   end

//      VT1T2
   VT1T2 = V_T1_T2;
   if((VT1T2_cnt>0) || ( maxEv_flg==0 ))   begin
      if( (VT1T2 < -30) && (VT1T2_retc!=-1))
      begin
        outfile=$fopen(errFileName,"a");
        $strobe("cif5a         VT1T2   leaving   OCA (  .. -30.000 V ) at %7.4r  %M", $abstime );
        $fwrite(outfile,"cif5a         VT1T2   leaving   OCA (  .. -30.000 V ) at %7.4r  %M\n", $abstime );
        VT1T2_retc=-1;
        VT1T2_cnt=VT1T2_cnt-1;
        $fclose(outfile);
      end
      if((VT1T2 >= -30) &&  (VT1T2 <= 30) && (VT1T2_retc!=0))
      begin
        outfile=$fopen(errFileName,"a");
        $strobe("cif5a         VT1T2   entering SOCA ( -30.000 V .. 30.000 V ) at %7.4r  %M", $abstime );
        $fwrite(outfile,"cif5a         VT1T2   entering SOCA ( -30.000 V .. 30.000 V ) at %7.4r  %M\n", $abstime );
        VT1T2_retc=0;
        VT1T2_cnt=VT1T2_cnt-1;
        $fclose(outfile);
      end
      if((VT1T2 > 30) &&  (VT1T2_retc!=1))
      begin
        outfile=$fopen(errFileName,"a");
        $strobe("cif5a         VT1T2   leaving   OCA ( 30.000 V ..  ) at %7.4r  %M", $abstime );
        $fwrite(outfile,"cif5a         VT1T2   leaving   OCA ( 30.000 V ..  ) at %7.4r  %M\n", $abstime );
        VT1T2_retc=1;
        VT1T2_cnt=VT1T2_cnt-1;
        $fclose(outfile);
      end
   end
   else
   begin
      if(VT1T2_cnt==0)
      begin
        outfile=$fopen(errFileName,"a");
        $strobe("cif5a         VT1T2   error limit ( %d ) reached at %7.4r  %M", maxEv, $abstime );
        $fwrite(outfile,"cif5a         VT1T2   error limit ( %d ) reached at %7.4r  %M\n", maxEv, $abstime );
        VT1T2_cnt=VT1T2_cnt-1;
        $fclose(outfile);
      end
   end

end // analog
endmodule // cif5a

// Verilog-A OC Watch for device cift4a Parameters  VT1 VT2 VT1T2
module cift4a_ahdl(T1,T2);
parameter tstep_occ=100n;
parameter errFileName="./occ.err";
parameter maxEv = 25;
parameter maxEv_flg = 0;
inout T1,T2;
electrical T1,T2;

integer outfile;
real V_T1_T2;
real V_T2;
real V_T1;
real VT1;
integer VT1_retc;
integer VT1_cnt;
real VT2;
integer VT2_retc;
integer VT2_cnt;
real VT1T2;
integer VT1T2_retc;
integer VT1T2_cnt;

analog begin
   $bound_step( tstep_occ );
   @(initial_step) begin
      VT1_retc=0;
      VT1_cnt = maxEv;
      VT2_retc=0;
      VT2_cnt = maxEv;
      VT1T2_retc=0;
      VT1T2_cnt = maxEv;
   end
   V_T1_T2 = V(T1,T2);
   V_T2 = V(T2);
   V_T1 = V(T1);

//      VT1
   VT1 = V_T1;
   if((VT1_cnt>0) || ( maxEv_flg==0 ))   begin
      if( (VT1 < -45) && (VT1_retc!=-1))
      begin
        outfile=$fopen(errFileName,"a");
        $strobe("cift4a        VT1     leaving   OCA (  .. -45.000 V ) at %7.4r  %M", $abstime );
        $fwrite(outfile,"cift4a        VT1     leaving   OCA (  .. -45.000 V ) at %7.4r  %M\n", $abstime );
        VT1_retc=-1;
        VT1_cnt=VT1_cnt-1;
        $fclose(outfile);
      end
      if((VT1 >= -45) &&  (VT1 <= 45) && (VT1_retc!=0))
      begin
        outfile=$fopen(errFileName,"a");
        $strobe("cift4a        VT1     entering SOCA ( -45.000 V .. 45.000 V ) at %7.4r  %M", $abstime );
        $fwrite(outfile,"cift4a        VT1     entering SOCA ( -45.000 V .. 45.000 V ) at %7.4r  %M\n", $abstime );
        VT1_retc=0;
        VT1_cnt=VT1_cnt-1;
        $fclose(outfile);
      end
      if((VT1 > 45) &&  (VT1_retc!=1))
      begin
        outfile=$fopen(errFileName,"a");
        $strobe("cift4a        VT1     leaving   OCA ( 45.000 V ..  ) at %7.4r  %M", $abstime );
        $fwrite(outfile,"cift4a        VT1     leaving   OCA ( 45.000 V ..  ) at %7.4r  %M\n", $abstime );
        VT1_retc=1;
        VT1_cnt=VT1_cnt-1;
        $fclose(outfile);
      end
   end
   else
   begin
      if(VT1_cnt==0)
      begin
        outfile=$fopen(errFileName,"a");
        $strobe("cift4a        VT1     error limit ( %d ) reached at %7.4r  %M", maxEv, $abstime );
        $fwrite(outfile,"cift4a        VT1     error limit ( %d ) reached at %7.4r  %M\n", maxEv, $abstime );
        VT1_cnt=VT1_cnt-1;
        $fclose(outfile);
      end
   end

//      VT2
   VT2 = V_T2;
   if((VT2_cnt>0) || ( maxEv_flg==0 ))   begin
      if( (VT2 < -45) && (VT2_retc!=-1))
      begin
        outfile=$fopen(errFileName,"a");
        $strobe("cift4a        VT2     leaving   OCA (  .. -45.000 V ) at %7.4r  %M", $abstime );
        $fwrite(outfile,"cift4a        VT2     leaving   OCA (  .. -45.000 V ) at %7.4r  %M\n", $abstime );
        VT2_retc=-1;
        VT2_cnt=VT2_cnt-1;
        $fclose(outfile);
      end
      if((VT2 >= -45) &&  (VT2 <= 45) && (VT2_retc!=0))
      begin
        outfile=$fopen(errFileName,"a");
        $strobe("cift4a        VT2     entering SOCA ( -45.000 V .. 45.000 V ) at %7.4r  %M", $abstime );
        $fwrite(outfile,"cift4a        VT2     entering SOCA ( -45.000 V .. 45.000 V ) at %7.4r  %M\n", $abstime );
        VT2_retc=0;
        VT2_cnt=VT2_cnt-1;
        $fclose(outfile);
      end
      if((VT2 > 45) &&  (VT2_retc!=1))
      begin
        outfile=$fopen(errFileName,"a");
        $strobe("cift4a        VT2     leaving   OCA ( 45.000 V ..  ) at %7.4r  %M", $abstime );
        $fwrite(outfile,"cift4a        VT2     leaving   OCA ( 45.000 V ..  ) at %7.4r  %M\n", $abstime );
        VT2_retc=1;
        VT2_cnt=VT2_cnt-1;
        $fclose(outfile);
      end
   end
   else
   begin
      if(VT2_cnt==0)
      begin
        outfile=$fopen(errFileName,"a");
        $strobe("cift4a        VT2     error limit ( %d ) reached at %7.4r  %M", maxEv, $abstime );
        $fwrite(outfile,"cift4a        VT2     error limit ( %d ) reached at %7.4r  %M\n", maxEv, $abstime );
        VT2_cnt=VT2_cnt-1;
        $fclose(outfile);
      end
   end

//      VT1T2
   VT1T2 = V_T1_T2;
   if((VT1T2_cnt>0) || ( maxEv_flg==0 ))   begin
      if( (VT1T2 < -30) && (VT1T2_retc!=-1))
      begin
        outfile=$fopen(errFileName,"a");
        $strobe("cift4a        VT1T2   leaving   OCA (  .. -30.000 V ) at %7.4r  %M", $abstime );
        $fwrite(outfile,"cift4a        VT1T2   leaving   OCA (  .. -30.000 V ) at %7.4r  %M\n", $abstime );
        VT1T2_retc=-1;
        VT1T2_cnt=VT1T2_cnt-1;
        $fclose(outfile);
      end
      if((VT1T2 >= -30) &&  (VT1T2 <= 30) && (VT1T2_retc!=0))
      begin
        outfile=$fopen(errFileName,"a");
        $strobe("cift4a        VT1T2   entering SOCA ( -30.000 V .. 30.000 V ) at %7.4r  %M", $abstime );
        $fwrite(outfile,"cift4a        VT1T2   entering SOCA ( -30.000 V .. 30.000 V ) at %7.4r  %M\n", $abstime );
        VT1T2_retc=0;
        VT1T2_cnt=VT1T2_cnt-1;
        $fclose(outfile);
      end
      if((VT1T2 > 30) &&  (VT1T2_retc!=1))
      begin
        outfile=$fopen(errFileName,"a");
        $strobe("cift4a        VT1T2   leaving   OCA ( 30.000 V ..  ) at %7.4r  %M", $abstime );
        $fwrite(outfile,"cift4a        VT1T2   leaving   OCA ( 30.000 V ..  ) at %7.4r  %M\n", $abstime );
        VT1T2_retc=1;
        VT1T2_cnt=VT1T2_cnt-1;
        $fclose(outfile);
      end
   end
   else
   begin
      if(VT1T2_cnt==0)
      begin
        outfile=$fopen(errFileName,"a");
        $strobe("cift4a        VT1T2   error limit ( %d ) reached at %7.4r  %M", maxEv, $abstime );
        $fwrite(outfile,"cift4a        VT1T2   error limit ( %d ) reached at %7.4r  %M\n", maxEv, $abstime );
        VT1T2_cnt=VT1T2_cnt-1;
        $fclose(outfile);
      end
   end

end // analog
endmodule // cift4a

// Verilog-A OC Watch for device cift5a Parameters  VT1 VT2 VT1T2
module cift5a_ahdl(T1,T2);
parameter tstep_occ=100n;
parameter errFileName="./occ.err";
parameter maxEv = 25;
parameter maxEv_flg = 0;
inout T1,T2;
electrical T1,T2;

integer outfile;
real V_T1_T2;
real V_T2;
real V_T1;
real VT1;
integer VT1_retc;
integer VT1_cnt;
real VT2;
integer VT2_retc;
integer VT2_cnt;
real VT1T2;
integer VT1T2_retc;
integer VT1T2_cnt;

analog begin
   $bound_step( tstep_occ );
   @(initial_step) begin
      VT1_retc=0;
      VT1_cnt = maxEv;
      VT2_retc=0;
      VT2_cnt = maxEv;
      VT1T2_retc=0;
      VT1T2_cnt = maxEv;
   end
   V_T1_T2 = V(T1,T2);
   V_T2 = V(T2);
   V_T1 = V(T1);

//      VT1
   VT1 = V_T1;
   if((VT1_cnt>0) || ( maxEv_flg==0 ))   begin
      if( (VT1 < -45) && (VT1_retc!=-1))
      begin
        outfile=$fopen(errFileName,"a");
        $strobe("cift5a        VT1     leaving   OCA (  .. -45.000 V ) at %7.4r  %M", $abstime );
        $fwrite(outfile,"cift5a        VT1     leaving   OCA (  .. -45.000 V ) at %7.4r  %M\n", $abstime );
        VT1_retc=-1;
        VT1_cnt=VT1_cnt-1;
        $fclose(outfile);
      end
      if((VT1 >= -45) &&  (VT1 <= 45) && (VT1_retc!=0))
      begin
        outfile=$fopen(errFileName,"a");
        $strobe("cift5a        VT1     entering SOCA ( -45.000 V .. 45.000 V ) at %7.4r  %M", $abstime );
        $fwrite(outfile,"cift5a        VT1     entering SOCA ( -45.000 V .. 45.000 V ) at %7.4r  %M\n", $abstime );
        VT1_retc=0;
        VT1_cnt=VT1_cnt-1;
        $fclose(outfile);
      end
      if((VT1 > 45) &&  (VT1_retc!=1))
      begin
        outfile=$fopen(errFileName,"a");
        $strobe("cift5a        VT1     leaving   OCA ( 45.000 V ..  ) at %7.4r  %M", $abstime );
        $fwrite(outfile,"cift5a        VT1     leaving   OCA ( 45.000 V ..  ) at %7.4r  %M\n", $abstime );
        VT1_retc=1;
        VT1_cnt=VT1_cnt-1;
        $fclose(outfile);
      end
   end
   else
   begin
      if(VT1_cnt==0)
      begin
        outfile=$fopen(errFileName,"a");
        $strobe("cift5a        VT1     error limit ( %d ) reached at %7.4r  %M", maxEv, $abstime );
        $fwrite(outfile,"cift5a        VT1     error limit ( %d ) reached at %7.4r  %M\n", maxEv, $abstime );
        VT1_cnt=VT1_cnt-1;
        $fclose(outfile);
      end
   end

//      VT2
   VT2 = V_T2;
   if((VT2_cnt>0) || ( maxEv_flg==0 ))   begin
      if( (VT2 < -45) && (VT2_retc!=-1))
      begin
        outfile=$fopen(errFileName,"a");
        $strobe("cift5a        VT2     leaving   OCA (  .. -45.000 V ) at %7.4r  %M", $abstime );
        $fwrite(outfile,"cift5a        VT2     leaving   OCA (  .. -45.000 V ) at %7.4r  %M\n", $abstime );
        VT2_retc=-1;
        VT2_cnt=VT2_cnt-1;
        $fclose(outfile);
      end
      if((VT2 >= -45) &&  (VT2 <= 45) && (VT2_retc!=0))
      begin
        outfile=$fopen(errFileName,"a");
        $strobe("cift5a        VT2     entering SOCA ( -45.000 V .. 45.000 V ) at %7.4r  %M", $abstime );
        $fwrite(outfile,"cift5a        VT2     entering SOCA ( -45.000 V .. 45.000 V ) at %7.4r  %M\n", $abstime );
        VT2_retc=0;
        VT2_cnt=VT2_cnt-1;
        $fclose(outfile);
      end
      if((VT2 > 45) &&  (VT2_retc!=1))
      begin
        outfile=$fopen(errFileName,"a");
        $strobe("cift5a        VT2     leaving   OCA ( 45.000 V ..  ) at %7.4r  %M", $abstime );
        $fwrite(outfile,"cift5a        VT2     leaving   OCA ( 45.000 V ..  ) at %7.4r  %M\n", $abstime );
        VT2_retc=1;
        VT2_cnt=VT2_cnt-1;
        $fclose(outfile);
      end
   end
   else
   begin
      if(VT2_cnt==0)
      begin
        outfile=$fopen(errFileName,"a");
        $strobe("cift5a        VT2     error limit ( %d ) reached at %7.4r  %M", maxEv, $abstime );
        $fwrite(outfile,"cift5a        VT2     error limit ( %d ) reached at %7.4r  %M\n", maxEv, $abstime );
        VT2_cnt=VT2_cnt-1;
        $fclose(outfile);
      end
   end

//      VT1T2
   VT1T2 = V_T1_T2;
   if((VT1T2_cnt>0) || ( maxEv_flg==0 ))   begin
      if( (VT1T2 < -30) && (VT1T2_retc!=-1))
      begin
        outfile=$fopen(errFileName,"a");
        $strobe("cift5a        VT1T2   leaving   OCA (  .. -30.000 V ) at %7.4r  %M", $abstime );
        $fwrite(outfile,"cift5a        VT1T2   leaving   OCA (  .. -30.000 V ) at %7.4r  %M\n", $abstime );
        VT1T2_retc=-1;
        VT1T2_cnt=VT1T2_cnt-1;
        $fclose(outfile);
      end
      if((VT1T2 >= -30) &&  (VT1T2 <= 30) && (VT1T2_retc!=0))
      begin
        outfile=$fopen(errFileName,"a");
        $strobe("cift5a        VT1T2   entering SOCA ( -30.000 V .. 30.000 V ) at %7.4r  %M", $abstime );
        $fwrite(outfile,"cift5a        VT1T2   entering SOCA ( -30.000 V .. 30.000 V ) at %7.4r  %M\n", $abstime );
        VT1T2_retc=0;
        VT1T2_cnt=VT1T2_cnt-1;
        $fclose(outfile);
      end
      if((VT1T2 > 30) &&  (VT1T2_retc!=1))
      begin
        outfile=$fopen(errFileName,"a");
        $strobe("cift5a        VT1T2   leaving   OCA ( 30.000 V ..  ) at %7.4r  %M", $abstime );
        $fwrite(outfile,"cift5a        VT1T2   leaving   OCA ( 30.000 V ..  ) at %7.4r  %M\n", $abstime );
        VT1T2_retc=1;
        VT1T2_cnt=VT1T2_cnt-1;
        $fclose(outfile);
      end
   end
   else
   begin
      if(VT1T2_cnt==0)
      begin
        outfile=$fopen(errFileName,"a");
        $strobe("cift5a        VT1T2   error limit ( %d ) reached at %7.4r  %M", maxEv, $abstime );
        $fwrite(outfile,"cift5a        VT1T2   error limit ( %d ) reached at %7.4r  %M\n", maxEv, $abstime );
        VT1T2_cnt=VT1T2_cnt-1;
        $fclose(outfile);
      end
   end

end // analog
endmodule // cift5a

// Verilog-A OC Watch for device cift6a Parameters  VT1 VT2 VT1T2
module cift6a_ahdl(T1,T2);
parameter tstep_occ=100n;
parameter errFileName="./occ.err";
parameter maxEv = 25;
parameter maxEv_flg = 0;
inout T1,T2;
electrical T1,T2;

integer outfile;
real V_T1_T2;
real V_T2;
real V_T1;
real VT1;
integer VT1_retc;
integer VT1_cnt;
real VT2;
integer VT2_retc;
integer VT2_cnt;
real VT1T2;
integer VT1T2_retc;
integer VT1T2_cnt;

analog begin
   $bound_step( tstep_occ );
   @(initial_step) begin
      VT1_retc=0;
      VT1_cnt = maxEv;
      VT2_retc=0;
      VT2_cnt = maxEv;
      VT1T2_retc=0;
      VT1T2_cnt = maxEv;
   end
   V_T1_T2 = V(T1,T2);
   V_T2 = V(T2);
   V_T1 = V(T1);

//      VT1
   VT1 = V_T1;
   if((VT1_cnt>0) || ( maxEv_flg==0 ))   begin
      if( (VT1 < -45) && (VT1_retc!=-1))
      begin
        outfile=$fopen(errFileName,"a");
        $strobe("cift6a        VT1     leaving   OCA (  .. -45.000 V ) at %7.4r  %M", $abstime );
        $fwrite(outfile,"cift6a        VT1     leaving   OCA (  .. -45.000 V ) at %7.4r  %M\n", $abstime );
        VT1_retc=-1;
        VT1_cnt=VT1_cnt-1;
        $fclose(outfile);
      end
      if((VT1 >= -45) &&  (VT1 <= 45) && (VT1_retc!=0))
      begin
        outfile=$fopen(errFileName,"a");
        $strobe("cift6a        VT1     entering SOCA ( -45.000 V .. 45.000 V ) at %7.4r  %M", $abstime );
        $fwrite(outfile,"cift6a        VT1     entering SOCA ( -45.000 V .. 45.000 V ) at %7.4r  %M\n", $abstime );
        VT1_retc=0;
        VT1_cnt=VT1_cnt-1;
        $fclose(outfile);
      end
      if((VT1 > 45) &&  (VT1_retc!=1))
      begin
        outfile=$fopen(errFileName,"a");
        $strobe("cift6a        VT1     leaving   OCA ( 45.000 V ..  ) at %7.4r  %M", $abstime );
        $fwrite(outfile,"cift6a        VT1     leaving   OCA ( 45.000 V ..  ) at %7.4r  %M\n", $abstime );
        VT1_retc=1;
        VT1_cnt=VT1_cnt-1;
        $fclose(outfile);
      end
   end
   else
   begin
      if(VT1_cnt==0)
      begin
        outfile=$fopen(errFileName,"a");
        $strobe("cift6a        VT1     error limit ( %d ) reached at %7.4r  %M", maxEv, $abstime );
        $fwrite(outfile,"cift6a        VT1     error limit ( %d ) reached at %7.4r  %M\n", maxEv, $abstime );
        VT1_cnt=VT1_cnt-1;
        $fclose(outfile);
      end
   end

//      VT2
   VT2 = V_T2;
   if((VT2_cnt>0) || ( maxEv_flg==0 ))   begin
      if( (VT2 < -45) && (VT2_retc!=-1))
      begin
        outfile=$fopen(errFileName,"a");
        $strobe("cift6a        VT2     leaving   OCA (  .. -45.000 V ) at %7.4r  %M", $abstime );
        $fwrite(outfile,"cift6a        VT2     leaving   OCA (  .. -45.000 V ) at %7.4r  %M\n", $abstime );
        VT2_retc=-1;
        VT2_cnt=VT2_cnt-1;
        $fclose(outfile);
      end
      if((VT2 >= -45) &&  (VT2 <= 45) && (VT2_retc!=0))
      begin
        outfile=$fopen(errFileName,"a");
        $strobe("cift6a        VT2     entering SOCA ( -45.000 V .. 45.000 V ) at %7.4r  %M", $abstime );
        $fwrite(outfile,"cift6a        VT2     entering SOCA ( -45.000 V .. 45.000 V ) at %7.4r  %M\n", $abstime );
        VT2_retc=0;
        VT2_cnt=VT2_cnt-1;
        $fclose(outfile);
      end
      if((VT2 > 45) &&  (VT2_retc!=1))
      begin
        outfile=$fopen(errFileName,"a");
        $strobe("cift6a        VT2     leaving   OCA ( 45.000 V ..  ) at %7.4r  %M", $abstime );
        $fwrite(outfile,"cift6a        VT2     leaving   OCA ( 45.000 V ..  ) at %7.4r  %M\n", $abstime );
        VT2_retc=1;
        VT2_cnt=VT2_cnt-1;
        $fclose(outfile);
      end
   end
   else
   begin
      if(VT2_cnt==0)
      begin
        outfile=$fopen(errFileName,"a");
        $strobe("cift6a        VT2     error limit ( %d ) reached at %7.4r  %M", maxEv, $abstime );
        $fwrite(outfile,"cift6a        VT2     error limit ( %d ) reached at %7.4r  %M\n", maxEv, $abstime );
        VT2_cnt=VT2_cnt-1;
        $fclose(outfile);
      end
   end

//      VT1T2
   VT1T2 = V_T1_T2;
   if((VT1T2_cnt>0) || ( maxEv_flg==0 ))   begin
      if( (VT1T2 < -30) && (VT1T2_retc!=-1))
      begin
        outfile=$fopen(errFileName,"a");
        $strobe("cift6a        VT1T2   leaving   OCA (  .. -30.000 V ) at %7.4r  %M", $abstime );
        $fwrite(outfile,"cift6a        VT1T2   leaving   OCA (  .. -30.000 V ) at %7.4r  %M\n", $abstime );
        VT1T2_retc=-1;
        VT1T2_cnt=VT1T2_cnt-1;
        $fclose(outfile);
      end
      if((VT1T2 >= -30) &&  (VT1T2 <= 30) && (VT1T2_retc!=0))
      begin
        outfile=$fopen(errFileName,"a");
        $strobe("cift6a        VT1T2   entering SOCA ( -30.000 V .. 30.000 V ) at %7.4r  %M", $abstime );
        $fwrite(outfile,"cift6a        VT1T2   entering SOCA ( -30.000 V .. 30.000 V ) at %7.4r  %M\n", $abstime );
        VT1T2_retc=0;
        VT1T2_cnt=VT1T2_cnt-1;
        $fclose(outfile);
      end
      if((VT1T2 > 30) &&  (VT1T2_retc!=1))
      begin
        outfile=$fopen(errFileName,"a");
        $strobe("cift6a        VT1T2   leaving   OCA ( 30.000 V ..  ) at %7.4r  %M", $abstime );
        $fwrite(outfile,"cift6a        VT1T2   leaving   OCA ( 30.000 V ..  ) at %7.4r  %M\n", $abstime );
        VT1T2_retc=1;
        VT1T2_cnt=VT1T2_cnt-1;
        $fclose(outfile);
      end
   end
   else
   begin
      if(VT1T2_cnt==0)
      begin
        outfile=$fopen(errFileName,"a");
        $strobe("cift6a        VT1T2   error limit ( %d ) reached at %7.4r  %M", maxEv, $abstime );
        $fwrite(outfile,"cift6a        VT1T2   error limit ( %d ) reached at %7.4r  %M\n", maxEv, $abstime );
        VT1T2_cnt=VT1T2_cnt-1;
        $fclose(outfile);
      end
   end

end // analog
endmodule // cift6a

// Verilog-A OC Watch for device csp5tl_3 Parameters  VT1NB VT2NB VT1T2
module csp5tl_3_ahdl(T1,T2,S);
parameter tstep_occ=100n;
parameter errFileName="./occ.err";
parameter maxEv = 25;
parameter maxEv_flg = 0;
inout T1,T2,S;
electrical T1,T2,S;

integer outfile;
real V_T1_T2;
real V_T2_S;
real V_T1_S;
real VT1NB;
integer VT1NB_retc;
integer VT1NB_cnt;
real VT2NB;
integer VT2NB_retc;
integer VT2NB_cnt;
real VT1T2;
integer VT1T2_retc;
integer VT1T2_cnt;

analog begin
   $bound_step( tstep_occ );
   @(initial_step) begin
      VT1NB_retc=0;
      VT1NB_cnt = maxEv;
      VT2NB_retc=0;
      VT2NB_cnt = maxEv;
      VT1T2_retc=0;
      VT1T2_cnt = maxEv;
   end
   V_T1_T2 = V(T1,T2);
   V_T2_S = V(T2,S);
   V_T1_S = V(T1,S);

//      VT1NB
   VT1NB = V_T1_S;
   if((VT1NB_cnt>0) || ( maxEv_flg==0 ))   begin
      if( (VT1NB < -375) && (VT1NB_retc!=-1))
      begin
        outfile=$fopen(errFileName,"a");
        $strobe("csp5tl_3      VT1NB   leaving   OCA (  .. -375.000 V ) at %7.4r  %M", $abstime );
        $fwrite(outfile,"csp5tl_3      VT1NB   leaving   OCA (  .. -375.000 V ) at %7.4r  %M\n", $abstime );
        VT1NB_retc=-1;
        VT1NB_cnt=VT1NB_cnt-1;
        $fclose(outfile);
      end
      if((VT1NB >= -375) &&  (VT1NB <= 1) && (VT1NB_retc!=0))
      begin
        outfile=$fopen(errFileName,"a");
        $strobe("csp5tl_3      VT1NB   entering SOCA ( -375.000 V .. 1.000 V ) at %7.4r  %M", $abstime );
        $fwrite(outfile,"csp5tl_3      VT1NB   entering SOCA ( -375.000 V .. 1.000 V ) at %7.4r  %M\n", $abstime );
        VT1NB_retc=0;
        VT1NB_cnt=VT1NB_cnt-1;
        $fclose(outfile);
      end
      if((VT1NB > 1) &&  (VT1NB_retc!=1))
      begin
        outfile=$fopen(errFileName,"a");
        $strobe("csp5tl_3      VT1NB   leaving   OCA ( 1.000 V ..  ) at %7.4r  %M", $abstime );
        $fwrite(outfile,"csp5tl_3      VT1NB   leaving   OCA ( 1.000 V ..  ) at %7.4r  %M\n", $abstime );
        VT1NB_retc=1;
        VT1NB_cnt=VT1NB_cnt-1;
        $fclose(outfile);
      end
   end
   else
   begin
      if(VT1NB_cnt==0)
      begin
        outfile=$fopen(errFileName,"a");
        $strobe("csp5tl_3      VT1NB   error limit ( %d ) reached at %7.4r  %M", maxEv, $abstime );
        $fwrite(outfile,"csp5tl_3      VT1NB   error limit ( %d ) reached at %7.4r  %M\n", maxEv, $abstime );
        VT1NB_cnt=VT1NB_cnt-1;
        $fclose(outfile);
      end
   end

//      VT2NB
   VT2NB = V_T2_S;
   if((VT2NB_cnt>0) || ( maxEv_flg==0 ))   begin
      if( (VT2NB < -375) && (VT2NB_retc!=-1))
      begin
        outfile=$fopen(errFileName,"a");
        $strobe("csp5tl_3      VT2NB   leaving   OCA (  .. -375.000 V ) at %7.4r  %M", $abstime );
        $fwrite(outfile,"csp5tl_3      VT2NB   leaving   OCA (  .. -375.000 V ) at %7.4r  %M\n", $abstime );
        VT2NB_retc=-1;
        VT2NB_cnt=VT2NB_cnt-1;
        $fclose(outfile);
      end
      if((VT2NB >= -375) &&  (VT2NB <= 1) && (VT2NB_retc!=0))
      begin
        outfile=$fopen(errFileName,"a");
        $strobe("csp5tl_3      VT2NB   entering SOCA ( -375.000 V .. 1.000 V ) at %7.4r  %M", $abstime );
        $fwrite(outfile,"csp5tl_3      VT2NB   entering SOCA ( -375.000 V .. 1.000 V ) at %7.4r  %M\n", $abstime );
        VT2NB_retc=0;
        VT2NB_cnt=VT2NB_cnt-1;
        $fclose(outfile);
      end
      if((VT2NB > 1) &&  (VT2NB_retc!=1))
      begin
        outfile=$fopen(errFileName,"a");
        $strobe("csp5tl_3      VT2NB   leaving   OCA ( 1.000 V ..  ) at %7.4r  %M", $abstime );
        $fwrite(outfile,"csp5tl_3      VT2NB   leaving   OCA ( 1.000 V ..  ) at %7.4r  %M\n", $abstime );
        VT2NB_retc=1;
        VT2NB_cnt=VT2NB_cnt-1;
        $fclose(outfile);
      end
   end
   else
   begin
      if(VT2NB_cnt==0)
      begin
        outfile=$fopen(errFileName,"a");
        $strobe("csp5tl_3      VT2NB   error limit ( %d ) reached at %7.4r  %M", maxEv, $abstime );
        $fwrite(outfile,"csp5tl_3      VT2NB   error limit ( %d ) reached at %7.4r  %M\n", maxEv, $abstime );
        VT2NB_cnt=VT2NB_cnt-1;
        $fclose(outfile);
      end
   end

//      VT1T2
   VT1T2 = V_T1_T2;
   if((VT1T2_cnt>0) || ( maxEv_flg==0 ))   begin
      if( (VT1T2 < -300) && (VT1T2_retc!=-1))
      begin
        outfile=$fopen(errFileName,"a");
        $strobe("csp5tl_3      VT1T2   leaving   OCA (  .. -300.000 V ) at %7.4r  %M", $abstime );
        $fwrite(outfile,"csp5tl_3      VT1T2   leaving   OCA (  .. -300.000 V ) at %7.4r  %M\n", $abstime );
        VT1T2_retc=-1;
        VT1T2_cnt=VT1T2_cnt-1;
        $fclose(outfile);
      end
      if((VT1T2 >= -300) &&  (VT1T2 <= 300) && (VT1T2_retc!=0))
      begin
        outfile=$fopen(errFileName,"a");
        $strobe("csp5tl_3      VT1T2   entering SOCA ( -300.000 V .. 300.000 V ) at %7.4r  %M", $abstime );
        $fwrite(outfile,"csp5tl_3      VT1T2   entering SOCA ( -300.000 V .. 300.000 V ) at %7.4r  %M\n", $abstime );
        VT1T2_retc=0;
        VT1T2_cnt=VT1T2_cnt-1;
        $fclose(outfile);
      end
      if((VT1T2 > 300) &&  (VT1T2_retc!=1))
      begin
        outfile=$fopen(errFileName,"a");
        $strobe("csp5tl_3      VT1T2   leaving   OCA ( 300.000 V ..  ) at %7.4r  %M", $abstime );
        $fwrite(outfile,"csp5tl_3      VT1T2   leaving   OCA ( 300.000 V ..  ) at %7.4r  %M\n", $abstime );
        VT1T2_retc=1;
        VT1T2_cnt=VT1T2_cnt-1;
        $fclose(outfile);
      end
   end
   else
   begin
      if(VT1T2_cnt==0)
      begin
        outfile=$fopen(errFileName,"a");
        $strobe("csp5tl_3      VT1T2   error limit ( %d ) reached at %7.4r  %M", maxEv, $abstime );
        $fwrite(outfile,"csp5tl_3      VT1T2   error limit ( %d ) reached at %7.4r  %M\n", maxEv, $abstime );
        VT1T2_cnt=VT1T2_cnt-1;
        $fclose(outfile);
      end
   end

end // analog
endmodule // csp5tl_3

// Verilog-A OC Watch for device csp5tla_3 Parameters  VT1NB VT2NB VT1T2
module csp5tla_3_ahdl(T1,T2,S);
parameter tstep_occ=100n;
parameter errFileName="./occ.err";
parameter maxEv = 25;
parameter maxEv_flg = 0;
inout T1,T2,S;
electrical T1,T2,S;

integer outfile;
real V_T1_T2;
real V_T2_S;
real V_T1_S;
real VT1NB;
integer VT1NB_retc;
integer VT1NB_cnt;
real VT2NB;
integer VT2NB_retc;
integer VT2NB_cnt;
real VT1T2;
integer VT1T2_retc;
integer VT1T2_cnt;

analog begin
   $bound_step( tstep_occ );
   @(initial_step) begin
      VT1NB_retc=0;
      VT1NB_cnt = maxEv;
      VT2NB_retc=0;
      VT2NB_cnt = maxEv;
      VT1T2_retc=0;
      VT1T2_cnt = maxEv;
   end
   V_T1_T2 = V(T1,T2);
   V_T2_S = V(T2,S);
   V_T1_S = V(T1,S);

//      VT1NB
   VT1NB = V_T1_S;
   if((VT1NB_cnt>0) || ( maxEv_flg==0 ))   begin
      if( (VT1NB < -375) && (VT1NB_retc!=-1))
      begin
        outfile=$fopen(errFileName,"a");
        $strobe("csp5tla_3     VT1NB   leaving   OCA (  .. -375.000 V ) at %7.4r  %M", $abstime );
        $fwrite(outfile,"csp5tla_3     VT1NB   leaving   OCA (  .. -375.000 V ) at %7.4r  %M\n", $abstime );
        VT1NB_retc=-1;
        VT1NB_cnt=VT1NB_cnt-1;
        $fclose(outfile);
      end
      if((VT1NB >= -375) &&  (VT1NB <= 1) && (VT1NB_retc!=0))
      begin
        outfile=$fopen(errFileName,"a");
        $strobe("csp5tla_3     VT1NB   entering SOCA ( -375.000 V .. 1.000 V ) at %7.4r  %M", $abstime );
        $fwrite(outfile,"csp5tla_3     VT1NB   entering SOCA ( -375.000 V .. 1.000 V ) at %7.4r  %M\n", $abstime );
        VT1NB_retc=0;
        VT1NB_cnt=VT1NB_cnt-1;
        $fclose(outfile);
      end
      if((VT1NB > 1) &&  (VT1NB_retc!=1))
      begin
        outfile=$fopen(errFileName,"a");
        $strobe("csp5tla_3     VT1NB   leaving   OCA ( 1.000 V ..  ) at %7.4r  %M", $abstime );
        $fwrite(outfile,"csp5tla_3     VT1NB   leaving   OCA ( 1.000 V ..  ) at %7.4r  %M\n", $abstime );
        VT1NB_retc=1;
        VT1NB_cnt=VT1NB_cnt-1;
        $fclose(outfile);
      end
   end
   else
   begin
      if(VT1NB_cnt==0)
      begin
        outfile=$fopen(errFileName,"a");
        $strobe("csp5tla_3     VT1NB   error limit ( %d ) reached at %7.4r  %M", maxEv, $abstime );
        $fwrite(outfile,"csp5tla_3     VT1NB   error limit ( %d ) reached at %7.4r  %M\n", maxEv, $abstime );
        VT1NB_cnt=VT1NB_cnt-1;
        $fclose(outfile);
      end
   end

//      VT2NB
   VT2NB = V_T2_S;
   if((VT2NB_cnt>0) || ( maxEv_flg==0 ))   begin
      if( (VT2NB < -375) && (VT2NB_retc!=-1))
      begin
        outfile=$fopen(errFileName,"a");
        $strobe("csp5tla_3     VT2NB   leaving   OCA (  .. -375.000 V ) at %7.4r  %M", $abstime );
        $fwrite(outfile,"csp5tla_3     VT2NB   leaving   OCA (  .. -375.000 V ) at %7.4r  %M\n", $abstime );
        VT2NB_retc=-1;
        VT2NB_cnt=VT2NB_cnt-1;
        $fclose(outfile);
      end
      if((VT2NB >= -375) &&  (VT2NB <= 1) && (VT2NB_retc!=0))
      begin
        outfile=$fopen(errFileName,"a");
        $strobe("csp5tla_3     VT2NB   entering SOCA ( -375.000 V .. 1.000 V ) at %7.4r  %M", $abstime );
        $fwrite(outfile,"csp5tla_3     VT2NB   entering SOCA ( -375.000 V .. 1.000 V ) at %7.4r  %M\n", $abstime );
        VT2NB_retc=0;
        VT2NB_cnt=VT2NB_cnt-1;
        $fclose(outfile);
      end
      if((VT2NB > 1) &&  (VT2NB_retc!=1))
      begin
        outfile=$fopen(errFileName,"a");
        $strobe("csp5tla_3     VT2NB   leaving   OCA ( 1.000 V ..  ) at %7.4r  %M", $abstime );
        $fwrite(outfile,"csp5tla_3     VT2NB   leaving   OCA ( 1.000 V ..  ) at %7.4r  %M\n", $abstime );
        VT2NB_retc=1;
        VT2NB_cnt=VT2NB_cnt-1;
        $fclose(outfile);
      end
   end
   else
   begin
      if(VT2NB_cnt==0)
      begin
        outfile=$fopen(errFileName,"a");
        $strobe("csp5tla_3     VT2NB   error limit ( %d ) reached at %7.4r  %M", maxEv, $abstime );
        $fwrite(outfile,"csp5tla_3     VT2NB   error limit ( %d ) reached at %7.4r  %M\n", maxEv, $abstime );
        VT2NB_cnt=VT2NB_cnt-1;
        $fclose(outfile);
      end
   end

//      VT1T2
   VT1T2 = V_T1_T2;
   if((VT1T2_cnt>0) || ( maxEv_flg==0 ))   begin
      if( (VT1T2 < -400) && (VT1T2_retc!=-1))
      begin
        outfile=$fopen(errFileName,"a");
        $strobe("csp5tla_3     VT1T2   leaving   OCA (  .. -400.000 V ) at %7.4r  %M", $abstime );
        $fwrite(outfile,"csp5tla_3     VT1T2   leaving   OCA (  .. -400.000 V ) at %7.4r  %M\n", $abstime );
        VT1T2_retc=-1;
        VT1T2_cnt=VT1T2_cnt-1;
        $fclose(outfile);
      end
      if((VT1T2 >= -400) &&  (VT1T2 <= 400) && (VT1T2_retc!=0))
      begin
        outfile=$fopen(errFileName,"a");
        $strobe("csp5tla_3     VT1T2   entering SOCA ( -400.000 V .. 400.000 V ) at %7.4r  %M", $abstime );
        $fwrite(outfile,"csp5tla_3     VT1T2   entering SOCA ( -400.000 V .. 400.000 V ) at %7.4r  %M\n", $abstime );
        VT1T2_retc=0;
        VT1T2_cnt=VT1T2_cnt-1;
        $fclose(outfile);
      end
      if((VT1T2 > 400) &&  (VT1T2_retc!=1))
      begin
        outfile=$fopen(errFileName,"a");
        $strobe("csp5tla_3     VT1T2   leaving   OCA ( 400.000 V ..  ) at %7.4r  %M", $abstime );
        $fwrite(outfile,"csp5tla_3     VT1T2   leaving   OCA ( 400.000 V ..  ) at %7.4r  %M\n", $abstime );
        VT1T2_retc=1;
        VT1T2_cnt=VT1T2_cnt-1;
        $fclose(outfile);
      end
   end
   else
   begin
      if(VT1T2_cnt==0)
      begin
        outfile=$fopen(errFileName,"a");
        $strobe("csp5tla_3     VT1T2   error limit ( %d ) reached at %7.4r  %M", maxEv, $abstime );
        $fwrite(outfile,"csp5tla_3     VT1T2   error limit ( %d ) reached at %7.4r  %M\n", maxEv, $abstime );
        VT1T2_cnt=VT1T2_cnt-1;
        $fclose(outfile);
      end
   end

end // analog
endmodule // csp5tla_3

// Verilog-A OC Watch for device oc_m45v_1v Parameters  VT1T2
module oc_m45v_1v_ahdl(T1,T2);
parameter tstep_occ=100n;
parameter errFileName="./occ.err";
parameter maxEv = 25;
parameter maxEv_flg = 0;
inout T1,T2;
electrical T1,T2;

integer outfile;
real V_T1_T2;
real VT1T2;
integer VT1T2_retc;
integer VT1T2_cnt;

analog begin
   $bound_step( tstep_occ );
   @(initial_step) begin
      VT1T2_retc=0;
      VT1T2_cnt = maxEv;
   end
   V_T1_T2 = V(T1,T2);

//      VT1T2
   VT1T2 = V_T1_T2;
   if((VT1T2_cnt>0) || ( maxEv_flg==0 ))   begin
      if( (VT1T2 < -45) && (VT1T2_retc!=-1))
      begin
        outfile=$fopen(errFileName,"a");
        $strobe("oc_m45v_1v    VT1T2   leaving   OCA (  .. -45.000 V ) at %7.4r  %M", $abstime );
        $fwrite(outfile,"oc_m45v_1v    VT1T2   leaving   OCA (  .. -45.000 V ) at %7.4r  %M\n", $abstime );
        VT1T2_retc=-1;
        VT1T2_cnt=VT1T2_cnt-1;
        $fclose(outfile);
      end
      if((VT1T2 >= -45) &&  (VT1T2 <= 1) && (VT1T2_retc!=0))
      begin
        outfile=$fopen(errFileName,"a");
        $strobe("oc_m45v_1v    VT1T2   entering SOCA ( -45.000 V .. 1.000 V ) at %7.4r  %M", $abstime );
        $fwrite(outfile,"oc_m45v_1v    VT1T2   entering SOCA ( -45.000 V .. 1.000 V ) at %7.4r  %M\n", $abstime );
        VT1T2_retc=0;
        VT1T2_cnt=VT1T2_cnt-1;
        $fclose(outfile);
      end
      if((VT1T2 > 1) &&  (VT1T2_retc!=1))
      begin
        outfile=$fopen(errFileName,"a");
        $strobe("oc_m45v_1v    VT1T2   leaving   OCA ( 1.000 V ..  ) at %7.4r  %M", $abstime );
        $fwrite(outfile,"oc_m45v_1v    VT1T2   leaving   OCA ( 1.000 V ..  ) at %7.4r  %M\n", $abstime );
        VT1T2_retc=1;
        VT1T2_cnt=VT1T2_cnt-1;
        $fclose(outfile);
      end
   end
   else
   begin
      if(VT1T2_cnt==0)
      begin
        outfile=$fopen(errFileName,"a");
        $strobe("oc_m45v_1v    VT1T2   error limit ( %d ) reached at %7.4r  %M", maxEv, $abstime );
        $fwrite(outfile,"oc_m45v_1v    VT1T2   error limit ( %d ) reached at %7.4r  %M\n", maxEv, $abstime );
        VT1T2_cnt=VT1T2_cnt-1;
        $fclose(outfile);
      end
   end

end // analog
endmodule // oc_m45v_1v

// Verilog-A OC Watch for device oc_m72v_1v Parameters  VT1T2
module oc_m72v_1v_ahdl(T1,T2);
parameter tstep_occ=100n;
parameter errFileName="./occ.err";
parameter maxEv = 25;
parameter maxEv_flg = 0;
inout T1,T2;
electrical T1,T2;

integer outfile;
real V_T1_T2;
real VT1T2;
integer VT1T2_retc;
integer VT1T2_cnt;

analog begin
   $bound_step( tstep_occ );
   @(initial_step) begin
      VT1T2_retc=0;
      VT1T2_cnt = maxEv;
   end
   V_T1_T2 = V(T1,T2);

//      VT1T2
   VT1T2 = V_T1_T2;
   if((VT1T2_cnt>0) || ( maxEv_flg==0 ))   begin
      if( (VT1T2 < -72) && (VT1T2_retc!=-1))
      begin
        outfile=$fopen(errFileName,"a");
        $strobe("oc_m72v_1v    VT1T2   leaving   OCA (  .. -72.000 V ) at %7.4r  %M", $abstime );
        $fwrite(outfile,"oc_m72v_1v    VT1T2   leaving   OCA (  .. -72.000 V ) at %7.4r  %M\n", $abstime );
        VT1T2_retc=-1;
        VT1T2_cnt=VT1T2_cnt-1;
        $fclose(outfile);
      end
      if((VT1T2 >= -72) &&  (VT1T2 <= 1) && (VT1T2_retc!=0))
      begin
        outfile=$fopen(errFileName,"a");
        $strobe("oc_m72v_1v    VT1T2   entering SOCA ( -72.000 V .. 1.000 V ) at %7.4r  %M", $abstime );
        $fwrite(outfile,"oc_m72v_1v    VT1T2   entering SOCA ( -72.000 V .. 1.000 V ) at %7.4r  %M\n", $abstime );
        VT1T2_retc=0;
        VT1T2_cnt=VT1T2_cnt-1;
        $fclose(outfile);
      end
      if((VT1T2 > 1) &&  (VT1T2_retc!=1))
      begin
        outfile=$fopen(errFileName,"a");
        $strobe("oc_m72v_1v    VT1T2   leaving   OCA ( 1.000 V ..  ) at %7.4r  %M", $abstime );
        $fwrite(outfile,"oc_m72v_1v    VT1T2   leaving   OCA ( 1.000 V ..  ) at %7.4r  %M\n", $abstime );
        VT1T2_retc=1;
        VT1T2_cnt=VT1T2_cnt-1;
        $fclose(outfile);
      end
   end
   else
   begin
      if(VT1T2_cnt==0)
      begin
        outfile=$fopen(errFileName,"a");
        $strobe("oc_m72v_1v    VT1T2   error limit ( %d ) reached at %7.4r  %M", maxEv, $abstime );
        $fwrite(outfile,"oc_m72v_1v    VT1T2   error limit ( %d ) reached at %7.4r  %M\n", maxEv, $abstime );
        VT1T2_cnt=VT1T2_cnt-1;
        $fclose(outfile);
      end
   end

end // analog
endmodule // oc_m72v_1v

// Verilog-A OC Watch for device oc_m95v_1v Parameters  VT1T2
module oc_m95v_1v_ahdl(T1,T2);
parameter tstep_occ=100n;
parameter errFileName="./occ.err";
parameter maxEv = 25;
parameter maxEv_flg = 0;
inout T1,T2;
electrical T1,T2;

integer outfile;
real V_T1_T2;
real VT1T2;
integer VT1T2_retc;
integer VT1T2_cnt;

analog begin
   $bound_step( tstep_occ );
   @(initial_step) begin
      VT1T2_retc=0;
      VT1T2_cnt = maxEv;
   end
   V_T1_T2 = V(T1,T2);

//      VT1T2
   VT1T2 = V_T1_T2;
   if((VT1T2_cnt>0) || ( maxEv_flg==0 ))   begin
      if( (VT1T2 < -95) && (VT1T2_retc!=-1))
      begin
        outfile=$fopen(errFileName,"a");
        $strobe("oc_m95v_1v    VT1T2   leaving   OCA (  .. -95.000 V ) at %7.4r  %M", $abstime );
        $fwrite(outfile,"oc_m95v_1v    VT1T2   leaving   OCA (  .. -95.000 V ) at %7.4r  %M\n", $abstime );
        VT1T2_retc=-1;
        VT1T2_cnt=VT1T2_cnt-1;
        $fclose(outfile);
      end
      if((VT1T2 >= -95) &&  (VT1T2 <= 1) && (VT1T2_retc!=0))
      begin
        outfile=$fopen(errFileName,"a");
        $strobe("oc_m95v_1v    VT1T2   entering SOCA ( -95.000 V .. 1.000 V ) at %7.4r  %M", $abstime );
        $fwrite(outfile,"oc_m95v_1v    VT1T2   entering SOCA ( -95.000 V .. 1.000 V ) at %7.4r  %M\n", $abstime );
        VT1T2_retc=0;
        VT1T2_cnt=VT1T2_cnt-1;
        $fclose(outfile);
      end
      if((VT1T2 > 1) &&  (VT1T2_retc!=1))
      begin
        outfile=$fopen(errFileName,"a");
        $strobe("oc_m95v_1v    VT1T2   leaving   OCA ( 1.000 V ..  ) at %7.4r  %M", $abstime );
        $fwrite(outfile,"oc_m95v_1v    VT1T2   leaving   OCA ( 1.000 V ..  ) at %7.4r  %M\n", $abstime );
        VT1T2_retc=1;
        VT1T2_cnt=VT1T2_cnt-1;
        $fclose(outfile);
      end
   end
   else
   begin
      if(VT1T2_cnt==0)
      begin
        outfile=$fopen(errFileName,"a");
        $strobe("oc_m95v_1v    VT1T2   error limit ( %d ) reached at %7.4r  %M", maxEv, $abstime );
        $fwrite(outfile,"oc_m95v_1v    VT1T2   error limit ( %d ) reached at %7.4r  %M\n", maxEv, $abstime );
        VT1T2_cnt=VT1T2_cnt-1;
        $fclose(outfile);
      end
   end

end // analog
endmodule // oc_m95v_1v

// Verilog-A OC Watch for device oc_m100v_1v Parameters  VT1T2
module oc_m100v_1v_ahdl(T1,T2);
parameter tstep_occ=100n;
parameter errFileName="./occ.err";
parameter maxEv = 25;
parameter maxEv_flg = 0;
inout T1,T2;
electrical T1,T2;

integer outfile;
real V_T1_T2;
real VT1T2;
integer VT1T2_retc;
integer VT1T2_cnt;

analog begin
   $bound_step( tstep_occ );
   @(initial_step) begin
      VT1T2_retc=0;
      VT1T2_cnt = maxEv;
   end
   V_T1_T2 = V(T1,T2);

//      VT1T2
   VT1T2 = V_T1_T2;
   if((VT1T2_cnt>0) || ( maxEv_flg==0 ))   begin
      if( (VT1T2 < -100) && (VT1T2_retc!=-1))
      begin
        outfile=$fopen(errFileName,"a");
        $strobe("oc_m100v_1v   VT1T2   leaving   OCA (  .. -100.000 V ) at %7.4r  %M", $abstime );
        $fwrite(outfile,"oc_m100v_1v   VT1T2   leaving   OCA (  .. -100.000 V ) at %7.4r  %M\n", $abstime );
        VT1T2_retc=-1;
        VT1T2_cnt=VT1T2_cnt-1;
        $fclose(outfile);
      end
      if((VT1T2 >= -100) &&  (VT1T2 <= 1) && (VT1T2_retc!=0))
      begin
        outfile=$fopen(errFileName,"a");
        $strobe("oc_m100v_1v   VT1T2   entering SOCA ( -100.000 V .. 1.000 V ) at %7.4r  %M", $abstime );
        $fwrite(outfile,"oc_m100v_1v   VT1T2   entering SOCA ( -100.000 V .. 1.000 V ) at %7.4r  %M\n", $abstime );
        VT1T2_retc=0;
        VT1T2_cnt=VT1T2_cnt-1;
        $fclose(outfile);
      end
      if((VT1T2 > 1) &&  (VT1T2_retc!=1))
      begin
        outfile=$fopen(errFileName,"a");
        $strobe("oc_m100v_1v   VT1T2   leaving   OCA ( 1.000 V ..  ) at %7.4r  %M", $abstime );
        $fwrite(outfile,"oc_m100v_1v   VT1T2   leaving   OCA ( 1.000 V ..  ) at %7.4r  %M\n", $abstime );
        VT1T2_retc=1;
        VT1T2_cnt=VT1T2_cnt-1;
        $fclose(outfile);
      end
   end
   else
   begin
      if(VT1T2_cnt==0)
      begin
        outfile=$fopen(errFileName,"a");
        $strobe("oc_m100v_1v   VT1T2   error limit ( %d ) reached at %7.4r  %M", maxEv, $abstime );
        $fwrite(outfile,"oc_m100v_1v   VT1T2   error limit ( %d ) reached at %7.4r  %M\n", maxEv, $abstime );
        VT1T2_cnt=VT1T2_cnt-1;
        $fclose(outfile);
      end
   end

end // analog
endmodule // oc_m100v_1v

// Verilog-A OC Watch for device oc_m115v_1v Parameters  VT1T2
module oc_m115v_1v_ahdl(T1,T2);
parameter tstep_occ=100n;
parameter errFileName="./occ.err";
parameter maxEv = 25;
parameter maxEv_flg = 0;
inout T1,T2;
electrical T1,T2;

integer outfile;
real V_T1_T2;
real VT1T2;
integer VT1T2_retc;
integer VT1T2_cnt;

analog begin
   $bound_step( tstep_occ );
   @(initial_step) begin
      VT1T2_retc=0;
      VT1T2_cnt = maxEv;
   end
   V_T1_T2 = V(T1,T2);

//      VT1T2
   VT1T2 = V_T1_T2;
   if((VT1T2_cnt>0) || ( maxEv_flg==0 ))   begin
      if( (VT1T2 < -115) && (VT1T2_retc!=-1))
      begin
        outfile=$fopen(errFileName,"a");
        $strobe("oc_m115v_1v   VT1T2   leaving   OCA (  .. -115.000 V ) at %7.4r  %M", $abstime );
        $fwrite(outfile,"oc_m115v_1v   VT1T2   leaving   OCA (  .. -115.000 V ) at %7.4r  %M\n", $abstime );
        VT1T2_retc=-1;
        VT1T2_cnt=VT1T2_cnt-1;
        $fclose(outfile);
      end
      if((VT1T2 >= -115) &&  (VT1T2 <= 1) && (VT1T2_retc!=0))
      begin
        outfile=$fopen(errFileName,"a");
        $strobe("oc_m115v_1v   VT1T2   entering SOCA ( -115.000 V .. 1.000 V ) at %7.4r  %M", $abstime );
        $fwrite(outfile,"oc_m115v_1v   VT1T2   entering SOCA ( -115.000 V .. 1.000 V ) at %7.4r  %M\n", $abstime );
        VT1T2_retc=0;
        VT1T2_cnt=VT1T2_cnt-1;
        $fclose(outfile);
      end
      if((VT1T2 > 1) &&  (VT1T2_retc!=1))
      begin
        outfile=$fopen(errFileName,"a");
        $strobe("oc_m115v_1v   VT1T2   leaving   OCA ( 1.000 V ..  ) at %7.4r  %M", $abstime );
        $fwrite(outfile,"oc_m115v_1v   VT1T2   leaving   OCA ( 1.000 V ..  ) at %7.4r  %M\n", $abstime );
        VT1T2_retc=1;
        VT1T2_cnt=VT1T2_cnt-1;
        $fclose(outfile);
      end
   end
   else
   begin
      if(VT1T2_cnt==0)
      begin
        outfile=$fopen(errFileName,"a");
        $strobe("oc_m115v_1v   VT1T2   error limit ( %d ) reached at %7.4r  %M", maxEv, $abstime );
        $fwrite(outfile,"oc_m115v_1v   VT1T2   error limit ( %d ) reached at %7.4r  %M\n", maxEv, $abstime );
        VT1T2_cnt=VT1T2_cnt-1;
        $fclose(outfile);
      end
   end

end // analog
endmodule // oc_m115v_1v

// Verilog-A OC Watch for device oc_m140v_1v Parameters  VT1T2
module oc_m140v_1v_ahdl(T1,T2);
parameter tstep_occ=100n;
parameter errFileName="./occ.err";
parameter maxEv = 25;
parameter maxEv_flg = 0;
inout T1,T2;
electrical T1,T2;

integer outfile;
real V_T1_T2;
real VT1T2;
integer VT1T2_retc;
integer VT1T2_cnt;

analog begin
   $bound_step( tstep_occ );
   @(initial_step) begin
      VT1T2_retc=0;
      VT1T2_cnt = maxEv;
   end
   V_T1_T2 = V(T1,T2);

//      VT1T2
   VT1T2 = V_T1_T2;
   if((VT1T2_cnt>0) || ( maxEv_flg==0 ))   begin
      if( (VT1T2 < -140) && (VT1T2_retc!=-1))
      begin
        outfile=$fopen(errFileName,"a");
        $strobe("oc_m140v_1v   VT1T2   leaving   OCA (  .. -140.000 V ) at %7.4r  %M", $abstime );
        $fwrite(outfile,"oc_m140v_1v   VT1T2   leaving   OCA (  .. -140.000 V ) at %7.4r  %M\n", $abstime );
        VT1T2_retc=-1;
        VT1T2_cnt=VT1T2_cnt-1;
        $fclose(outfile);
      end
      if((VT1T2 >= -140) &&  (VT1T2 <= 1) && (VT1T2_retc!=0))
      begin
        outfile=$fopen(errFileName,"a");
        $strobe("oc_m140v_1v   VT1T2   entering SOCA ( -140.000 V .. 1.000 V ) at %7.4r  %M", $abstime );
        $fwrite(outfile,"oc_m140v_1v   VT1T2   entering SOCA ( -140.000 V .. 1.000 V ) at %7.4r  %M\n", $abstime );
        VT1T2_retc=0;
        VT1T2_cnt=VT1T2_cnt-1;
        $fclose(outfile);
      end
      if((VT1T2 > 1) &&  (VT1T2_retc!=1))
      begin
        outfile=$fopen(errFileName,"a");
        $strobe("oc_m140v_1v   VT1T2   leaving   OCA ( 1.000 V ..  ) at %7.4r  %M", $abstime );
        $fwrite(outfile,"oc_m140v_1v   VT1T2   leaving   OCA ( 1.000 V ..  ) at %7.4r  %M\n", $abstime );
        VT1T2_retc=1;
        VT1T2_cnt=VT1T2_cnt-1;
        $fclose(outfile);
      end
   end
   else
   begin
      if(VT1T2_cnt==0)
      begin
        outfile=$fopen(errFileName,"a");
        $strobe("oc_m140v_1v   VT1T2   error limit ( %d ) reached at %7.4r  %M", maxEv, $abstime );
        $fwrite(outfile,"oc_m140v_1v   VT1T2   error limit ( %d ) reached at %7.4r  %M\n", maxEv, $abstime );
        VT1T2_cnt=VT1T2_cnt-1;
        $fclose(outfile);
      end
   end

end // analog
endmodule // oc_m140v_1v

// Verilog-A OC Watch for device oc_m155v_1v Parameters  VT1T2
module oc_m155v_1v_ahdl(T1,T2);
parameter tstep_occ=100n;
parameter errFileName="./occ.err";
parameter maxEv = 25;
parameter maxEv_flg = 0;
inout T1,T2;
electrical T1,T2;

integer outfile;
real V_T1_T2;
real VT1T2;
integer VT1T2_retc;
integer VT1T2_cnt;

analog begin
   $bound_step( tstep_occ );
   @(initial_step) begin
      VT1T2_retc=0;
      VT1T2_cnt = maxEv;
   end
   V_T1_T2 = V(T1,T2);

//      VT1T2
   VT1T2 = V_T1_T2;
   if((VT1T2_cnt>0) || ( maxEv_flg==0 ))   begin
      if( (VT1T2 < -155) && (VT1T2_retc!=-1))
      begin
        outfile=$fopen(errFileName,"a");
        $strobe("oc_m155v_1v   VT1T2   leaving   OCA (  .. -155.000 V ) at %7.4r  %M", $abstime );
        $fwrite(outfile,"oc_m155v_1v   VT1T2   leaving   OCA (  .. -155.000 V ) at %7.4r  %M\n", $abstime );
        VT1T2_retc=-1;
        VT1T2_cnt=VT1T2_cnt-1;
        $fclose(outfile);
      end
      if((VT1T2 >= -155) &&  (VT1T2 <= 1) && (VT1T2_retc!=0))
      begin
        outfile=$fopen(errFileName,"a");
        $strobe("oc_m155v_1v   VT1T2   entering SOCA ( -155.000 V .. 1.000 V ) at %7.4r  %M", $abstime );
        $fwrite(outfile,"oc_m155v_1v   VT1T2   entering SOCA ( -155.000 V .. 1.000 V ) at %7.4r  %M\n", $abstime );
        VT1T2_retc=0;
        VT1T2_cnt=VT1T2_cnt-1;
        $fclose(outfile);
      end
      if((VT1T2 > 1) &&  (VT1T2_retc!=1))
      begin
        outfile=$fopen(errFileName,"a");
        $strobe("oc_m155v_1v   VT1T2   leaving   OCA ( 1.000 V ..  ) at %7.4r  %M", $abstime );
        $fwrite(outfile,"oc_m155v_1v   VT1T2   leaving   OCA ( 1.000 V ..  ) at %7.4r  %M\n", $abstime );
        VT1T2_retc=1;
        VT1T2_cnt=VT1T2_cnt-1;
        $fclose(outfile);
      end
   end
   else
   begin
      if(VT1T2_cnt==0)
      begin
        outfile=$fopen(errFileName,"a");
        $strobe("oc_m155v_1v   VT1T2   error limit ( %d ) reached at %7.4r  %M", maxEv, $abstime );
        $fwrite(outfile,"oc_m155v_1v   VT1T2   error limit ( %d ) reached at %7.4r  %M\n", maxEv, $abstime );
        VT1T2_cnt=VT1T2_cnt-1;
        $fclose(outfile);
      end
   end

end // analog
endmodule // oc_m155v_1v

// Verilog-A OC Watch for device oc_m195v_1v Parameters  VT1T2
module oc_m195v_1v_ahdl(T1,T2);
parameter tstep_occ=100n;
parameter errFileName="./occ.err";
parameter maxEv = 25;
parameter maxEv_flg = 0;
inout T1,T2;
electrical T1,T2;

integer outfile;
real V_T1_T2;
real VT1T2;
integer VT1T2_retc;
integer VT1T2_cnt;

analog begin
   $bound_step( tstep_occ );
   @(initial_step) begin
      VT1T2_retc=0;
      VT1T2_cnt = maxEv;
   end
   V_T1_T2 = V(T1,T2);

//      VT1T2
   VT1T2 = V_T1_T2;
   if((VT1T2_cnt>0) || ( maxEv_flg==0 ))   begin
      if( (VT1T2 < -195) && (VT1T2_retc!=-1))
      begin
        outfile=$fopen(errFileName,"a");
        $strobe("oc_m195v_1v   VT1T2   leaving   OCA (  .. -195.000 V ) at %7.4r  %M", $abstime );
        $fwrite(outfile,"oc_m195v_1v   VT1T2   leaving   OCA (  .. -195.000 V ) at %7.4r  %M\n", $abstime );
        VT1T2_retc=-1;
        VT1T2_cnt=VT1T2_cnt-1;
        $fclose(outfile);
      end
      if((VT1T2 >= -195) &&  (VT1T2 <= 1) && (VT1T2_retc!=0))
      begin
        outfile=$fopen(errFileName,"a");
        $strobe("oc_m195v_1v   VT1T2   entering SOCA ( -195.000 V .. 1.000 V ) at %7.4r  %M", $abstime );
        $fwrite(outfile,"oc_m195v_1v   VT1T2   entering SOCA ( -195.000 V .. 1.000 V ) at %7.4r  %M\n", $abstime );
        VT1T2_retc=0;
        VT1T2_cnt=VT1T2_cnt-1;
        $fclose(outfile);
      end
      if((VT1T2 > 1) &&  (VT1T2_retc!=1))
      begin
        outfile=$fopen(errFileName,"a");
        $strobe("oc_m195v_1v   VT1T2   leaving   OCA ( 1.000 V ..  ) at %7.4r  %M", $abstime );
        $fwrite(outfile,"oc_m195v_1v   VT1T2   leaving   OCA ( 1.000 V ..  ) at %7.4r  %M\n", $abstime );
        VT1T2_retc=1;
        VT1T2_cnt=VT1T2_cnt-1;
        $fclose(outfile);
      end
   end
   else
   begin
      if(VT1T2_cnt==0)
      begin
        outfile=$fopen(errFileName,"a");
        $strobe("oc_m195v_1v   VT1T2   error limit ( %d ) reached at %7.4r  %M", maxEv, $abstime );
        $fwrite(outfile,"oc_m195v_1v   VT1T2   error limit ( %d ) reached at %7.4r  %M\n", maxEv, $abstime );
        VT1T2_cnt=VT1T2_cnt-1;
        $fclose(outfile);
      end
   end

end // analog
endmodule // oc_m195v_1v

// Verilog-A OC Watch for device oc_m200v_1v Parameters  VT1T2
module oc_m200v_1v_ahdl(T1,T2);
parameter tstep_occ=100n;
parameter errFileName="./occ.err";
parameter maxEv = 25;
parameter maxEv_flg = 0;
inout T1,T2;
electrical T1,T2;

integer outfile;
real V_T1_T2;
real VT1T2;
integer VT1T2_retc;
integer VT1T2_cnt;

analog begin
   $bound_step( tstep_occ );
   @(initial_step) begin
      VT1T2_retc=0;
      VT1T2_cnt = maxEv;
   end
   V_T1_T2 = V(T1,T2);

//      VT1T2
   VT1T2 = V_T1_T2;
   if((VT1T2_cnt>0) || ( maxEv_flg==0 ))   begin
      if( (VT1T2 < -200) && (VT1T2_retc!=-1))
      begin
        outfile=$fopen(errFileName,"a");
        $strobe("oc_m200v_1v   VT1T2   leaving   OCA (  .. -200.000 V ) at %7.4r  %M", $abstime );
        $fwrite(outfile,"oc_m200v_1v   VT1T2   leaving   OCA (  .. -200.000 V ) at %7.4r  %M\n", $abstime );
        VT1T2_retc=-1;
        VT1T2_cnt=VT1T2_cnt-1;
        $fclose(outfile);
      end
      if((VT1T2 >= -200) &&  (VT1T2 <= 1) && (VT1T2_retc!=0))
      begin
        outfile=$fopen(errFileName,"a");
        $strobe("oc_m200v_1v   VT1T2   entering SOCA ( -200.000 V .. 1.000 V ) at %7.4r  %M", $abstime );
        $fwrite(outfile,"oc_m200v_1v   VT1T2   entering SOCA ( -200.000 V .. 1.000 V ) at %7.4r  %M\n", $abstime );
        VT1T2_retc=0;
        VT1T2_cnt=VT1T2_cnt-1;
        $fclose(outfile);
      end
      if((VT1T2 > 1) &&  (VT1T2_retc!=1))
      begin
        outfile=$fopen(errFileName,"a");
        $strobe("oc_m200v_1v   VT1T2   leaving   OCA ( 1.000 V ..  ) at %7.4r  %M", $abstime );
        $fwrite(outfile,"oc_m200v_1v   VT1T2   leaving   OCA ( 1.000 V ..  ) at %7.4r  %M\n", $abstime );
        VT1T2_retc=1;
        VT1T2_cnt=VT1T2_cnt-1;
        $fclose(outfile);
      end
   end
   else
   begin
      if(VT1T2_cnt==0)
      begin
        outfile=$fopen(errFileName,"a");
        $strobe("oc_m200v_1v   VT1T2   error limit ( %d ) reached at %7.4r  %M", maxEv, $abstime );
        $fwrite(outfile,"oc_m200v_1v   VT1T2   error limit ( %d ) reached at %7.4r  %M\n", maxEv, $abstime );
        VT1T2_cnt=VT1T2_cnt-1;
        $fclose(outfile);
      end
   end

end // analog
endmodule // oc_m200v_1v

// Verilog-A OC Watch for device oc_m235v_1v Parameters  VT1T2
module oc_m235v_1v_ahdl(T1,T2);
parameter tstep_occ=100n;
parameter errFileName="./occ.err";
parameter maxEv = 25;
parameter maxEv_flg = 0;
inout T1,T2;
electrical T1,T2;

integer outfile;
real V_T1_T2;
real VT1T2;
integer VT1T2_retc;
integer VT1T2_cnt;

analog begin
   $bound_step( tstep_occ );
   @(initial_step) begin
      VT1T2_retc=0;
      VT1T2_cnt = maxEv;
   end
   V_T1_T2 = V(T1,T2);

//      VT1T2
   VT1T2 = V_T1_T2;
   if((VT1T2_cnt>0) || ( maxEv_flg==0 ))   begin
      if( (VT1T2 < -235) && (VT1T2_retc!=-1))
      begin
        outfile=$fopen(errFileName,"a");
        $strobe("oc_m235v_1v   VT1T2   leaving   OCA (  .. -235.000 V ) at %7.4r  %M", $abstime );
        $fwrite(outfile,"oc_m235v_1v   VT1T2   leaving   OCA (  .. -235.000 V ) at %7.4r  %M\n", $abstime );
        VT1T2_retc=-1;
        VT1T2_cnt=VT1T2_cnt-1;
        $fclose(outfile);
      end
      if((VT1T2 >= -235) &&  (VT1T2 <= 1) && (VT1T2_retc!=0))
      begin
        outfile=$fopen(errFileName,"a");
        $strobe("oc_m235v_1v   VT1T2   entering SOCA ( -235.000 V .. 1.000 V ) at %7.4r  %M", $abstime );
        $fwrite(outfile,"oc_m235v_1v   VT1T2   entering SOCA ( -235.000 V .. 1.000 V ) at %7.4r  %M\n", $abstime );
        VT1T2_retc=0;
        VT1T2_cnt=VT1T2_cnt-1;
        $fclose(outfile);
      end
      if((VT1T2 > 1) &&  (VT1T2_retc!=1))
      begin
        outfile=$fopen(errFileName,"a");
        $strobe("oc_m235v_1v   VT1T2   leaving   OCA ( 1.000 V ..  ) at %7.4r  %M", $abstime );
        $fwrite(outfile,"oc_m235v_1v   VT1T2   leaving   OCA ( 1.000 V ..  ) at %7.4r  %M\n", $abstime );
        VT1T2_retc=1;
        VT1T2_cnt=VT1T2_cnt-1;
        $fclose(outfile);
      end
   end
   else
   begin
      if(VT1T2_cnt==0)
      begin
        outfile=$fopen(errFileName,"a");
        $strobe("oc_m235v_1v   VT1T2   error limit ( %d ) reached at %7.4r  %M", maxEv, $abstime );
        $fwrite(outfile,"oc_m235v_1v   VT1T2   error limit ( %d ) reached at %7.4r  %M\n", maxEv, $abstime );
        VT1T2_cnt=VT1T2_cnt-1;
        $fclose(outfile);
      end
   end

end // analog
endmodule // oc_m235v_1v

// Verilog-A OC Watch for device oc_m290v_1v Parameters  VT1T2
module oc_m290v_1v_ahdl(T1,T2);
parameter tstep_occ=100n;
parameter errFileName="./occ.err";
parameter maxEv = 25;
parameter maxEv_flg = 0;
inout T1,T2;
electrical T1,T2;

integer outfile;
real V_T1_T2;
real VT1T2;
integer VT1T2_retc;
integer VT1T2_cnt;

analog begin
   $bound_step( tstep_occ );
   @(initial_step) begin
      VT1T2_retc=0;
      VT1T2_cnt = maxEv;
   end
   V_T1_T2 = V(T1,T2);

//      VT1T2
   VT1T2 = V_T1_T2;
   if((VT1T2_cnt>0) || ( maxEv_flg==0 ))   begin
      if( (VT1T2 < -290) && (VT1T2_retc!=-1))
      begin
        outfile=$fopen(errFileName,"a");
        $strobe("oc_m290v_1v   VT1T2   leaving   OCA (  .. -290.000 V ) at %7.4r  %M", $abstime );
        $fwrite(outfile,"oc_m290v_1v   VT1T2   leaving   OCA (  .. -290.000 V ) at %7.4r  %M\n", $abstime );
        VT1T2_retc=-1;
        VT1T2_cnt=VT1T2_cnt-1;
        $fclose(outfile);
      end
      if((VT1T2 >= -290) &&  (VT1T2 <= 1) && (VT1T2_retc!=0))
      begin
        outfile=$fopen(errFileName,"a");
        $strobe("oc_m290v_1v   VT1T2   entering SOCA ( -290.000 V .. 1.000 V ) at %7.4r  %M", $abstime );
        $fwrite(outfile,"oc_m290v_1v   VT1T2   entering SOCA ( -290.000 V .. 1.000 V ) at %7.4r  %M\n", $abstime );
        VT1T2_retc=0;
        VT1T2_cnt=VT1T2_cnt-1;
        $fclose(outfile);
      end
      if((VT1T2 > 1) &&  (VT1T2_retc!=1))
      begin
        outfile=$fopen(errFileName,"a");
        $strobe("oc_m290v_1v   VT1T2   leaving   OCA ( 1.000 V ..  ) at %7.4r  %M", $abstime );
        $fwrite(outfile,"oc_m290v_1v   VT1T2   leaving   OCA ( 1.000 V ..  ) at %7.4r  %M\n", $abstime );
        VT1T2_retc=1;
        VT1T2_cnt=VT1T2_cnt-1;
        $fclose(outfile);
      end
   end
   else
   begin
      if(VT1T2_cnt==0)
      begin
        outfile=$fopen(errFileName,"a");
        $strobe("oc_m290v_1v   VT1T2   error limit ( %d ) reached at %7.4r  %M", maxEv, $abstime );
        $fwrite(outfile,"oc_m290v_1v   VT1T2   error limit ( %d ) reached at %7.4r  %M\n", maxEv, $abstime );
        VT1T2_cnt=VT1T2_cnt-1;
        $fclose(outfile);
      end
   end

end // analog
endmodule // oc_m290v_1v

// Verilog-A OC Watch for device oc_m375v_1v Parameters  VT1T2
module oc_m375v_1v_ahdl(T1,T2);
parameter tstep_occ=100n;
parameter errFileName="./occ.err";
parameter maxEv = 25;
parameter maxEv_flg = 0;
inout T1,T2;
electrical T1,T2;

integer outfile;
real V_T1_T2;
real VT1T2;
integer VT1T2_retc;
integer VT1T2_cnt;

analog begin
   $bound_step( tstep_occ );
   @(initial_step) begin
      VT1T2_retc=0;
      VT1T2_cnt = maxEv;
   end
   V_T1_T2 = V(T1,T2);

//      VT1T2
   VT1T2 = V_T1_T2;
   if((VT1T2_cnt>0) || ( maxEv_flg==0 ))   begin
      if( (VT1T2 < -375) && (VT1T2_retc!=-1))
      begin
        outfile=$fopen(errFileName,"a");
        $strobe("oc_m375v_1v   VT1T2   leaving   OCA (  .. -375.000 V ) at %7.4r  %M", $abstime );
        $fwrite(outfile,"oc_m375v_1v   VT1T2   leaving   OCA (  .. -375.000 V ) at %7.4r  %M\n", $abstime );
        VT1T2_retc=-1;
        VT1T2_cnt=VT1T2_cnt-1;
        $fclose(outfile);
      end
      if((VT1T2 >= -375) &&  (VT1T2 <= 1) && (VT1T2_retc!=0))
      begin
        outfile=$fopen(errFileName,"a");
        $strobe("oc_m375v_1v   VT1T2   entering SOCA ( -375.000 V .. 1.000 V ) at %7.4r  %M", $abstime );
        $fwrite(outfile,"oc_m375v_1v   VT1T2   entering SOCA ( -375.000 V .. 1.000 V ) at %7.4r  %M\n", $abstime );
        VT1T2_retc=0;
        VT1T2_cnt=VT1T2_cnt-1;
        $fclose(outfile);
      end
      if((VT1T2 > 1) &&  (VT1T2_retc!=1))
      begin
        outfile=$fopen(errFileName,"a");
        $strobe("oc_m375v_1v   VT1T2   leaving   OCA ( 1.000 V ..  ) at %7.4r  %M", $abstime );
        $fwrite(outfile,"oc_m375v_1v   VT1T2   leaving   OCA ( 1.000 V ..  ) at %7.4r  %M\n", $abstime );
        VT1T2_retc=1;
        VT1T2_cnt=VT1T2_cnt-1;
        $fclose(outfile);
      end
   end
   else
   begin
      if(VT1T2_cnt==0)
      begin
        outfile=$fopen(errFileName,"a");
        $strobe("oc_m375v_1v   VT1T2   error limit ( %d ) reached at %7.4r  %M", maxEv, $abstime );
        $fwrite(outfile,"oc_m375v_1v   VT1T2   error limit ( %d ) reached at %7.4r  %M\n", maxEv, $abstime );
        VT1T2_cnt=VT1T2_cnt-1;
        $fclose(outfile);
      end
   end

end // analog
endmodule // oc_m375v_1v

// Verilog-A OC Watch for device oc_m100v_100v Parameters  VT1T2
module oc_m100v_100v_ahdl(T1,T2);
parameter tstep_occ=100n;
parameter errFileName="./occ.err";
parameter maxEv = 25;
parameter maxEv_flg = 0;
inout T1,T2;
electrical T1,T2;

integer outfile;
real V_T1_T2;
real VT1T2;
integer VT1T2_retc;
integer VT1T2_cnt;

analog begin
   $bound_step( tstep_occ );
   @(initial_step) begin
      VT1T2_retc=0;
      VT1T2_cnt = maxEv;
   end
   V_T1_T2 = V(T1,T2);

//      VT1T2
   VT1T2 = V_T1_T2;
   if((VT1T2_cnt>0) || ( maxEv_flg==0 ))   begin
      if( (VT1T2 < -100) && (VT1T2_retc!=-1))
      begin
        outfile=$fopen(errFileName,"a");
        $strobe("oc_m100v_100v VT1T2   leaving   OCA (  .. -100.000 V ) at %7.4r  %M", $abstime );
        $fwrite(outfile,"oc_m100v_100v VT1T2   leaving   OCA (  .. -100.000 V ) at %7.4r  %M\n", $abstime );
        VT1T2_retc=-1;
        VT1T2_cnt=VT1T2_cnt-1;
        $fclose(outfile);
      end
      if((VT1T2 >= -100) &&  (VT1T2 <= 100) && (VT1T2_retc!=0))
      begin
        outfile=$fopen(errFileName,"a");
        $strobe("oc_m100v_100v VT1T2   entering SOCA ( -100.000 V .. 100.000 V ) at %7.4r  %M", $abstime );
        $fwrite(outfile,"oc_m100v_100v VT1T2   entering SOCA ( -100.000 V .. 100.000 V ) at %7.4r  %M\n", $abstime );
        VT1T2_retc=0;
        VT1T2_cnt=VT1T2_cnt-1;
        $fclose(outfile);
      end
      if((VT1T2 > 100) &&  (VT1T2_retc!=1))
      begin
        outfile=$fopen(errFileName,"a");
        $strobe("oc_m100v_100v VT1T2   leaving   OCA ( 100.000 V ..  ) at %7.4r  %M", $abstime );
        $fwrite(outfile,"oc_m100v_100v VT1T2   leaving   OCA ( 100.000 V ..  ) at %7.4r  %M\n", $abstime );
        VT1T2_retc=1;
        VT1T2_cnt=VT1T2_cnt-1;
        $fclose(outfile);
      end
   end
   else
   begin
      if(VT1T2_cnt==0)
      begin
        outfile=$fopen(errFileName,"a");
        $strobe("oc_m100v_100v VT1T2   error limit ( %d ) reached at %7.4r  %M", maxEv, $abstime );
        $fwrite(outfile,"oc_m100v_100v VT1T2   error limit ( %d ) reached at %7.4r  %M\n", maxEv, $abstime );
        VT1T2_cnt=VT1T2_cnt-1;
        $fclose(outfile);
      end
   end

end // analog
endmodule // oc_m100v_100v

// Verilog-A OC Watch for device oc_m200v_400v Parameters  VT1T2
module oc_m200v_400v_ahdl(T1,T2);
parameter tstep_occ=100n;
parameter errFileName="./occ.err";
parameter maxEv = 25;
parameter maxEv_flg = 0;
inout T1,T2;
electrical T1,T2;

integer outfile;
real V_T1_T2;
real VT1T2;
integer VT1T2_retc;
integer VT1T2_cnt;

analog begin
   $bound_step( tstep_occ );
   @(initial_step) begin
      VT1T2_retc=0;
      VT1T2_cnt = maxEv;
   end
   V_T1_T2 = V(T1,T2);

//      VT1T2
   VT1T2 = V_T1_T2;
   if((VT1T2_cnt>0) || ( maxEv_flg==0 ))   begin
      if( (VT1T2 < -200) && (VT1T2_retc!=-1))
      begin
        outfile=$fopen(errFileName,"a");
        $strobe("oc_m200v_400v VT1T2   leaving   OCA (  .. -200.000 V ) at %7.4r  %M", $abstime );
        $fwrite(outfile,"oc_m200v_400v VT1T2   leaving   OCA (  .. -200.000 V ) at %7.4r  %M\n", $abstime );
        VT1T2_retc=-1;
        VT1T2_cnt=VT1T2_cnt-1;
        $fclose(outfile);
      end
      if((VT1T2 >= -200) &&  (VT1T2 <= 400) && (VT1T2_retc!=0))
      begin
        outfile=$fopen(errFileName,"a");
        $strobe("oc_m200v_400v VT1T2   entering SOCA ( -200.000 V .. 400.000 V ) at %7.4r  %M", $abstime );
        $fwrite(outfile,"oc_m200v_400v VT1T2   entering SOCA ( -200.000 V .. 400.000 V ) at %7.4r  %M\n", $abstime );
        VT1T2_retc=0;
        VT1T2_cnt=VT1T2_cnt-1;
        $fclose(outfile);
      end
      if((VT1T2 > 400) &&  (VT1T2_retc!=1))
      begin
        outfile=$fopen(errFileName,"a");
        $strobe("oc_m200v_400v VT1T2   leaving   OCA ( 400.000 V ..  ) at %7.4r  %M", $abstime );
        $fwrite(outfile,"oc_m200v_400v VT1T2   leaving   OCA ( 400.000 V ..  ) at %7.4r  %M\n", $abstime );
        VT1T2_retc=1;
        VT1T2_cnt=VT1T2_cnt-1;
        $fclose(outfile);
      end
   end
   else
   begin
      if(VT1T2_cnt==0)
      begin
        outfile=$fopen(errFileName,"a");
        $strobe("oc_m200v_400v VT1T2   error limit ( %d ) reached at %7.4r  %M", maxEv, $abstime );
        $fwrite(outfile,"oc_m200v_400v VT1T2   error limit ( %d ) reached at %7.4r  %M\n", maxEv, $abstime );
        VT1T2_cnt=VT1T2_cnt-1;
        $fclose(outfile);
      end
   end

end // analog
endmodule // oc_m200v_400v

// Verilog-A OC Watch for device oc_m2v_400v Parameters  VT1T2
module oc_m2v_400v_ahdl(T1,T2);
parameter tstep_occ=100n;
parameter errFileName="./occ.err";
parameter maxEv = 25;
parameter maxEv_flg = 0;
inout T1,T2;
electrical T1,T2;

integer outfile;
real V_T1_T2;
real VT1T2;
integer VT1T2_retc;
integer VT1T2_cnt;

analog begin
   $bound_step( tstep_occ );
   @(initial_step) begin
      VT1T2_retc=0;
      VT1T2_cnt = maxEv;
   end
   V_T1_T2 = V(T1,T2);

//      VT1T2
   VT1T2 = V_T1_T2;
   if((VT1T2_cnt>0) || ( maxEv_flg==0 ))   begin
      if( (VT1T2 < -1.98) && (VT1T2_retc!=-1))
      begin
        outfile=$fopen(errFileName,"a");
        $strobe("oc_m2v_400v   VT1T2   leaving   OCA (  .. -1.980 V ) at %7.4r  %M", $abstime );
        $fwrite(outfile,"oc_m2v_400v   VT1T2   leaving   OCA (  .. -1.980 V ) at %7.4r  %M\n", $abstime );
        VT1T2_retc=-1;
        VT1T2_cnt=VT1T2_cnt-1;
        $fclose(outfile);
      end
      if((VT1T2 >= -1.98) &&  (VT1T2 <= 400) && (VT1T2_retc!=0))
      begin
        outfile=$fopen(errFileName,"a");
        $strobe("oc_m2v_400v   VT1T2   entering SOCA ( -1.980 V .. 400.000 V ) at %7.4r  %M", $abstime );
        $fwrite(outfile,"oc_m2v_400v   VT1T2   entering SOCA ( -1.980 V .. 400.000 V ) at %7.4r  %M\n", $abstime );
        VT1T2_retc=0;
        VT1T2_cnt=VT1T2_cnt-1;
        $fclose(outfile);
      end
      if((VT1T2 > 400) &&  (VT1T2_retc!=1))
      begin
        outfile=$fopen(errFileName,"a");
        $strobe("oc_m2v_400v   VT1T2   leaving   OCA ( 400.000 V ..  ) at %7.4r  %M", $abstime );
        $fwrite(outfile,"oc_m2v_400v   VT1T2   leaving   OCA ( 400.000 V ..  ) at %7.4r  %M\n", $abstime );
        VT1T2_retc=1;
        VT1T2_cnt=VT1T2_cnt-1;
        $fclose(outfile);
      end
   end
   else
   begin
      if(VT1T2_cnt==0)
      begin
        outfile=$fopen(errFileName,"a");
        $strobe("oc_m2v_400v   VT1T2   error limit ( %d ) reached at %7.4r  %M", maxEv, $abstime );
        $fwrite(outfile,"oc_m2v_400v   VT1T2   error limit ( %d ) reached at %7.4r  %M\n", maxEv, $abstime );
        VT1T2_cnt=VT1T2_cnt-1;
        $fclose(outfile);
      end
   end

end // analog
endmodule // oc_m2v_400v

// Verilog-A OC Watch for device oc_m6v_400v Parameters  VT1T2
module oc_m6v_400v_ahdl(T1,T2);
parameter tstep_occ=100n;
parameter errFileName="./occ.err";
parameter maxEv = 25;
parameter maxEv_flg = 0;
inout T1,T2;
electrical T1,T2;

integer outfile;
real V_T1_T2;
real VT1T2;
integer VT1T2_retc;
integer VT1T2_cnt;

analog begin
   $bound_step( tstep_occ );
   @(initial_step) begin
      VT1T2_retc=0;
      VT1T2_cnt = maxEv;
   end
   V_T1_T2 = V(T1,T2);

//      VT1T2
   VT1T2 = V_T1_T2;
   if((VT1T2_cnt>0) || ( maxEv_flg==0 ))   begin
      if( (VT1T2 < -5.5) && (VT1T2_retc!=-1))
      begin
        outfile=$fopen(errFileName,"a");
        $strobe("oc_m6v_400v   VT1T2   leaving   OCA (  .. -5.500 V ) at %7.4r  %M", $abstime );
        $fwrite(outfile,"oc_m6v_400v   VT1T2   leaving   OCA (  .. -5.500 V ) at %7.4r  %M\n", $abstime );
        VT1T2_retc=-1;
        VT1T2_cnt=VT1T2_cnt-1;
        $fclose(outfile);
      end
      if((VT1T2 >= -5.5) &&  (VT1T2 <= 400) && (VT1T2_retc!=0))
      begin
        outfile=$fopen(errFileName,"a");
        $strobe("oc_m6v_400v   VT1T2   entering SOCA ( -5.500 V .. 400.000 V ) at %7.4r  %M", $abstime );
        $fwrite(outfile,"oc_m6v_400v   VT1T2   entering SOCA ( -5.500 V .. 400.000 V ) at %7.4r  %M\n", $abstime );
        VT1T2_retc=0;
        VT1T2_cnt=VT1T2_cnt-1;
        $fclose(outfile);
      end
      if((VT1T2 > 400) &&  (VT1T2_retc!=1))
      begin
        outfile=$fopen(errFileName,"a");
        $strobe("oc_m6v_400v   VT1T2   leaving   OCA ( 400.000 V ..  ) at %7.4r  %M", $abstime );
        $fwrite(outfile,"oc_m6v_400v   VT1T2   leaving   OCA ( 400.000 V ..  ) at %7.4r  %M\n", $abstime );
        VT1T2_retc=1;
        VT1T2_cnt=VT1T2_cnt-1;
        $fclose(outfile);
      end
   end
   else
   begin
      if(VT1T2_cnt==0)
      begin
        outfile=$fopen(errFileName,"a");
        $strobe("oc_m6v_400v   VT1T2   error limit ( %d ) reached at %7.4r  %M", maxEv, $abstime );
        $fwrite(outfile,"oc_m6v_400v   VT1T2   error limit ( %d ) reached at %7.4r  %M\n", maxEv, $abstime );
        VT1T2_cnt=VT1T2_cnt-1;
        $fclose(outfile);
      end
   end

end // analog
endmodule // oc_m6v_400v

// Verilog-A OC Watch for device oc_m360v_1v Parameters  VT1T2
module oc_m360v_1v_ahdl(T1,T2);
parameter tstep_occ=100n;
parameter errFileName="./occ.err";
parameter maxEv = 25;
parameter maxEv_flg = 0;
inout T1,T2;
electrical T1,T2;

integer outfile;
real V_T1_T2;
real VT1T2;
integer VT1T2_retc;
integer VT1T2_cnt;

analog begin
   $bound_step( tstep_occ );
   @(initial_step) begin
      VT1T2_retc=0;
      VT1T2_cnt = maxEv;
   end
   V_T1_T2 = V(T1,T2);

//      VT1T2
   VT1T2 = V_T1_T2;
   if((VT1T2_cnt>0) || ( maxEv_flg==0 ))   begin
      if( (VT1T2 < -360) && (VT1T2_retc!=-1))
      begin
        outfile=$fopen(errFileName,"a");
        $strobe("oc_m360v_1v   VT1T2   leaving   OCA (  .. -360.000 V ) at %7.4r  %M", $abstime );
        $fwrite(outfile,"oc_m360v_1v   VT1T2   leaving   OCA (  .. -360.000 V ) at %7.4r  %M\n", $abstime );
        VT1T2_retc=-1;
        VT1T2_cnt=VT1T2_cnt-1;
        $fclose(outfile);
      end
      if((VT1T2 >= -360) &&  (VT1T2 <= 1) && (VT1T2_retc!=0))
      begin
        outfile=$fopen(errFileName,"a");
        $strobe("oc_m360v_1v   VT1T2   entering SOCA ( -360.000 V .. 1.000 V ) at %7.4r  %M", $abstime );
        $fwrite(outfile,"oc_m360v_1v   VT1T2   entering SOCA ( -360.000 V .. 1.000 V ) at %7.4r  %M\n", $abstime );
        VT1T2_retc=0;
        VT1T2_cnt=VT1T2_cnt-1;
        $fclose(outfile);
      end
      if((VT1T2 > 1) &&  (VT1T2_retc!=1))
      begin
        outfile=$fopen(errFileName,"a");
        $strobe("oc_m360v_1v   VT1T2   leaving   OCA ( 1.000 V ..  ) at %7.4r  %M", $abstime );
        $fwrite(outfile,"oc_m360v_1v   VT1T2   leaving   OCA ( 1.000 V ..  ) at %7.4r  %M\n", $abstime );
        VT1T2_retc=1;
        VT1T2_cnt=VT1T2_cnt-1;
        $fclose(outfile);
      end
   end
   else
   begin
      if(VT1T2_cnt==0)
      begin
        outfile=$fopen(errFileName,"a");
        $strobe("oc_m360v_1v   VT1T2   error limit ( %d ) reached at %7.4r  %M", maxEv, $abstime );
        $fwrite(outfile,"oc_m360v_1v   VT1T2   error limit ( %d ) reached at %7.4r  %M\n", maxEv, $abstime );
        VT1T2_cnt=VT1T2_cnt-1;
        $fclose(outfile);
      end
   end

end // analog
endmodule // oc_m360v_1v

// Verilog-A OC Watch for device oc_m280v_1v Parameters  VT1T2
module oc_m280v_1v_ahdl(T1,T2);
parameter tstep_occ=100n;
parameter errFileName="./occ.err";
parameter maxEv = 25;
parameter maxEv_flg = 0;
inout T1,T2;
electrical T1,T2;

integer outfile;
real V_T1_T2;
real VT1T2;
integer VT1T2_retc;
integer VT1T2_cnt;

analog begin
   $bound_step( tstep_occ );
   @(initial_step) begin
      VT1T2_retc=0;
      VT1T2_cnt = maxEv;
   end
   V_T1_T2 = V(T1,T2);

//      VT1T2
   VT1T2 = V_T1_T2;
   if((VT1T2_cnt>0) || ( maxEv_flg==0 ))   begin
      if( (VT1T2 < -280) && (VT1T2_retc!=-1))
      begin
        outfile=$fopen(errFileName,"a");
        $strobe("oc_m280v_1v   VT1T2   leaving   OCA (  .. -280.000 V ) at %7.4r  %M", $abstime );
        $fwrite(outfile,"oc_m280v_1v   VT1T2   leaving   OCA (  .. -280.000 V ) at %7.4r  %M\n", $abstime );
        VT1T2_retc=-1;
        VT1T2_cnt=VT1T2_cnt-1;
        $fclose(outfile);
      end
      if((VT1T2 >= -280) &&  (VT1T2 <= 1) && (VT1T2_retc!=0))
      begin
        outfile=$fopen(errFileName,"a");
        $strobe("oc_m280v_1v   VT1T2   entering SOCA ( -280.000 V .. 1.000 V ) at %7.4r  %M", $abstime );
        $fwrite(outfile,"oc_m280v_1v   VT1T2   entering SOCA ( -280.000 V .. 1.000 V ) at %7.4r  %M\n", $abstime );
        VT1T2_retc=0;
        VT1T2_cnt=VT1T2_cnt-1;
        $fclose(outfile);
      end
      if((VT1T2 > 1) &&  (VT1T2_retc!=1))
      begin
        outfile=$fopen(errFileName,"a");
        $strobe("oc_m280v_1v   VT1T2   leaving   OCA ( 1.000 V ..  ) at %7.4r  %M", $abstime );
        $fwrite(outfile,"oc_m280v_1v   VT1T2   leaving   OCA ( 1.000 V ..  ) at %7.4r  %M\n", $abstime );
        VT1T2_retc=1;
        VT1T2_cnt=VT1T2_cnt-1;
        $fclose(outfile);
      end
   end
   else
   begin
      if(VT1T2_cnt==0)
      begin
        outfile=$fopen(errFileName,"a");
        $strobe("oc_m280v_1v   VT1T2   error limit ( %d ) reached at %7.4r  %M", maxEv, $abstime );
        $fwrite(outfile,"oc_m280v_1v   VT1T2   error limit ( %d ) reached at %7.4r  %M\n", maxEv, $abstime );
        VT1T2_cnt=VT1T2_cnt-1;
        $fclose(outfile);
      end
   end

end // analog
endmodule // oc_m280v_1v

// Verilog-A OC Watch for device oc_m160v_1v Parameters  VT1T2
module oc_m160v_1v_ahdl(T1,T2);
parameter tstep_occ=100n;
parameter errFileName="./occ.err";
parameter maxEv = 25;
parameter maxEv_flg = 0;
inout T1,T2;
electrical T1,T2;

integer outfile;
real V_T1_T2;
real VT1T2;
integer VT1T2_retc;
integer VT1T2_cnt;

analog begin
   $bound_step( tstep_occ );
   @(initial_step) begin
      VT1T2_retc=0;
      VT1T2_cnt = maxEv;
   end
   V_T1_T2 = V(T1,T2);

//      VT1T2
   VT1T2 = V_T1_T2;
   if((VT1T2_cnt>0) || ( maxEv_flg==0 ))   begin
      if( (VT1T2 < -160) && (VT1T2_retc!=-1))
      begin
        outfile=$fopen(errFileName,"a");
        $strobe("oc_m160v_1v   VT1T2   leaving   OCA (  .. -160.000 V ) at %7.4r  %M", $abstime );
        $fwrite(outfile,"oc_m160v_1v   VT1T2   leaving   OCA (  .. -160.000 V ) at %7.4r  %M\n", $abstime );
        VT1T2_retc=-1;
        VT1T2_cnt=VT1T2_cnt-1;
        $fclose(outfile);
      end
      if((VT1T2 >= -160) &&  (VT1T2 <= 1) && (VT1T2_retc!=0))
      begin
        outfile=$fopen(errFileName,"a");
        $strobe("oc_m160v_1v   VT1T2   entering SOCA ( -160.000 V .. 1.000 V ) at %7.4r  %M", $abstime );
        $fwrite(outfile,"oc_m160v_1v   VT1T2   entering SOCA ( -160.000 V .. 1.000 V ) at %7.4r  %M\n", $abstime );
        VT1T2_retc=0;
        VT1T2_cnt=VT1T2_cnt-1;
        $fclose(outfile);
      end
      if((VT1T2 > 1) &&  (VT1T2_retc!=1))
      begin
        outfile=$fopen(errFileName,"a");
        $strobe("oc_m160v_1v   VT1T2   leaving   OCA ( 1.000 V ..  ) at %7.4r  %M", $abstime );
        $fwrite(outfile,"oc_m160v_1v   VT1T2   leaving   OCA ( 1.000 V ..  ) at %7.4r  %M\n", $abstime );
        VT1T2_retc=1;
        VT1T2_cnt=VT1T2_cnt-1;
        $fclose(outfile);
      end
   end
   else
   begin
      if(VT1T2_cnt==0)
      begin
        outfile=$fopen(errFileName,"a");
        $strobe("oc_m160v_1v   VT1T2   error limit ( %d ) reached at %7.4r  %M", maxEv, $abstime );
        $fwrite(outfile,"oc_m160v_1v   VT1T2   error limit ( %d ) reached at %7.4r  %M\n", maxEv, $abstime );
        VT1T2_cnt=VT1T2_cnt-1;
        $fclose(outfile);
      end
   end

end // analog
endmodule // oc_m160v_1v

// Verilog-A OC Watch for device oc_m200v_200v Parameters  VT1T2
module oc_m200v_200v_ahdl(T1,T2);
parameter tstep_occ=100n;
parameter errFileName="./occ.err";
parameter maxEv = 25;
parameter maxEv_flg = 0;
inout T1,T2;
electrical T1,T2;

integer outfile;
real V_T1_T2;
real VT1T2;
integer VT1T2_retc;
integer VT1T2_cnt;

analog begin
   $bound_step( tstep_occ );
   @(initial_step) begin
      VT1T2_retc=0;
      VT1T2_cnt = maxEv;
   end
   V_T1_T2 = V(T1,T2);

//      VT1T2
   VT1T2 = V_T1_T2;
   if((VT1T2_cnt>0) || ( maxEv_flg==0 ))   begin
      if( (VT1T2 < -200) && (VT1T2_retc!=-1))
      begin
        outfile=$fopen(errFileName,"a");
        $strobe("oc_m200v_200v VT1T2   leaving   OCA (  .. -200.000 V ) at %7.4r  %M", $abstime );
        $fwrite(outfile,"oc_m200v_200v VT1T2   leaving   OCA (  .. -200.000 V ) at %7.4r  %M\n", $abstime );
        VT1T2_retc=-1;
        VT1T2_cnt=VT1T2_cnt-1;
        $fclose(outfile);
      end
      if((VT1T2 >= -200) &&  (VT1T2 <= 200) && (VT1T2_retc!=0))
      begin
        outfile=$fopen(errFileName,"a");
        $strobe("oc_m200v_200v VT1T2   entering SOCA ( -200.000 V .. 200.000 V ) at %7.4r  %M", $abstime );
        $fwrite(outfile,"oc_m200v_200v VT1T2   entering SOCA ( -200.000 V .. 200.000 V ) at %7.4r  %M\n", $abstime );
        VT1T2_retc=0;
        VT1T2_cnt=VT1T2_cnt-1;
        $fclose(outfile);
      end
      if((VT1T2 > 200) &&  (VT1T2_retc!=1))
      begin
        outfile=$fopen(errFileName,"a");
        $strobe("oc_m200v_200v VT1T2   leaving   OCA ( 200.000 V ..  ) at %7.4r  %M", $abstime );
        $fwrite(outfile,"oc_m200v_200v VT1T2   leaving   OCA ( 200.000 V ..  ) at %7.4r  %M\n", $abstime );
        VT1T2_retc=1;
        VT1T2_cnt=VT1T2_cnt-1;
        $fclose(outfile);
      end
   end
   else
   begin
      if(VT1T2_cnt==0)
      begin
        outfile=$fopen(errFileName,"a");
        $strobe("oc_m200v_200v VT1T2   error limit ( %d ) reached at %7.4r  %M", maxEv, $abstime );
        $fwrite(outfile,"oc_m200v_200v VT1T2   error limit ( %d ) reached at %7.4r  %M\n", maxEv, $abstime );
        VT1T2_cnt=VT1T2_cnt-1;
        $fclose(outfile);
      end
   end

end // analog
endmodule // oc_m200v_200v

// Verilog-A OC Watch for device oc_0v_6v Parameters  VT1T2
module oc_0v_6v_ahdl(T1,T2);
parameter tstep_occ=100n;
parameter errFileName="./occ.err";
parameter maxEv = 25;
parameter maxEv_flg = 0;
inout T1,T2;
electrical T1,T2;

integer outfile;
real V_T1_T2;
real VT1T2;
integer VT1T2_retc;
integer VT1T2_cnt;

analog begin
   $bound_step( tstep_occ );
   @(initial_step) begin
      VT1T2_retc=0;
      VT1T2_cnt = maxEv;
   end
   V_T1_T2 = V(T1,T2);

//      VT1T2
   VT1T2 = V_T1_T2;
   if((VT1T2_cnt>0) || ( maxEv_flg==0 ))   begin
      if( (VT1T2 < -0.1) && (VT1T2_retc!=-1))
      begin
        outfile=$fopen(errFileName,"a");
        $strobe("oc_0v_6v      VT1T2   leaving   OCA (  .. -0.100 V ) at %7.4r  %M", $abstime );
        $fwrite(outfile,"oc_0v_6v      VT1T2   leaving   OCA (  .. -0.100 V ) at %7.4r  %M\n", $abstime );
        VT1T2_retc=-1;
        VT1T2_cnt=VT1T2_cnt-1;
        $fclose(outfile);
      end
      if((VT1T2 >= -0.1) &&  (VT1T2 <= 6) && (VT1T2_retc!=0))
      begin
        outfile=$fopen(errFileName,"a");
        $strobe("oc_0v_6v      VT1T2   entering SOCA ( -0.100 V .. 6.000 V ) at %7.4r  %M", $abstime );
        $fwrite(outfile,"oc_0v_6v      VT1T2   entering SOCA ( -0.100 V .. 6.000 V ) at %7.4r  %M\n", $abstime );
        VT1T2_retc=0;
        VT1T2_cnt=VT1T2_cnt-1;
        $fclose(outfile);
      end
      if((VT1T2 > 6) &&  (VT1T2_retc!=1))
      begin
        outfile=$fopen(errFileName,"a");
        $strobe("oc_0v_6v      VT1T2   leaving   OCA ( 6.000 V ..  ) at %7.4r  %M", $abstime );
        $fwrite(outfile,"oc_0v_6v      VT1T2   leaving   OCA ( 6.000 V ..  ) at %7.4r  %M\n", $abstime );
        VT1T2_retc=1;
        VT1T2_cnt=VT1T2_cnt-1;
        $fclose(outfile);
      end
   end
   else
   begin
      if(VT1T2_cnt==0)
      begin
        outfile=$fopen(errFileName,"a");
        $strobe("oc_0v_6v      VT1T2   error limit ( %d ) reached at %7.4r  %M", maxEv, $abstime );
        $fwrite(outfile,"oc_0v_6v      VT1T2   error limit ( %d ) reached at %7.4r  %M\n", maxEv, $abstime );
        VT1T2_cnt=VT1T2_cnt-1;
        $fclose(outfile);
      end
   end

end // analog
endmodule // oc_0v_6v

// Verilog-A OC Watch for device oc_m1v_200v Parameters  VT1T2
module oc_m1v_200v_ahdl(T1,T2);
parameter tstep_occ=100n;
parameter errFileName="./occ.err";
parameter maxEv = 25;
parameter maxEv_flg = 0;
inout T1,T2;
electrical T1,T2;

integer outfile;
real V_T1_T2;
real VT1T2;
integer VT1T2_retc;
integer VT1T2_cnt;

analog begin
   $bound_step( tstep_occ );
   @(initial_step) begin
      VT1T2_retc=0;
      VT1T2_cnt = maxEv;
   end
   V_T1_T2 = V(T1,T2);

//      VT1T2
   VT1T2 = V_T1_T2;
   if((VT1T2_cnt>0) || ( maxEv_flg==0 ))   begin
      if( (VT1T2 < -1) && (VT1T2_retc!=-1))
      begin
        outfile=$fopen(errFileName,"a");
        $strobe("oc_m1v_200v   VT1T2   leaving   OCA (  .. -1.000 V ) at %7.4r  %M", $abstime );
        $fwrite(outfile,"oc_m1v_200v   VT1T2   leaving   OCA (  .. -1.000 V ) at %7.4r  %M\n", $abstime );
        VT1T2_retc=-1;
        VT1T2_cnt=VT1T2_cnt-1;
        $fclose(outfile);
      end
      if((VT1T2 >= -1) &&  (VT1T2 <= 200) && (VT1T2_retc!=0))
      begin
        outfile=$fopen(errFileName,"a");
        $strobe("oc_m1v_200v   VT1T2   entering SOCA ( -1.000 V .. 200.000 V ) at %7.4r  %M", $abstime );
        $fwrite(outfile,"oc_m1v_200v   VT1T2   entering SOCA ( -1.000 V .. 200.000 V ) at %7.4r  %M\n", $abstime );
        VT1T2_retc=0;
        VT1T2_cnt=VT1T2_cnt-1;
        $fclose(outfile);
      end
      if((VT1T2 > 200) &&  (VT1T2_retc!=1))
      begin
        outfile=$fopen(errFileName,"a");
        $strobe("oc_m1v_200v   VT1T2   leaving   OCA ( 200.000 V ..  ) at %7.4r  %M", $abstime );
        $fwrite(outfile,"oc_m1v_200v   VT1T2   leaving   OCA ( 200.000 V ..  ) at %7.4r  %M\n", $abstime );
        VT1T2_retc=1;
        VT1T2_cnt=VT1T2_cnt-1;
        $fclose(outfile);
      end
   end
   else
   begin
      if(VT1T2_cnt==0)
      begin
        outfile=$fopen(errFileName,"a");
        $strobe("oc_m1v_200v   VT1T2   error limit ( %d ) reached at %7.4r  %M", maxEv, $abstime );
        $fwrite(outfile,"oc_m1v_200v   VT1T2   error limit ( %d ) reached at %7.4r  %M\n", maxEv, $abstime );
        VT1T2_cnt=VT1T2_cnt-1;
        $fclose(outfile);
      end
   end

end // analog
endmodule // oc_m1v_200v

// Verilog-A OC Watch for device oc_m1v_400v Parameters  VT1T2
module oc_m1v_400v_ahdl(T1,T2);
parameter tstep_occ=100n;
parameter errFileName="./occ.err";
parameter maxEv = 25;
parameter maxEv_flg = 0;
inout T1,T2;
electrical T1,T2;

integer outfile;
real V_T1_T2;
real VT1T2;
integer VT1T2_retc;
integer VT1T2_cnt;

analog begin
   $bound_step( tstep_occ );
   @(initial_step) begin
      VT1T2_retc=0;
      VT1T2_cnt = maxEv;
   end
   V_T1_T2 = V(T1,T2);

//      VT1T2
   VT1T2 = V_T1_T2;
   if((VT1T2_cnt>0) || ( maxEv_flg==0 ))   begin
      if( (VT1T2 < -1) && (VT1T2_retc!=-1))
      begin
        outfile=$fopen(errFileName,"a");
        $strobe("oc_m1v_400v   VT1T2   leaving   OCA (  .. -1.000 V ) at %7.4r  %M", $abstime );
        $fwrite(outfile,"oc_m1v_400v   VT1T2   leaving   OCA (  .. -1.000 V ) at %7.4r  %M\n", $abstime );
        VT1T2_retc=-1;
        VT1T2_cnt=VT1T2_cnt-1;
        $fclose(outfile);
      end
      if((VT1T2 >= -1) &&  (VT1T2 <= 400) && (VT1T2_retc!=0))
      begin
        outfile=$fopen(errFileName,"a");
        $strobe("oc_m1v_400v   VT1T2   entering SOCA ( -1.000 V .. 400.000 V ) at %7.4r  %M", $abstime );
        $fwrite(outfile,"oc_m1v_400v   VT1T2   entering SOCA ( -1.000 V .. 400.000 V ) at %7.4r  %M\n", $abstime );
        VT1T2_retc=0;
        VT1T2_cnt=VT1T2_cnt-1;
        $fclose(outfile);
      end
      if((VT1T2 > 400) &&  (VT1T2_retc!=1))
      begin
        outfile=$fopen(errFileName,"a");
        $strobe("oc_m1v_400v   VT1T2   leaving   OCA ( 400.000 V ..  ) at %7.4r  %M", $abstime );
        $fwrite(outfile,"oc_m1v_400v   VT1T2   leaving   OCA ( 400.000 V ..  ) at %7.4r  %M\n", $abstime );
        VT1T2_retc=1;
        VT1T2_cnt=VT1T2_cnt-1;
        $fclose(outfile);
      end
   end
   else
   begin
      if(VT1T2_cnt==0)
      begin
        outfile=$fopen(errFileName,"a");
        $strobe("oc_m1v_400v   VT1T2   error limit ( %d ) reached at %7.4r  %M", maxEv, $abstime );
        $fwrite(outfile,"oc_m1v_400v   VT1T2   error limit ( %d ) reached at %7.4r  %M\n", maxEv, $abstime );
        VT1T2_cnt=VT1T2_cnt-1;
        $fclose(outfile);
      end
   end

end // analog
endmodule // oc_m1v_400v

// Verilog-A OC Watch for device oc_m6v_200v Parameters  VT1T2
module oc_m6v_200v_ahdl(T1,T2);
parameter tstep_occ=100n;
parameter errFileName="./occ.err";
parameter maxEv = 25;
parameter maxEv_flg = 0;
inout T1,T2;
electrical T1,T2;

integer outfile;
real V_T1_T2;
real VT1T2;
integer VT1T2_retc;
integer VT1T2_cnt;

analog begin
   $bound_step( tstep_occ );
   @(initial_step) begin
      VT1T2_retc=0;
      VT1T2_cnt = maxEv;
   end
   V_T1_T2 = V(T1,T2);

//      VT1T2
   VT1T2 = V_T1_T2;
   if((VT1T2_cnt>0) || ( maxEv_flg==0 ))   begin
      if( (VT1T2 < -6.3) && (VT1T2_retc!=-1))
      begin
        outfile=$fopen(errFileName,"a");
        $strobe("oc_m6v_200v   VT1T2   leaving   OCA (  .. -6.300 V ) at %7.4r  %M", $abstime );
        $fwrite(outfile,"oc_m6v_200v   VT1T2   leaving   OCA (  .. -6.300 V ) at %7.4r  %M\n", $abstime );
        VT1T2_retc=-1;
        VT1T2_cnt=VT1T2_cnt-1;
        $fclose(outfile);
      end
      if((VT1T2 >= -6.3) &&  (VT1T2 <= 200) && (VT1T2_retc!=0))
      begin
        outfile=$fopen(errFileName,"a");
        $strobe("oc_m6v_200v   VT1T2   entering SOCA ( -6.300 V .. 200.000 V ) at %7.4r  %M", $abstime );
        $fwrite(outfile,"oc_m6v_200v   VT1T2   entering SOCA ( -6.300 V .. 200.000 V ) at %7.4r  %M\n", $abstime );
        VT1T2_retc=0;
        VT1T2_cnt=VT1T2_cnt-1;
        $fclose(outfile);
      end
      if((VT1T2 > 200) &&  (VT1T2_retc!=1))
      begin
        outfile=$fopen(errFileName,"a");
        $strobe("oc_m6v_200v   VT1T2   leaving   OCA ( 200.000 V ..  ) at %7.4r  %M", $abstime );
        $fwrite(outfile,"oc_m6v_200v   VT1T2   leaving   OCA ( 200.000 V ..  ) at %7.4r  %M\n", $abstime );
        VT1T2_retc=1;
        VT1T2_cnt=VT1T2_cnt-1;
        $fclose(outfile);
      end
   end
   else
   begin
      if(VT1T2_cnt==0)
      begin
        outfile=$fopen(errFileName,"a");
        $strobe("oc_m6v_200v   VT1T2   error limit ( %d ) reached at %7.4r  %M", maxEv, $abstime );
        $fwrite(outfile,"oc_m6v_200v   VT1T2   error limit ( %d ) reached at %7.4r  %M\n", maxEv, $abstime );
        VT1T2_cnt=VT1T2_cnt-1;
        $fclose(outfile);
      end
   end

end // analog
endmodule // oc_m6v_200v

// Verilog-A OC Watch for device oc_m25v_125v Parameters  VT1T2
module oc_m25v_125v_ahdl(T1,T2);
parameter tstep_occ=100n;
parameter errFileName="./occ.err";
parameter maxEv = 25;
parameter maxEv_flg = 0;
inout T1,T2;
electrical T1,T2;

integer outfile;
real V_T1_T2;
real VT1T2;
integer VT1T2_retc;
integer VT1T2_cnt;

analog begin
   $bound_step( tstep_occ );
   @(initial_step) begin
      VT1T2_retc=0;
      VT1T2_cnt = maxEv;
   end
   V_T1_T2 = V(T1,T2);

//      VT1T2
   VT1T2 = V_T1_T2;
   if((VT1T2_cnt>0) || ( maxEv_flg==0 ))   begin
      if( (VT1T2 < -25) && (VT1T2_retc!=-1))
      begin
        outfile=$fopen(errFileName,"a");
        $strobe("oc_m25v_125v  VT1T2   leaving   OCA (  .. -25.000 V ) at %7.4r  %M", $abstime );
        $fwrite(outfile,"oc_m25v_125v  VT1T2   leaving   OCA (  .. -25.000 V ) at %7.4r  %M\n", $abstime );
        VT1T2_retc=-1;
        VT1T2_cnt=VT1T2_cnt-1;
        $fclose(outfile);
      end
      if((VT1T2 >= -25) &&  (VT1T2 <= 125) && (VT1T2_retc!=0))
      begin
        outfile=$fopen(errFileName,"a");
        $strobe("oc_m25v_125v  VT1T2   entering SOCA ( -25.000 V .. 125.000 V ) at %7.4r  %M", $abstime );
        $fwrite(outfile,"oc_m25v_125v  VT1T2   entering SOCA ( -25.000 V .. 125.000 V ) at %7.4r  %M\n", $abstime );
        VT1T2_retc=0;
        VT1T2_cnt=VT1T2_cnt-1;
        $fclose(outfile);
      end
      if((VT1T2 > 125) &&  (VT1T2_retc!=1))
      begin
        outfile=$fopen(errFileName,"a");
        $strobe("oc_m25v_125v  VT1T2   leaving   OCA ( 125.000 V ..  ) at %7.4r  %M", $abstime );
        $fwrite(outfile,"oc_m25v_125v  VT1T2   leaving   OCA ( 125.000 V ..  ) at %7.4r  %M\n", $abstime );
        VT1T2_retc=1;
        VT1T2_cnt=VT1T2_cnt-1;
        $fclose(outfile);
      end
   end
   else
   begin
      if(VT1T2_cnt==0)
      begin
        outfile=$fopen(errFileName,"a");
        $strobe("oc_m25v_125v  VT1T2   error limit ( %d ) reached at %7.4r  %M", maxEv, $abstime );
        $fwrite(outfile,"oc_m25v_125v  VT1T2   error limit ( %d ) reached at %7.4r  %M\n", maxEv, $abstime );
        VT1T2_cnt=VT1T2_cnt-1;
        $fclose(outfile);
      end
   end

end // analog
endmodule // oc_m25v_125v

// Verilog-A OC Watch for device oc_m25v_400v Parameters  VT1T2
module oc_m25v_400v_ahdl(T1,T2);
parameter tstep_occ=100n;
parameter errFileName="./occ.err";
parameter maxEv = 25;
parameter maxEv_flg = 0;
inout T1,T2;
electrical T1,T2;

integer outfile;
real V_T1_T2;
real VT1T2;
integer VT1T2_retc;
integer VT1T2_cnt;

analog begin
   $bound_step( tstep_occ );
   @(initial_step) begin
      VT1T2_retc=0;
      VT1T2_cnt = maxEv;
   end
   V_T1_T2 = V(T1,T2);

//      VT1T2
   VT1T2 = V_T1_T2;
   if((VT1T2_cnt>0) || ( maxEv_flg==0 ))   begin
      if( (VT1T2 < -25) && (VT1T2_retc!=-1))
      begin
        outfile=$fopen(errFileName,"a");
        $strobe("oc_m25v_400v  VT1T2   leaving   OCA (  .. -25.000 V ) at %7.4r  %M", $abstime );
        $fwrite(outfile,"oc_m25v_400v  VT1T2   leaving   OCA (  .. -25.000 V ) at %7.4r  %M\n", $abstime );
        VT1T2_retc=-1;
        VT1T2_cnt=VT1T2_cnt-1;
        $fclose(outfile);
      end
      if((VT1T2 >= -25) &&  (VT1T2 <= 400) && (VT1T2_retc!=0))
      begin
        outfile=$fopen(errFileName,"a");
        $strobe("oc_m25v_400v  VT1T2   entering SOCA ( -25.000 V .. 400.000 V ) at %7.4r  %M", $abstime );
        $fwrite(outfile,"oc_m25v_400v  VT1T2   entering SOCA ( -25.000 V .. 400.000 V ) at %7.4r  %M\n", $abstime );
        VT1T2_retc=0;
        VT1T2_cnt=VT1T2_cnt-1;
        $fclose(outfile);
      end
      if((VT1T2 > 400) &&  (VT1T2_retc!=1))
      begin
        outfile=$fopen(errFileName,"a");
        $strobe("oc_m25v_400v  VT1T2   leaving   OCA ( 400.000 V ..  ) at %7.4r  %M", $abstime );
        $fwrite(outfile,"oc_m25v_400v  VT1T2   leaving   OCA ( 400.000 V ..  ) at %7.4r  %M\n", $abstime );
        VT1T2_retc=1;
        VT1T2_cnt=VT1T2_cnt-1;
        $fclose(outfile);
      end
   end
   else
   begin
      if(VT1T2_cnt==0)
      begin
        outfile=$fopen(errFileName,"a");
        $strobe("oc_m25v_400v  VT1T2   error limit ( %d ) reached at %7.4r  %M", maxEv, $abstime );
        $fwrite(outfile,"oc_m25v_400v  VT1T2   error limit ( %d ) reached at %7.4r  %M\n", maxEv, $abstime );
        VT1T2_cnt=VT1T2_cnt-1;
        $fclose(outfile);
      end
   end

end // analog
endmodule // oc_m25v_400v

// Verilog-A OC Watch for device oc_m100v_200v Parameters  VT1T2
module oc_m100v_200v_ahdl(T1,T2);
parameter tstep_occ=100n;
parameter errFileName="./occ.err";
parameter maxEv = 25;
parameter maxEv_flg = 0;
inout T1,T2;
electrical T1,T2;

integer outfile;
real V_T1_T2;
real VT1T2;
integer VT1T2_retc;
integer VT1T2_cnt;

analog begin
   $bound_step( tstep_occ );
   @(initial_step) begin
      VT1T2_retc=0;
      VT1T2_cnt = maxEv;
   end
   V_T1_T2 = V(T1,T2);

//      VT1T2
   VT1T2 = V_T1_T2;
   if((VT1T2_cnt>0) || ( maxEv_flg==0 ))   begin
      if( (VT1T2 < -100) && (VT1T2_retc!=-1))
      begin
        outfile=$fopen(errFileName,"a");
        $strobe("oc_m100v_200v VT1T2   leaving   OCA (  .. -100.000 V ) at %7.4r  %M", $abstime );
        $fwrite(outfile,"oc_m100v_200v VT1T2   leaving   OCA (  .. -100.000 V ) at %7.4r  %M\n", $abstime );
        VT1T2_retc=-1;
        VT1T2_cnt=VT1T2_cnt-1;
        $fclose(outfile);
      end
      if((VT1T2 >= -100) &&  (VT1T2 <= 200) && (VT1T2_retc!=0))
      begin
        outfile=$fopen(errFileName,"a");
        $strobe("oc_m100v_200v VT1T2   entering SOCA ( -100.000 V .. 200.000 V ) at %7.4r  %M", $abstime );
        $fwrite(outfile,"oc_m100v_200v VT1T2   entering SOCA ( -100.000 V .. 200.000 V ) at %7.4r  %M\n", $abstime );
        VT1T2_retc=0;
        VT1T2_cnt=VT1T2_cnt-1;
        $fclose(outfile);
      end
      if((VT1T2 > 200) &&  (VT1T2_retc!=1))
      begin
        outfile=$fopen(errFileName,"a");
        $strobe("oc_m100v_200v VT1T2   leaving   OCA ( 200.000 V ..  ) at %7.4r  %M", $abstime );
        $fwrite(outfile,"oc_m100v_200v VT1T2   leaving   OCA ( 200.000 V ..  ) at %7.4r  %M\n", $abstime );
        VT1T2_retc=1;
        VT1T2_cnt=VT1T2_cnt-1;
        $fclose(outfile);
      end
   end
   else
   begin
      if(VT1T2_cnt==0)
      begin
        outfile=$fopen(errFileName,"a");
        $strobe("oc_m100v_200v VT1T2   error limit ( %d ) reached at %7.4r  %M", maxEv, $abstime );
        $fwrite(outfile,"oc_m100v_200v VT1T2   error limit ( %d ) reached at %7.4r  %M\n", maxEv, $abstime );
        VT1T2_cnt=VT1T2_cnt-1;
        $fclose(outfile);
      end
   end

end // analog
endmodule // oc_m100v_200v

// Verilog-A OC Watch for device oc_m100v_60v Parameters  VT1T2
module oc_m100v_60v_ahdl(T1,T2);
parameter tstep_occ=100n;
parameter errFileName="./occ.err";
parameter maxEv = 25;
parameter maxEv_flg = 0;
inout T1,T2;
electrical T1,T2;

integer outfile;
real V_T1_T2;
real VT1T2;
integer VT1T2_retc;
integer VT1T2_cnt;

analog begin
   $bound_step( tstep_occ );
   @(initial_step) begin
      VT1T2_retc=0;
      VT1T2_cnt = maxEv;
   end
   V_T1_T2 = V(T1,T2);

//      VT1T2
   VT1T2 = V_T1_T2;
   if((VT1T2_cnt>0) || ( maxEv_flg==0 ))   begin
      if( (VT1T2 < -100) && (VT1T2_retc!=-1))
      begin
        outfile=$fopen(errFileName,"a");
        $strobe("oc_m100v_60v  VT1T2   leaving   OCA (  .. -100.000 V ) at %7.4r  %M", $abstime );
        $fwrite(outfile,"oc_m100v_60v  VT1T2   leaving   OCA (  .. -100.000 V ) at %7.4r  %M\n", $abstime );
        VT1T2_retc=-1;
        VT1T2_cnt=VT1T2_cnt-1;
        $fclose(outfile);
      end
      if((VT1T2 >= -100) &&  (VT1T2 <= 60) && (VT1T2_retc!=0))
      begin
        outfile=$fopen(errFileName,"a");
        $strobe("oc_m100v_60v  VT1T2   entering SOCA ( -100.000 V .. 60.000 V ) at %7.4r  %M", $abstime );
        $fwrite(outfile,"oc_m100v_60v  VT1T2   entering SOCA ( -100.000 V .. 60.000 V ) at %7.4r  %M\n", $abstime );
        VT1T2_retc=0;
        VT1T2_cnt=VT1T2_cnt-1;
        $fclose(outfile);
      end
      if((VT1T2 > 60) &&  (VT1T2_retc!=1))
      begin
        outfile=$fopen(errFileName,"a");
        $strobe("oc_m100v_60v  VT1T2   leaving   OCA ( 60.000 V ..  ) at %7.4r  %M", $abstime );
        $fwrite(outfile,"oc_m100v_60v  VT1T2   leaving   OCA ( 60.000 V ..  ) at %7.4r  %M\n", $abstime );
        VT1T2_retc=1;
        VT1T2_cnt=VT1T2_cnt-1;
        $fclose(outfile);
      end
   end
   else
   begin
      if(VT1T2_cnt==0)
      begin
        outfile=$fopen(errFileName,"a");
        $strobe("oc_m100v_60v  VT1T2   error limit ( %d ) reached at %7.4r  %M", maxEv, $abstime );
        $fwrite(outfile,"oc_m100v_60v  VT1T2   error limit ( %d ) reached at %7.4r  %M\n", maxEv, $abstime );
        VT1T2_cnt=VT1T2_cnt-1;
        $fclose(outfile);
      end
   end

end // analog
endmodule // oc_m100v_60v

// Verilog-A OC Watch for device oc_m106v_200v Parameters  VT1T2
module oc_m106v_200v_ahdl(T1,T2);
parameter tstep_occ=100n;
parameter errFileName="./occ.err";
parameter maxEv = 25;
parameter maxEv_flg = 0;
inout T1,T2;
electrical T1,T2;

integer outfile;
real V_T1_T2;
real VT1T2;
integer VT1T2_retc;
integer VT1T2_cnt;

analog begin
   $bound_step( tstep_occ );
   @(initial_step) begin
      VT1T2_retc=0;
      VT1T2_cnt = maxEv;
   end
   V_T1_T2 = V(T1,T2);

//      VT1T2
   VT1T2 = V_T1_T2;
   if((VT1T2_cnt>0) || ( maxEv_flg==0 ))   begin
      if( (VT1T2 < -106) && (VT1T2_retc!=-1))
      begin
        outfile=$fopen(errFileName,"a");
        $strobe("oc_m106v_200v VT1T2   leaving   OCA (  .. -106.000 V ) at %7.4r  %M", $abstime );
        $fwrite(outfile,"oc_m106v_200v VT1T2   leaving   OCA (  .. -106.000 V ) at %7.4r  %M\n", $abstime );
        VT1T2_retc=-1;
        VT1T2_cnt=VT1T2_cnt-1;
        $fclose(outfile);
      end
      if((VT1T2 >= -106) &&  (VT1T2 <= 200) && (VT1T2_retc!=0))
      begin
        outfile=$fopen(errFileName,"a");
        $strobe("oc_m106v_200v VT1T2   entering SOCA ( -106.000 V .. 200.000 V ) at %7.4r  %M", $abstime );
        $fwrite(outfile,"oc_m106v_200v VT1T2   entering SOCA ( -106.000 V .. 200.000 V ) at %7.4r  %M\n", $abstime );
        VT1T2_retc=0;
        VT1T2_cnt=VT1T2_cnt-1;
        $fclose(outfile);
      end
      if((VT1T2 > 200) &&  (VT1T2_retc!=1))
      begin
        outfile=$fopen(errFileName,"a");
        $strobe("oc_m106v_200v VT1T2   leaving   OCA ( 200.000 V ..  ) at %7.4r  %M", $abstime );
        $fwrite(outfile,"oc_m106v_200v VT1T2   leaving   OCA ( 200.000 V ..  ) at %7.4r  %M\n", $abstime );
        VT1T2_retc=1;
        VT1T2_cnt=VT1T2_cnt-1;
        $fclose(outfile);
      end
   end
   else
   begin
      if(VT1T2_cnt==0)
      begin
        outfile=$fopen(errFileName,"a");
        $strobe("oc_m106v_200v VT1T2   error limit ( %d ) reached at %7.4r  %M", maxEv, $abstime );
        $fwrite(outfile,"oc_m106v_200v VT1T2   error limit ( %d ) reached at %7.4r  %M\n", maxEv, $abstime );
        VT1T2_cnt=VT1T2_cnt-1;
        $fclose(outfile);
      end
   end

end // analog
endmodule // oc_m106v_200v

// Verilog-A OC Watch for device mosvc Parameters  VGB VBS
module mosvc_ahdl(G,B,S);
parameter tstep_occ=100n;
parameter errFileName="./occ.err";
parameter maxEv = 25;
parameter maxEv_flg = 0;
inout G,B,S;
electrical G,B,S;

integer outfile;
real V_B_S;
real V_G_B;
real VGB;
integer VGB_retc;
integer VGB_cnt;
real VBS;
integer VBS_retc;
integer VBS_cnt;

analog begin
   $bound_step( tstep_occ );
   @(initial_step) begin
      VGB_retc=0;
      VGB_cnt = maxEv;
      VBS_retc=0;
      VBS_cnt = maxEv;
   end
   V_B_S = V(B,S);
   V_G_B = V(G,B);

//      VGB
   VGB = V_G_B;
   if((VGB_cnt>0) || ( maxEv_flg==0 ))   begin
      if( (VGB < -1.98) && (VGB_retc!=-1))
      begin
        outfile=$fopen(errFileName,"a");
        $strobe("mosvc         VGB     leaving   OCA (  .. -1.980 V ) at %7.4r  %M", $abstime );
        $fwrite(outfile,"mosvc         VGB     leaving   OCA (  .. -1.980 V ) at %7.4r  %M\n", $abstime );
        VGB_retc=-1;
        VGB_cnt=VGB_cnt-1;
        $fclose(outfile);
      end
      if((VGB >= -1.98) &&  (VGB <= 1.98) && (VGB_retc!=0))
      begin
        outfile=$fopen(errFileName,"a");
        $strobe("mosvc         VGB     entering SOCA ( -1.980 V .. 1.980 V ) at %7.4r  %M", $abstime );
        $fwrite(outfile,"mosvc         VGB     entering SOCA ( -1.980 V .. 1.980 V ) at %7.4r  %M\n", $abstime );
        VGB_retc=0;
        VGB_cnt=VGB_cnt-1;
        $fclose(outfile);
      end
      if((VGB > 1.98) &&  (VGB_retc!=1))
      begin
        outfile=$fopen(errFileName,"a");
        $strobe("mosvc         VGB     leaving   OCA ( 1.980 V ..  ) at %7.4r  %M", $abstime );
        $fwrite(outfile,"mosvc         VGB     leaving   OCA ( 1.980 V ..  ) at %7.4r  %M\n", $abstime );
        VGB_retc=1;
        VGB_cnt=VGB_cnt-1;
        $fclose(outfile);
      end
   end
   else
   begin
      if(VGB_cnt==0)
      begin
        outfile=$fopen(errFileName,"a");
        $strobe("mosvc         VGB     error limit ( %d ) reached at %7.4r  %M", maxEv, $abstime );
        $fwrite(outfile,"mosvc         VGB     error limit ( %d ) reached at %7.4r  %M\n", maxEv, $abstime );
        VGB_cnt=VGB_cnt-1;
        $fclose(outfile);
      end
   end

//      VBS
   VBS = V_B_S;
   if((VBS_cnt>0) || ( maxEv_flg==0 ))   begin
      if( (VBS < -0.1) && (VBS_retc!=-1))
      begin
        outfile=$fopen(errFileName,"a");
        $strobe("mosvc         VBS     leaving   OCA (  .. -0.100 V ) at %7.4r  %M", $abstime );
        $fwrite(outfile,"mosvc         VBS     leaving   OCA (  .. -0.100 V ) at %7.4r  %M\n", $abstime );
        VBS_retc=-1;
        VBS_cnt=VBS_cnt-1;
        $fclose(outfile);
      end
      if((VBS >= -0.1) &&  (VBS <= 5.5) && (VBS_retc!=0))
      begin
        outfile=$fopen(errFileName,"a");
        $strobe("mosvc         VBS     entering SOCA ( -0.100 V .. 5.500 V ) at %7.4r  %M", $abstime );
        $fwrite(outfile,"mosvc         VBS     entering SOCA ( -0.100 V .. 5.500 V ) at %7.4r  %M\n", $abstime );
        VBS_retc=0;
        VBS_cnt=VBS_cnt-1;
        $fclose(outfile);
      end
      if((VBS > 5.5) &&  (VBS_retc!=1))
      begin
        outfile=$fopen(errFileName,"a");
        $strobe("mosvc         VBS     leaving   OCA ( 5.500 V ..  ) at %7.4r  %M", $abstime );
        $fwrite(outfile,"mosvc         VBS     leaving   OCA ( 5.500 V ..  ) at %7.4r  %M\n", $abstime );
        VBS_retc=1;
        VBS_cnt=VBS_cnt-1;
        $fclose(outfile);
      end
   end
   else
   begin
      if(VBS_cnt==0)
      begin
        outfile=$fopen(errFileName,"a");
        $strobe("mosvc         VBS     error limit ( %d ) reached at %7.4r  %M", maxEv, $abstime );
        $fwrite(outfile,"mosvc         VBS     error limit ( %d ) reached at %7.4r  %M\n", maxEv, $abstime );
        VBS_cnt=VBS_cnt-1;
        $fclose(outfile);
      end
   end

end // analog
endmodule // mosvc

// Verilog-A OC Watch for device mosvcti Parameters  VGB
module mosvcti_ahdl(G,B);
parameter tstep_occ=100n;
parameter errFileName="./occ.err";
parameter maxEv = 25;
parameter maxEv_flg = 0;
inout G,B;
electrical G,B;

integer outfile;
real V_G_B;
real VGB;
integer VGB_retc;
integer VGB_cnt;

analog begin
   $bound_step( tstep_occ );
   @(initial_step) begin
      VGB_retc=0;
      VGB_cnt = maxEv;
   end
   V_G_B = V(G,B);

//      VGB
   VGB = V_G_B;
   if((VGB_cnt>0) || ( maxEv_flg==0 ))   begin
      if( (VGB < -1.98) && (VGB_retc!=-1))
      begin
        outfile=$fopen(errFileName,"a");
        $strobe("mosvcti       VGB     leaving   OCA (  .. -1.980 V ) at %7.4r  %M", $abstime );
        $fwrite(outfile,"mosvcti       VGB     leaving   OCA (  .. -1.980 V ) at %7.4r  %M\n", $abstime );
        VGB_retc=-1;
        VGB_cnt=VGB_cnt-1;
        $fclose(outfile);
      end
      if((VGB >= -1.98) &&  (VGB <= 1.98) && (VGB_retc!=0))
      begin
        outfile=$fopen(errFileName,"a");
        $strobe("mosvcti       VGB     entering SOCA ( -1.980 V .. 1.980 V ) at %7.4r  %M", $abstime );
        $fwrite(outfile,"mosvcti       VGB     entering SOCA ( -1.980 V .. 1.980 V ) at %7.4r  %M\n", $abstime );
        VGB_retc=0;
        VGB_cnt=VGB_cnt-1;
        $fclose(outfile);
      end
      if((VGB > 1.98) &&  (VGB_retc!=1))
      begin
        outfile=$fopen(errFileName,"a");
        $strobe("mosvcti       VGB     leaving   OCA ( 1.980 V ..  ) at %7.4r  %M", $abstime );
        $fwrite(outfile,"mosvcti       VGB     leaving   OCA ( 1.980 V ..  ) at %7.4r  %M\n", $abstime );
        VGB_retc=1;
        VGB_cnt=VGB_cnt-1;
        $fclose(outfile);
      end
   end
   else
   begin
      if(VGB_cnt==0)
      begin
        outfile=$fopen(errFileName,"a");
        $strobe("mosvcti       VGB     error limit ( %d ) reached at %7.4r  %M", maxEv, $abstime );
        $fwrite(outfile,"mosvcti       VGB     error limit ( %d ) reached at %7.4r  %M\n", maxEv, $abstime );
        VGB_cnt=VGB_cnt-1;
        $fclose(outfile);
      end
   end

end // analog
endmodule // mosvcti

// Verilog-A OC Watch for device mosvc5 Parameters  VGB VBS
module mosvc5_ahdl(G,B,S);
parameter tstep_occ=100n;
parameter errFileName="./occ.err";
parameter maxEv = 25;
parameter maxEv_flg = 0;
inout G,B,S;
electrical G,B,S;

integer outfile;
real V_B_S;
real V_G_B;
real VGB;
integer VGB_retc;
integer VGB_cnt;
real VBS;
integer VBS_retc;
integer VBS_cnt;

analog begin
   $bound_step( tstep_occ );
   @(initial_step) begin
      VGB_retc=0;
      VGB_cnt = maxEv;
      VBS_retc=0;
      VBS_cnt = maxEv;
   end
   V_B_S = V(B,S);
   V_G_B = V(G,B);

//      VGB
   VGB = V_G_B;
   if((VGB_cnt>0) || ( maxEv_flg==0 ))   begin
      if( (VGB < -1.98) && (VGB_retc!=-1))
      begin
        outfile=$fopen(errFileName,"a");
        $strobe("mosvc5        VGB     leaving   OCA (  .. -1.980 V ) at %7.4r  %M", $abstime );
        $fwrite(outfile,"mosvc5        VGB     leaving   OCA (  .. -1.980 V ) at %7.4r  %M\n", $abstime );
        VGB_retc=-1;
        VGB_cnt=VGB_cnt-1;
        $fclose(outfile);
      end
      if((VGB >= -1.98) &&  (VGB <= 5.5) && (VGB_retc!=0))
      begin
        outfile=$fopen(errFileName,"a");
        $strobe("mosvc5        VGB     entering SOCA ( -1.980 V .. 5.500 V ) at %7.4r  %M", $abstime );
        $fwrite(outfile,"mosvc5        VGB     entering SOCA ( -1.980 V .. 5.500 V ) at %7.4r  %M\n", $abstime );
        VGB_retc=0;
        VGB_cnt=VGB_cnt-1;
        $fclose(outfile);
      end
      if((VGB > 5.5) &&  (VGB_retc!=1))
      begin
        outfile=$fopen(errFileName,"a");
        $strobe("mosvc5        VGB     leaving   OCA ( 5.500 V ..  ) at %7.4r  %M", $abstime );
        $fwrite(outfile,"mosvc5        VGB     leaving   OCA ( 5.500 V ..  ) at %7.4r  %M\n", $abstime );
        VGB_retc=1;
        VGB_cnt=VGB_cnt-1;
        $fclose(outfile);
      end
   end
   else
   begin
      if(VGB_cnt==0)
      begin
        outfile=$fopen(errFileName,"a");
        $strobe("mosvc5        VGB     error limit ( %d ) reached at %7.4r  %M", maxEv, $abstime );
        $fwrite(outfile,"mosvc5        VGB     error limit ( %d ) reached at %7.4r  %M\n", maxEv, $abstime );
        VGB_cnt=VGB_cnt-1;
        $fclose(outfile);
      end
   end

//      VBS
   VBS = V_B_S;
   if((VBS_cnt>0) || ( maxEv_flg==0 ))   begin
      if( (VBS < -0.1) && (VBS_retc!=-1))
      begin
        outfile=$fopen(errFileName,"a");
        $strobe("mosvc5        VBS     leaving   OCA (  .. -0.100 V ) at %7.4r  %M", $abstime );
        $fwrite(outfile,"mosvc5        VBS     leaving   OCA (  .. -0.100 V ) at %7.4r  %M\n", $abstime );
        VBS_retc=-1;
        VBS_cnt=VBS_cnt-1;
        $fclose(outfile);
      end
      if((VBS >= -0.1) &&  (VBS <= 5.5) && (VBS_retc!=0))
      begin
        outfile=$fopen(errFileName,"a");
        $strobe("mosvc5        VBS     entering SOCA ( -0.100 V .. 5.500 V ) at %7.4r  %M", $abstime );
        $fwrite(outfile,"mosvc5        VBS     entering SOCA ( -0.100 V .. 5.500 V ) at %7.4r  %M\n", $abstime );
        VBS_retc=0;
        VBS_cnt=VBS_cnt-1;
        $fclose(outfile);
      end
      if((VBS > 5.5) &&  (VBS_retc!=1))
      begin
        outfile=$fopen(errFileName,"a");
        $strobe("mosvc5        VBS     leaving   OCA ( 5.500 V ..  ) at %7.4r  %M", $abstime );
        $fwrite(outfile,"mosvc5        VBS     leaving   OCA ( 5.500 V ..  ) at %7.4r  %M\n", $abstime );
        VBS_retc=1;
        VBS_cnt=VBS_cnt-1;
        $fclose(outfile);
      end
   end
   else
   begin
      if(VBS_cnt==0)
      begin
        outfile=$fopen(errFileName,"a");
        $strobe("mosvc5        VBS     error limit ( %d ) reached at %7.4r  %M", maxEv, $abstime );
        $fwrite(outfile,"mosvc5        VBS     error limit ( %d ) reached at %7.4r  %M\n", maxEv, $abstime );
        VBS_cnt=VBS_cnt-1;
        $fclose(outfile);
      end
   end

end // analog
endmodule // mosvc5

// Verilog-A OC Watch for device mosvc5ti Parameters  VGB
module mosvc5ti_ahdl(G,B);
parameter tstep_occ=100n;
parameter errFileName="./occ.err";
parameter maxEv = 25;
parameter maxEv_flg = 0;
inout G,B;
electrical G,B;

integer outfile;
real V_G_B;
real VGB;
integer VGB_retc;
integer VGB_cnt;

analog begin
   $bound_step( tstep_occ );
   @(initial_step) begin
      VGB_retc=0;
      VGB_cnt = maxEv;
   end
   V_G_B = V(G,B);

//      VGB
   VGB = V_G_B;
   if((VGB_cnt>0) || ( maxEv_flg==0 ))   begin
      if( (VGB < -5) && (VGB_retc!=-1))
      begin
        outfile=$fopen(errFileName,"a");
        $strobe("mosvc5ti      VGB     leaving   OCA (  .. -5.000 V ) at %7.4r  %M", $abstime );
        $fwrite(outfile,"mosvc5ti      VGB     leaving   OCA (  .. -5.000 V ) at %7.4r  %M\n", $abstime );
        VGB_retc=-1;
        VGB_cnt=VGB_cnt-1;
        $fclose(outfile);
      end
      if((VGB >= -5) &&  (VGB <= 1.98) && (VGB_retc!=0))
      begin
        outfile=$fopen(errFileName,"a");
        $strobe("mosvc5ti      VGB     entering SOCA ( -5.000 V .. 1.980 V ) at %7.4r  %M", $abstime );
        $fwrite(outfile,"mosvc5ti      VGB     entering SOCA ( -5.000 V .. 1.980 V ) at %7.4r  %M\n", $abstime );
        VGB_retc=0;
        VGB_cnt=VGB_cnt-1;
        $fclose(outfile);
      end
      if((VGB > 1.98) &&  (VGB_retc!=1))
      begin
        outfile=$fopen(errFileName,"a");
        $strobe("mosvc5ti      VGB     leaving   OCA ( 1.980 V ..  ) at %7.4r  %M", $abstime );
        $fwrite(outfile,"mosvc5ti      VGB     leaving   OCA ( 1.980 V ..  ) at %7.4r  %M\n", $abstime );
        VGB_retc=1;
        VGB_cnt=VGB_cnt-1;
        $fclose(outfile);
      end
   end
   else
   begin
      if(VGB_cnt==0)
      begin
        outfile=$fopen(errFileName,"a");
        $strobe("mosvc5ti      VGB     error limit ( %d ) reached at %7.4r  %M", maxEv, $abstime );
        $fwrite(outfile,"mosvc5ti      VGB     error limit ( %d ) reached at %7.4r  %M\n", maxEv, $abstime );
        VGB_cnt=VGB_cnt-1;
        $fclose(outfile);
      end
   end

end // analog
endmodule // mosvc5ti

// Verilog-A OC Watch for device dn Parameters  VAC
module dn_ahdl(A,C);
parameter tstep_occ=100n;
parameter errFileName="./occ.err";
parameter maxEv = 25;
parameter maxEv_flg = 0;
inout A,C;
electrical A,C;

integer outfile;
real V_A_C;
real VAC;
integer VAC_retc;
integer VAC_cnt;

analog begin
   $bound_step( tstep_occ );
   @(initial_step) begin
      VAC_retc=0;
      VAC_cnt = maxEv;
   end
   V_A_C = V(A,C);

//      VAC
   VAC = V_A_C;
   if((VAC_cnt>0) || ( maxEv_flg==0 ))   begin
      if( (VAC < -1.98) && (VAC_retc!=-1))
      begin
        outfile=$fopen(errFileName,"a");
        $strobe("dn            VAC     leaving   OCA (  .. -1.980 V ) at %7.4r  %M", $abstime );
        $fwrite(outfile,"dn            VAC     leaving   OCA (  .. -1.980 V ) at %7.4r  %M\n", $abstime );
        VAC_retc=-1;
        VAC_cnt=VAC_cnt-1;
        $fclose(outfile);
      end
      if((VAC >= -1.98) &&  (VAC <= 0.1) && (VAC_retc!=0))
      begin
        outfile=$fopen(errFileName,"a");
        $strobe("dn            VAC     entering SOCA ( -1.980 V .. 0.100 V ) at %7.4r  %M", $abstime );
        $fwrite(outfile,"dn            VAC     entering SOCA ( -1.980 V .. 0.100 V ) at %7.4r  %M\n", $abstime );
        VAC_retc=0;
        VAC_cnt=VAC_cnt-1;
        $fclose(outfile);
      end
      if((VAC > 0.1) &&  (VAC_retc!=1))
      begin
        outfile=$fopen(errFileName,"a");
        $strobe("dn            VAC     leaving   OCA ( 0.100 V ..  ) at %7.4r  %M", $abstime );
        $fwrite(outfile,"dn            VAC     leaving   OCA ( 0.100 V ..  ) at %7.4r  %M\n", $abstime );
        VAC_retc=1;
        VAC_cnt=VAC_cnt-1;
        $fclose(outfile);
      end
   end
   else
   begin
      if(VAC_cnt==0)
      begin
        outfile=$fopen(errFileName,"a");
        $strobe("dn            VAC     error limit ( %d ) reached at %7.4r  %M", maxEv, $abstime );
        $fwrite(outfile,"dn            VAC     error limit ( %d ) reached at %7.4r  %M\n", maxEv, $abstime );
        VAC_cnt=VAC_cnt-1;
        $fclose(outfile);
      end
   end

end // analog
endmodule // dn

// Verilog-A OC Watch for device dnn Parameters  VAC
module dnn_ahdl(A,C);
parameter tstep_occ=100n;
parameter errFileName="./occ.err";
parameter maxEv = 25;
parameter maxEv_flg = 0;
inout A,C;
electrical A,C;

integer outfile;
real V_A_C;
real VAC;
integer VAC_retc;
integer VAC_cnt;

analog begin
   $bound_step( tstep_occ );
   @(initial_step) begin
      VAC_retc=0;
      VAC_cnt = maxEv;
   end
   V_A_C = V(A,C);

//      VAC
   VAC = V_A_C;
   if((VAC_cnt>0) || ( maxEv_flg==0 ))   begin
      if( (VAC < -1.98) && (VAC_retc!=-1))
      begin
        outfile=$fopen(errFileName,"a");
        $strobe("dnn           VAC     leaving   OCA (  .. -1.980 V ) at %7.4r  %M", $abstime );
        $fwrite(outfile,"dnn           VAC     leaving   OCA (  .. -1.980 V ) at %7.4r  %M\n", $abstime );
        VAC_retc=-1;
        VAC_cnt=VAC_cnt-1;
        $fclose(outfile);
      end
      if((VAC >= -1.98) &&  (VAC <= 0.1) && (VAC_retc!=0))
      begin
        outfile=$fopen(errFileName,"a");
        $strobe("dnn           VAC     entering SOCA ( -1.980 V .. 0.100 V ) at %7.4r  %M", $abstime );
        $fwrite(outfile,"dnn           VAC     entering SOCA ( -1.980 V .. 0.100 V ) at %7.4r  %M\n", $abstime );
        VAC_retc=0;
        VAC_cnt=VAC_cnt-1;
        $fclose(outfile);
      end
      if((VAC > 0.1) &&  (VAC_retc!=1))
      begin
        outfile=$fopen(errFileName,"a");
        $strobe("dnn           VAC     leaving   OCA ( 0.100 V ..  ) at %7.4r  %M", $abstime );
        $fwrite(outfile,"dnn           VAC     leaving   OCA ( 0.100 V ..  ) at %7.4r  %M\n", $abstime );
        VAC_retc=1;
        VAC_cnt=VAC_cnt-1;
        $fclose(outfile);
      end
   end
   else
   begin
      if(VAC_cnt==0)
      begin
        outfile=$fopen(errFileName,"a");
        $strobe("dnn           VAC     error limit ( %d ) reached at %7.4r  %M", maxEv, $abstime );
        $fwrite(outfile,"dnn           VAC     error limit ( %d ) reached at %7.4r  %M\n", maxEv, $abstime );
        VAC_cnt=VAC_cnt-1;
        $fclose(outfile);
      end
   end

end // analog
endmodule // dnn

// Verilog-A OC Watch for device dp Parameters  VAC
module dp_ahdl(A,C);
parameter tstep_occ=100n;
parameter errFileName="./occ.err";
parameter maxEv = 25;
parameter maxEv_flg = 0;
inout A,C;
electrical A,C;

integer outfile;
real V_A_C;
real VAC;
integer VAC_retc;
integer VAC_cnt;

analog begin
   $bound_step( tstep_occ );
   @(initial_step) begin
      VAC_retc=0;
      VAC_cnt = maxEv;
   end
   V_A_C = V(A,C);

//      VAC
   VAC = V_A_C;
   if((VAC_cnt>0) || ( maxEv_flg==0 ))   begin
      if( (VAC < -1.98) && (VAC_retc!=-1))
      begin
        outfile=$fopen(errFileName,"a");
        $strobe("dp            VAC     leaving   OCA (  .. -1.980 V ) at %7.4r  %M", $abstime );
        $fwrite(outfile,"dp            VAC     leaving   OCA (  .. -1.980 V ) at %7.4r  %M\n", $abstime );
        VAC_retc=-1;
        VAC_cnt=VAC_cnt-1;
        $fclose(outfile);
      end
      if((VAC >= -1.98) &&  (VAC <= 0.1) && (VAC_retc!=0))
      begin
        outfile=$fopen(errFileName,"a");
        $strobe("dp            VAC     entering SOCA ( -1.980 V .. 0.100 V ) at %7.4r  %M", $abstime );
        $fwrite(outfile,"dp            VAC     entering SOCA ( -1.980 V .. 0.100 V ) at %7.4r  %M\n", $abstime );
        VAC_retc=0;
        VAC_cnt=VAC_cnt-1;
        $fclose(outfile);
      end
      if((VAC > 0.1) &&  (VAC_retc!=1))
      begin
        outfile=$fopen(errFileName,"a");
        $strobe("dp            VAC     leaving   OCA ( 0.100 V ..  ) at %7.4r  %M", $abstime );
        $fwrite(outfile,"dp            VAC     leaving   OCA ( 0.100 V ..  ) at %7.4r  %M\n", $abstime );
        VAC_retc=1;
        VAC_cnt=VAC_cnt-1;
        $fclose(outfile);
      end
   end
   else
   begin
      if(VAC_cnt==0)
      begin
        outfile=$fopen(errFileName,"a");
        $strobe("dp            VAC     error limit ( %d ) reached at %7.4r  %M", maxEv, $abstime );
        $fwrite(outfile,"dp            VAC     error limit ( %d ) reached at %7.4r  %M\n", maxEv, $abstime );
        VAC_cnt=VAC_cnt-1;
        $fclose(outfile);
      end
   end

end // analog
endmodule // dp

// Verilog-A OC Watch for device dn5 Parameters  VAC
module dn5_ahdl(A,C);
parameter tstep_occ=100n;
parameter errFileName="./occ.err";
parameter maxEv = 25;
parameter maxEv_flg = 0;
inout A,C;
electrical A,C;

integer outfile;
real V_A_C;
real VAC;
integer VAC_retc;
integer VAC_cnt;

analog begin
   $bound_step( tstep_occ );
   @(initial_step) begin
      VAC_retc=0;
      VAC_cnt = maxEv;
   end
   V_A_C = V(A,C);

//      VAC
   VAC = V_A_C;
   if((VAC_cnt>0) || ( maxEv_flg==0 ))   begin
      if( (VAC < -5.5) && (VAC_retc!=-1))
      begin
        outfile=$fopen(errFileName,"a");
        $strobe("dn5           VAC     leaving   OCA (  .. -5.500 V ) at %7.4r  %M", $abstime );
        $fwrite(outfile,"dn5           VAC     leaving   OCA (  .. -5.500 V ) at %7.4r  %M\n", $abstime );
        VAC_retc=-1;
        VAC_cnt=VAC_cnt-1;
        $fclose(outfile);
      end
      if((VAC >= -5.5) &&  (VAC <= 0.1) && (VAC_retc!=0))
      begin
        outfile=$fopen(errFileName,"a");
        $strobe("dn5           VAC     entering SOCA ( -5.500 V .. 0.100 V ) at %7.4r  %M", $abstime );
        $fwrite(outfile,"dn5           VAC     entering SOCA ( -5.500 V .. 0.100 V ) at %7.4r  %M\n", $abstime );
        VAC_retc=0;
        VAC_cnt=VAC_cnt-1;
        $fclose(outfile);
      end
      if((VAC > 0.1) &&  (VAC_retc!=1))
      begin
        outfile=$fopen(errFileName,"a");
        $strobe("dn5           VAC     leaving   OCA ( 0.100 V ..  ) at %7.4r  %M", $abstime );
        $fwrite(outfile,"dn5           VAC     leaving   OCA ( 0.100 V ..  ) at %7.4r  %M\n", $abstime );
        VAC_retc=1;
        VAC_cnt=VAC_cnt-1;
        $fclose(outfile);
      end
   end
   else
   begin
      if(VAC_cnt==0)
      begin
        outfile=$fopen(errFileName,"a");
        $strobe("dn5           VAC     error limit ( %d ) reached at %7.4r  %M", maxEv, $abstime );
        $fwrite(outfile,"dn5           VAC     error limit ( %d ) reached at %7.4r  %M\n", maxEv, $abstime );
        VAC_cnt=VAC_cnt-1;
        $fclose(outfile);
      end
   end

end // analog
endmodule // dn5

// Verilog-A OC Watch for device dnn5 Parameters  VAC
module dnn5_ahdl(A,C);
parameter tstep_occ=100n;
parameter errFileName="./occ.err";
parameter maxEv = 25;
parameter maxEv_flg = 0;
inout A,C;
electrical A,C;

integer outfile;
real V_A_C;
real VAC;
integer VAC_retc;
integer VAC_cnt;

analog begin
   $bound_step( tstep_occ );
   @(initial_step) begin
      VAC_retc=0;
      VAC_cnt = maxEv;
   end
   V_A_C = V(A,C);

//      VAC
   VAC = V_A_C;
   if((VAC_cnt>0) || ( maxEv_flg==0 ))   begin
      if( (VAC < -5.5) && (VAC_retc!=-1))
      begin
        outfile=$fopen(errFileName,"a");
        $strobe("dnn5          VAC     leaving   OCA (  .. -5.500 V ) at %7.4r  %M", $abstime );
        $fwrite(outfile,"dnn5          VAC     leaving   OCA (  .. -5.500 V ) at %7.4r  %M\n", $abstime );
        VAC_retc=-1;
        VAC_cnt=VAC_cnt-1;
        $fclose(outfile);
      end
      if((VAC >= -5.5) &&  (VAC <= 0.1) && (VAC_retc!=0))
      begin
        outfile=$fopen(errFileName,"a");
        $strobe("dnn5          VAC     entering SOCA ( -5.500 V .. 0.100 V ) at %7.4r  %M", $abstime );
        $fwrite(outfile,"dnn5          VAC     entering SOCA ( -5.500 V .. 0.100 V ) at %7.4r  %M\n", $abstime );
        VAC_retc=0;
        VAC_cnt=VAC_cnt-1;
        $fclose(outfile);
      end
      if((VAC > 0.1) &&  (VAC_retc!=1))
      begin
        outfile=$fopen(errFileName,"a");
        $strobe("dnn5          VAC     leaving   OCA ( 0.100 V ..  ) at %7.4r  %M", $abstime );
        $fwrite(outfile,"dnn5          VAC     leaving   OCA ( 0.100 V ..  ) at %7.4r  %M\n", $abstime );
        VAC_retc=1;
        VAC_cnt=VAC_cnt-1;
        $fclose(outfile);
      end
   end
   else
   begin
      if(VAC_cnt==0)
      begin
        outfile=$fopen(errFileName,"a");
        $strobe("dnn5          VAC     error limit ( %d ) reached at %7.4r  %M", maxEv, $abstime );
        $fwrite(outfile,"dnn5          VAC     error limit ( %d ) reached at %7.4r  %M\n", maxEv, $abstime );
        VAC_cnt=VAC_cnt-1;
        $fclose(outfile);
      end
   end

end // analog
endmodule // dnn5

// Verilog-A OC Watch for device dp5 Parameters  VAC
module dp5_ahdl(A,C);
parameter tstep_occ=100n;
parameter errFileName="./occ.err";
parameter maxEv = 25;
parameter maxEv_flg = 0;
inout A,C;
electrical A,C;

integer outfile;
real V_A_C;
real VAC;
integer VAC_retc;
integer VAC_cnt;

analog begin
   $bound_step( tstep_occ );
   @(initial_step) begin
      VAC_retc=0;
      VAC_cnt = maxEv;
   end
   V_A_C = V(A,C);

//      VAC
   VAC = V_A_C;
   if((VAC_cnt>0) || ( maxEv_flg==0 ))   begin
      if( (VAC < -5.5) && (VAC_retc!=-1))
      begin
        outfile=$fopen(errFileName,"a");
        $strobe("dp5           VAC     leaving   OCA (  .. -5.500 V ) at %7.4r  %M", $abstime );
        $fwrite(outfile,"dp5           VAC     leaving   OCA (  .. -5.500 V ) at %7.4r  %M\n", $abstime );
        VAC_retc=-1;
        VAC_cnt=VAC_cnt-1;
        $fclose(outfile);
      end
      if((VAC >= -5.5) &&  (VAC <= 0.1) && (VAC_retc!=0))
      begin
        outfile=$fopen(errFileName,"a");
        $strobe("dp5           VAC     entering SOCA ( -5.500 V .. 0.100 V ) at %7.4r  %M", $abstime );
        $fwrite(outfile,"dp5           VAC     entering SOCA ( -5.500 V .. 0.100 V ) at %7.4r  %M\n", $abstime );
        VAC_retc=0;
        VAC_cnt=VAC_cnt-1;
        $fclose(outfile);
      end
      if((VAC > 0.1) &&  (VAC_retc!=1))
      begin
        outfile=$fopen(errFileName,"a");
        $strobe("dp5           VAC     leaving   OCA ( 0.100 V ..  ) at %7.4r  %M", $abstime );
        $fwrite(outfile,"dp5           VAC     leaving   OCA ( 0.100 V ..  ) at %7.4r  %M\n", $abstime );
        VAC_retc=1;
        VAC_cnt=VAC_cnt-1;
        $fclose(outfile);
      end
   end
   else
   begin
      if(VAC_cnt==0)
      begin
        outfile=$fopen(errFileName,"a");
        $strobe("dp5           VAC     error limit ( %d ) reached at %7.4r  %M", maxEv, $abstime );
        $fwrite(outfile,"dp5           VAC     error limit ( %d ) reached at %7.4r  %M\n", maxEv, $abstime );
        VAC_cnt=VAC_cnt-1;
        $fclose(outfile);
      end
   end

end // analog
endmodule // dp5

// Verilog-A OC Watch for device dnw Parameters  VAC
module dnw_ahdl(A,C);
parameter tstep_occ=100n;
parameter errFileName="./occ.err";
parameter maxEv = 25;
parameter maxEv_flg = 0;
inout A,C;
electrical A,C;

integer outfile;
real V_A_C;
real VAC;
integer VAC_retc;
integer VAC_cnt;

analog begin
   $bound_step( tstep_occ );
   @(initial_step) begin
      VAC_retc=0;
      VAC_cnt = maxEv;
   end
   V_A_C = V(A,C);

//      VAC
   VAC = V_A_C;
   if((VAC_cnt>0) || ( maxEv_flg==0 ))   begin
      if( (VAC < -5.5) && (VAC_retc!=-1))
      begin
        outfile=$fopen(errFileName,"a");
        $strobe("dnw           VAC     leaving   OCA (  .. -5.500 V ) at %7.4r  %M", $abstime );
        $fwrite(outfile,"dnw           VAC     leaving   OCA (  .. -5.500 V ) at %7.4r  %M\n", $abstime );
        VAC_retc=-1;
        VAC_cnt=VAC_cnt-1;
        $fclose(outfile);
      end
      if((VAC >= -5.5) &&  (VAC <= 0.1) && (VAC_retc!=0))
      begin
        outfile=$fopen(errFileName,"a");
        $strobe("dnw           VAC     entering SOCA ( -5.500 V .. 0.100 V ) at %7.4r  %M", $abstime );
        $fwrite(outfile,"dnw           VAC     entering SOCA ( -5.500 V .. 0.100 V ) at %7.4r  %M\n", $abstime );
        VAC_retc=0;
        VAC_cnt=VAC_cnt-1;
        $fclose(outfile);
      end
      if((VAC > 0.1) &&  (VAC_retc!=1))
      begin
        outfile=$fopen(errFileName,"a");
        $strobe("dnw           VAC     leaving   OCA ( 0.100 V ..  ) at %7.4r  %M", $abstime );
        $fwrite(outfile,"dnw           VAC     leaving   OCA ( 0.100 V ..  ) at %7.4r  %M\n", $abstime );
        VAC_retc=1;
        VAC_cnt=VAC_cnt-1;
        $fclose(outfile);
      end
   end
   else
   begin
      if(VAC_cnt==0)
      begin
        outfile=$fopen(errFileName,"a");
        $strobe("dnw           VAC     error limit ( %d ) reached at %7.4r  %M", maxEv, $abstime );
        $fwrite(outfile,"dnw           VAC     error limit ( %d ) reached at %7.4r  %M\n", maxEv, $abstime );
        VAC_cnt=VAC_cnt-1;
        $fclose(outfile);
      end
   end

end // analog
endmodule // dnw

// Verilog-A OC Watch for device dnw5 Parameters  VAC
module dnw5_ahdl(A,C);
parameter tstep_occ=100n;
parameter errFileName="./occ.err";
parameter maxEv = 25;
parameter maxEv_flg = 0;
inout A,C;
electrical A,C;

integer outfile;
real V_A_C;
real VAC;
integer VAC_retc;
integer VAC_cnt;

analog begin
   $bound_step( tstep_occ );
   @(initial_step) begin
      VAC_retc=0;
      VAC_cnt = maxEv;
   end
   V_A_C = V(A,C);

//      VAC
   VAC = V_A_C;
   if((VAC_cnt>0) || ( maxEv_flg==0 ))   begin
      if( (VAC < -5.5) && (VAC_retc!=-1))
      begin
        outfile=$fopen(errFileName,"a");
        $strobe("dnw5          VAC     leaving   OCA (  .. -5.500 V ) at %7.4r  %M", $abstime );
        $fwrite(outfile,"dnw5          VAC     leaving   OCA (  .. -5.500 V ) at %7.4r  %M\n", $abstime );
        VAC_retc=-1;
        VAC_cnt=VAC_cnt-1;
        $fclose(outfile);
      end
      if((VAC >= -5.5) &&  (VAC <= 0.1) && (VAC_retc!=0))
      begin
        outfile=$fopen(errFileName,"a");
        $strobe("dnw5          VAC     entering SOCA ( -5.500 V .. 0.100 V ) at %7.4r  %M", $abstime );
        $fwrite(outfile,"dnw5          VAC     entering SOCA ( -5.500 V .. 0.100 V ) at %7.4r  %M\n", $abstime );
        VAC_retc=0;
        VAC_cnt=VAC_cnt-1;
        $fclose(outfile);
      end
      if((VAC > 0.1) &&  (VAC_retc!=1))
      begin
        outfile=$fopen(errFileName,"a");
        $strobe("dnw5          VAC     leaving   OCA ( 0.100 V ..  ) at %7.4r  %M", $abstime );
        $fwrite(outfile,"dnw5          VAC     leaving   OCA ( 0.100 V ..  ) at %7.4r  %M\n", $abstime );
        VAC_retc=1;
        VAC_cnt=VAC_cnt-1;
        $fclose(outfile);
      end
   end
   else
   begin
      if(VAC_cnt==0)
      begin
        outfile=$fopen(errFileName,"a");
        $strobe("dnw5          VAC     error limit ( %d ) reached at %7.4r  %M", maxEv, $abstime );
        $fwrite(outfile,"dnw5          VAC     error limit ( %d ) reached at %7.4r  %M\n", maxEv, $abstime );
        VAC_cnt=VAC_cnt-1;
        $fclose(outfile);
      end
   end

end // analog
endmodule // dnw5

// Verilog-A OC Watch for device ds5 Parameters  VAC
module ds5_ahdl(A,C);
parameter tstep_occ=100n;
parameter errFileName="./occ.err";
parameter maxEv = 25;
parameter maxEv_flg = 0;
inout A,C;
electrical A,C;

integer outfile;
real V_A_C;
real VAC;
integer VAC_retc;
integer VAC_cnt;

analog begin
   $bound_step( tstep_occ );
   @(initial_step) begin
      VAC_retc=0;
      VAC_cnt = maxEv;
   end
   V_A_C = V(A,C);

//      VAC
   VAC = V_A_C;
   if((VAC_cnt>0) || ( maxEv_flg==0 ))   begin
      if( (VAC < -5.5) && (VAC_retc!=-1))
      begin
        outfile=$fopen(errFileName,"a");
        $strobe("ds5           VAC     leaving   OCA (  .. -5.500 V ) at %7.4r  %M", $abstime );
        $fwrite(outfile,"ds5           VAC     leaving   OCA (  .. -5.500 V ) at %7.4r  %M\n", $abstime );
        VAC_retc=-1;
        VAC_cnt=VAC_cnt-1;
        $fclose(outfile);
      end
      if((VAC >= -5.5) &&  (VAC <= 1.5) && (VAC_retc!=0))
      begin
        outfile=$fopen(errFileName,"a");
        $strobe("ds5           VAC     entering SOCA ( -5.500 V .. 1.500 V ) at %7.4r  %M", $abstime );
        $fwrite(outfile,"ds5           VAC     entering SOCA ( -5.500 V .. 1.500 V ) at %7.4r  %M\n", $abstime );
        VAC_retc=0;
        VAC_cnt=VAC_cnt-1;
        $fclose(outfile);
      end
      if((VAC > 1.5) &&  (VAC_retc!=1))
      begin
        outfile=$fopen(errFileName,"a");
        $strobe("ds5           VAC     leaving   OCA ( 1.500 V ..  ) at %7.4r  %M", $abstime );
        $fwrite(outfile,"ds5           VAC     leaving   OCA ( 1.500 V ..  ) at %7.4r  %M\n", $abstime );
        VAC_retc=1;
        VAC_cnt=VAC_cnt-1;
        $fclose(outfile);
      end
   end
   else
   begin
      if(VAC_cnt==0)
      begin
        outfile=$fopen(errFileName,"a");
        $strobe("ds5           VAC     error limit ( %d ) reached at %7.4r  %M", maxEv, $abstime );
        $fwrite(outfile,"ds5           VAC     error limit ( %d ) reached at %7.4r  %M\n", maxEv, $abstime );
        VAC_cnt=VAC_cnt-1;
        $fclose(outfile);
      end
   end

end // analog
endmodule // ds5

// Verilog-A OC Watch for device ds5a Parameters  VAC
module ds5a_ahdl(A,C);
parameter tstep_occ=100n;
parameter errFileName="./occ.err";
parameter maxEv = 25;
parameter maxEv_flg = 0;
inout A,C;
electrical A,C;

integer outfile;
real V_A_C;
real VAC;
integer VAC_retc;
integer VAC_cnt;

analog begin
   $bound_step( tstep_occ );
   @(initial_step) begin
      VAC_retc=0;
      VAC_cnt = maxEv;
   end
   V_A_C = V(A,C);

//      VAC
   VAC = V_A_C;
   if((VAC_cnt>0) || ( maxEv_flg==0 ))   begin
      if( (VAC < -5.5) && (VAC_retc!=-1))
      begin
        outfile=$fopen(errFileName,"a");
        $strobe("ds5a          VAC     leaving   OCA (  .. -5.500 V ) at %7.4r  %M", $abstime );
        $fwrite(outfile,"ds5a          VAC     leaving   OCA (  .. -5.500 V ) at %7.4r  %M\n", $abstime );
        VAC_retc=-1;
        VAC_cnt=VAC_cnt-1;
        $fclose(outfile);
      end
      if((VAC >= -5.5) &&  (VAC <= 1.5) && (VAC_retc!=0))
      begin
        outfile=$fopen(errFileName,"a");
        $strobe("ds5a          VAC     entering SOCA ( -5.500 V .. 1.500 V ) at %7.4r  %M", $abstime );
        $fwrite(outfile,"ds5a          VAC     entering SOCA ( -5.500 V .. 1.500 V ) at %7.4r  %M\n", $abstime );
        VAC_retc=0;
        VAC_cnt=VAC_cnt-1;
        $fclose(outfile);
      end
      if((VAC > 1.5) &&  (VAC_retc!=1))
      begin
        outfile=$fopen(errFileName,"a");
        $strobe("ds5a          VAC     leaving   OCA ( 1.500 V ..  ) at %7.4r  %M", $abstime );
        $fwrite(outfile,"ds5a          VAC     leaving   OCA ( 1.500 V ..  ) at %7.4r  %M\n", $abstime );
        VAC_retc=1;
        VAC_cnt=VAC_cnt-1;
        $fclose(outfile);
      end
   end
   else
   begin
      if(VAC_cnt==0)
      begin
        outfile=$fopen(errFileName,"a");
        $strobe("ds5a          VAC     error limit ( %d ) reached at %7.4r  %M", maxEv, $abstime );
        $fwrite(outfile,"ds5a          VAC     error limit ( %d ) reached at %7.4r  %M\n", maxEv, $abstime );
        VAC_cnt=VAC_cnt-1;
        $fclose(outfile);
      end
   end

end // analog
endmodule // ds5a

// Verilog-A OC Watch for device ds5b Parameters  VAC
module ds5b_ahdl(A,C);
parameter tstep_occ=100n;
parameter errFileName="./occ.err";
parameter maxEv = 25;
parameter maxEv_flg = 0;
inout A,C;
electrical A,C;

integer outfile;
real V_A_C;
real VAC;
integer VAC_retc;
integer VAC_cnt;

analog begin
   $bound_step( tstep_occ );
   @(initial_step) begin
      VAC_retc=0;
      VAC_cnt = maxEv;
   end
   V_A_C = V(A,C);

//      VAC
   VAC = V_A_C;
   if((VAC_cnt>0) || ( maxEv_flg==0 ))   begin
      if( (VAC < -5.5) && (VAC_retc!=-1))
      begin
        outfile=$fopen(errFileName,"a");
        $strobe("ds5b          VAC     leaving   OCA (  .. -5.500 V ) at %7.4r  %M", $abstime );
        $fwrite(outfile,"ds5b          VAC     leaving   OCA (  .. -5.500 V ) at %7.4r  %M\n", $abstime );
        VAC_retc=-1;
        VAC_cnt=VAC_cnt-1;
        $fclose(outfile);
      end
      if((VAC >= -5.5) &&  (VAC <= 1.5) && (VAC_retc!=0))
      begin
        outfile=$fopen(errFileName,"a");
        $strobe("ds5b          VAC     entering SOCA ( -5.500 V .. 1.500 V ) at %7.4r  %M", $abstime );
        $fwrite(outfile,"ds5b          VAC     entering SOCA ( -5.500 V .. 1.500 V ) at %7.4r  %M\n", $abstime );
        VAC_retc=0;
        VAC_cnt=VAC_cnt-1;
        $fclose(outfile);
      end
      if((VAC > 1.5) &&  (VAC_retc!=1))
      begin
        outfile=$fopen(errFileName,"a");
        $strobe("ds5b          VAC     leaving   OCA ( 1.500 V ..  ) at %7.4r  %M", $abstime );
        $fwrite(outfile,"ds5b          VAC     leaving   OCA ( 1.500 V ..  ) at %7.4r  %M\n", $abstime );
        VAC_retc=1;
        VAC_cnt=VAC_cnt-1;
        $fclose(outfile);
      end
   end
   else
   begin
      if(VAC_cnt==0)
      begin
        outfile=$fopen(errFileName,"a");
        $strobe("ds5b          VAC     error limit ( %d ) reached at %7.4r  %M", maxEv, $abstime );
        $fwrite(outfile,"ds5b          VAC     error limit ( %d ) reached at %7.4r  %M\n", maxEv, $abstime );
        VAC_cnt=VAC_cnt-1;
        $fclose(outfile);
      end
   end

end // analog
endmodule // ds5b

// Verilog-A OC Watch for device dfwdpa Parameters  VAC If_100n If_DC
module dfwdpa_ahdl(A1,C1,A,C);
parameter tstep_occ=100n;
parameter errFileName="./occ.err";
parameter area = 1u;
parameter m_soa = 1;
parameter maxEv = 25;
parameter maxEv_flg = 0;
inout A1,C1,A,C;
electrical A1,C1,A,C;

integer outfile;
real V_A_C;
real I_C;
real I_A;
real VAC;
integer VAC_retc;
integer VAC_cnt;
real If_100n;
integer If_100n_retc;
integer If_100n_cnt;
real If_DC;
integer If_DC_retc;
integer If_DC_cnt;

analog begin
   $bound_step( tstep_occ );
   @(initial_step) begin
      VAC_retc=0;
      VAC_cnt = maxEv;
      If_100n_retc=0;
      If_100n_cnt = maxEv;
      If_DC_retc=0;
      If_DC_cnt = maxEv;
   end
   V_A_C = V(A,C);
   I_C = I(C1,C);
   I_A = I(A1,A);

//      VAC
   VAC = V_A_C;
   if((VAC_cnt>0) || ( maxEv_flg==0 ))   begin
      if( (VAC < -5.5) && (VAC_retc!=-1))
      begin
        outfile=$fopen(errFileName,"a");
        $strobe("dfwdpa        VAC     leaving   OCA (  .. -5.500 V ) at %7.4r  %M", $abstime );
        $fwrite(outfile,"dfwdpa        VAC     leaving   OCA (  .. -5.500 V ) at %7.4r  %M\n", $abstime );
        VAC_retc=-1;
        VAC_cnt=VAC_cnt-1;
        $fclose(outfile);
      end
      if((VAC >= -5.5) &&  (VAC <= 1.5) && (VAC_retc!=0))
      begin
        outfile=$fopen(errFileName,"a");
        $strobe("dfwdpa        VAC     entering SOCA ( -5.500 V .. 1.500 V ) at %7.4r  %M", $abstime );
        $fwrite(outfile,"dfwdpa        VAC     entering SOCA ( -5.500 V .. 1.500 V ) at %7.4r  %M\n", $abstime );
        VAC_retc=0;
        VAC_cnt=VAC_cnt-1;
        $fclose(outfile);
      end
      if((VAC > 1.5) &&  (VAC_retc!=1))
      begin
        outfile=$fopen(errFileName,"a");
        $strobe("dfwdpa        VAC     leaving   OCA ( 1.500 V ..  ) at %7.4r  %M", $abstime );
        $fwrite(outfile,"dfwdpa        VAC     leaving   OCA ( 1.500 V ..  ) at %7.4r  %M\n", $abstime );
        VAC_retc=1;
        VAC_cnt=VAC_cnt-1;
        $fclose(outfile);
      end
   end
   else
   begin
      if(VAC_cnt==0)
      begin
        outfile=$fopen(errFileName,"a");
        $strobe("dfwdpa        VAC     error limit ( %d ) reached at %7.4r  %M", maxEv, $abstime );
        $fwrite(outfile,"dfwdpa        VAC     error limit ( %d ) reached at %7.4r  %M\n", maxEv, $abstime );
        VAC_cnt=VAC_cnt-1;
        $fclose(outfile);
      end
   end

//      If_100n
   If_100n = I_A /  ( m_soa * area / 1e-06 ) ;
   if((If_100n_cnt>0) || ( maxEv_flg==0 ))   begin
      if( (If_100n < -1000) && (If_100n_retc!=-1))
      begin
        outfile=$fopen(errFileName,"a");
        $strobe("dfwdpa        If_100n leaving   OCA (  .. -1.000 mA/um ) at %7.4r  %M", $abstime );
        $fwrite(outfile,"dfwdpa        If_100n leaving   OCA (  .. -1.000 mA/um ) at %7.4r  %M\n", $abstime );
        If_100n_retc=-1;
        If_100n_cnt=If_100n_cnt-1;
        $fclose(outfile);
      end
      if((If_100n >= -1000) &&  (If_100n <= 1000) && (If_100n_retc!=0))
      begin
        outfile=$fopen(errFileName,"a");
        $strobe("dfwdpa        If_100n entering SOCA ( -1.000 mA/um .. 1.000 mA/um ) at %7.4r  %M", $abstime );
        $fwrite(outfile,"dfwdpa        If_100n entering SOCA ( -1.000 mA/um .. 1.000 mA/um ) at %7.4r  %M\n", $abstime );
        If_100n_retc=0;
        If_100n_cnt=If_100n_cnt-1;
        $fclose(outfile);
      end
      if((If_100n > 1000) &&  (If_100n_retc!=1))
      begin
        outfile=$fopen(errFileName,"a");
        $strobe("dfwdpa        If_100n leaving   OCA ( 1.000 mA/um ..  ) at %7.4r  %M", $abstime );
        $fwrite(outfile,"dfwdpa        If_100n leaving   OCA ( 1.000 mA/um ..  ) at %7.4r  %M\n", $abstime );
        If_100n_retc=1;
        If_100n_cnt=If_100n_cnt-1;
        $fclose(outfile);
      end
   end
   else
   begin
      if(If_100n_cnt==0)
      begin
        outfile=$fopen(errFileName,"a");
        $strobe("dfwdpa        If_100n error limit ( %d ) reached at %7.4r  %M", maxEv, $abstime );
        $fwrite(outfile,"dfwdpa        If_100n error limit ( %d ) reached at %7.4r  %M\n", maxEv, $abstime );
        If_100n_cnt=If_100n_cnt-1;
        $fclose(outfile);
      end
   end

//      If_DC
   If_DC = I_A /  ( m_soa * area / 1e-06 ) ;
   if((If_DC_cnt>0) || ( maxEv_flg==0 ))   begin
      if( (If_DC < -1000) && (If_DC_retc!=-1))
      begin
        outfile=$fopen(errFileName,"a");
        $strobe("dfwdpa        If_DC   leaving   OCA (  .. -1.000 mA/um ) at %7.4r  %M", $abstime );
        $fwrite(outfile,"dfwdpa        If_DC   leaving   OCA (  .. -1.000 mA/um ) at %7.4r  %M\n", $abstime );
        If_DC_retc=-1;
        If_DC_cnt=If_DC_cnt-1;
        $fclose(outfile);
      end
      if((If_DC >= -1000) &&  (If_DC <= 100) && (If_DC_retc!=0))
      begin
        outfile=$fopen(errFileName,"a");
        $strobe("dfwdpa        If_DC   entering SOCA ( -1.000 mA/um .. 100.000 uA/um ) at %7.4r  %M", $abstime );
        $fwrite(outfile,"dfwdpa        If_DC   entering SOCA ( -1.000 mA/um .. 100.000 uA/um ) at %7.4r  %M\n", $abstime );
        If_DC_retc=0;
        If_DC_cnt=If_DC_cnt-1;
        $fclose(outfile);
      end
      if((If_DC > 100) &&  (If_DC_retc!=1))
      begin
        outfile=$fopen(errFileName,"a");
        $strobe("dfwdpa        If_DC   leaving   OCA ( 100.000 uA/um ..  ) at %7.4r  %M", $abstime );
        $fwrite(outfile,"dfwdpa        If_DC   leaving   OCA ( 100.000 uA/um ..  ) at %7.4r  %M\n", $abstime );
        If_DC_retc=1;
        If_DC_cnt=If_DC_cnt-1;
        $fclose(outfile);
      end
   end
   else
   begin
      if(If_DC_cnt==0)
      begin
        outfile=$fopen(errFileName,"a");
        $strobe("dfwdpa        If_DC   error limit ( %d ) reached at %7.4r  %M", maxEv, $abstime );
        $fwrite(outfile,"dfwdpa        If_DC   error limit ( %d ) reached at %7.4r  %M\n", maxEv, $abstime );
        If_DC_cnt=If_DC_cnt-1;
        $fclose(outfile);
      end
   end

end // analog
endmodule // dfwdpa

// Verilog-A OC Watch for device dfwdn5 Parameters  VAC If_100n If_DC
module dfwdn5_ahdl(A1,C1,A,C);
parameter tstep_occ=100n;
parameter errFileName="./occ.err";
parameter area = 1u;
parameter m_soa = 1;
parameter maxEv = 25;
parameter maxEv_flg = 0;
inout A1,C1,A,C;
electrical A1,C1,A,C;

integer outfile;
real V_A_C;
real I_C;
real I_A;
real VAC;
integer VAC_retc;
integer VAC_cnt;
real If_100n;
integer If_100n_retc;
integer If_100n_cnt;
real If_DC;
integer If_DC_retc;
integer If_DC_cnt;

analog begin
   $bound_step( tstep_occ );
   @(initial_step) begin
      VAC_retc=0;
      VAC_cnt = maxEv;
      If_100n_retc=0;
      If_100n_cnt = maxEv;
      If_DC_retc=0;
      If_DC_cnt = maxEv;
   end
   V_A_C = V(A,C);
   I_C = I(C1,C);
   I_A = I(A1,A);

//      VAC
   VAC = V_A_C;
   if((VAC_cnt>0) || ( maxEv_flg==0 ))   begin
      if( (VAC < -6) && (VAC_retc!=-1))
      begin
        outfile=$fopen(errFileName,"a");
        $strobe("dfwdn5        VAC     leaving   OCA (  .. -6.000 V ) at %7.4r  %M", $abstime );
        $fwrite(outfile,"dfwdn5        VAC     leaving   OCA (  .. -6.000 V ) at %7.4r  %M\n", $abstime );
        VAC_retc=-1;
        VAC_cnt=VAC_cnt-1;
        $fclose(outfile);
      end
      if((VAC >= -6) &&  (VAC <= 1.5) && (VAC_retc!=0))
      begin
        outfile=$fopen(errFileName,"a");
        $strobe("dfwdn5        VAC     entering SOCA ( -6.000 V .. 1.500 V ) at %7.4r  %M", $abstime );
        $fwrite(outfile,"dfwdn5        VAC     entering SOCA ( -6.000 V .. 1.500 V ) at %7.4r  %M\n", $abstime );
        VAC_retc=0;
        VAC_cnt=VAC_cnt-1;
        $fclose(outfile);
      end
      if((VAC > 1.5) &&  (VAC_retc!=1))
      begin
        outfile=$fopen(errFileName,"a");
        $strobe("dfwdn5        VAC     leaving   OCA ( 1.500 V ..  ) at %7.4r  %M", $abstime );
        $fwrite(outfile,"dfwdn5        VAC     leaving   OCA ( 1.500 V ..  ) at %7.4r  %M\n", $abstime );
        VAC_retc=1;
        VAC_cnt=VAC_cnt-1;
        $fclose(outfile);
      end
   end
   else
   begin
      if(VAC_cnt==0)
      begin
        outfile=$fopen(errFileName,"a");
        $strobe("dfwdn5        VAC     error limit ( %d ) reached at %7.4r  %M", maxEv, $abstime );
        $fwrite(outfile,"dfwdn5        VAC     error limit ( %d ) reached at %7.4r  %M\n", maxEv, $abstime );
        VAC_cnt=VAC_cnt-1;
        $fclose(outfile);
      end
   end

//      If_100n
   If_100n = I_A /  ( m_soa * area / 1e-06 ) ;
   if((If_100n_cnt>0) || ( maxEv_flg==0 ))   begin
      if( (If_100n < -1000) && (If_100n_retc!=-1))
      begin
        outfile=$fopen(errFileName,"a");
        $strobe("dfwdn5        If_100n leaving   OCA (  .. -1.000 mA/um ) at %7.4r  %M", $abstime );
        $fwrite(outfile,"dfwdn5        If_100n leaving   OCA (  .. -1.000 mA/um ) at %7.4r  %M\n", $abstime );
        If_100n_retc=-1;
        If_100n_cnt=If_100n_cnt-1;
        $fclose(outfile);
      end
      if((If_100n >= -1000) &&  (If_100n <= 1000) && (If_100n_retc!=0))
      begin
        outfile=$fopen(errFileName,"a");
        $strobe("dfwdn5        If_100n entering SOCA ( -1.000 mA/um .. 1.000 mA/um ) at %7.4r  %M", $abstime );
        $fwrite(outfile,"dfwdn5        If_100n entering SOCA ( -1.000 mA/um .. 1.000 mA/um ) at %7.4r  %M\n", $abstime );
        If_100n_retc=0;
        If_100n_cnt=If_100n_cnt-1;
        $fclose(outfile);
      end
      if((If_100n > 1000) &&  (If_100n_retc!=1))
      begin
        outfile=$fopen(errFileName,"a");
        $strobe("dfwdn5        If_100n leaving   OCA ( 1.000 mA/um ..  ) at %7.4r  %M", $abstime );
        $fwrite(outfile,"dfwdn5        If_100n leaving   OCA ( 1.000 mA/um ..  ) at %7.4r  %M\n", $abstime );
        If_100n_retc=1;
        If_100n_cnt=If_100n_cnt-1;
        $fclose(outfile);
      end
   end
   else
   begin
      if(If_100n_cnt==0)
      begin
        outfile=$fopen(errFileName,"a");
        $strobe("dfwdn5        If_100n error limit ( %d ) reached at %7.4r  %M", maxEv, $abstime );
        $fwrite(outfile,"dfwdn5        If_100n error limit ( %d ) reached at %7.4r  %M\n", maxEv, $abstime );
        If_100n_cnt=If_100n_cnt-1;
        $fclose(outfile);
      end
   end

//      If_DC
   If_DC = I_A /  ( m_soa * area / 1e-06 ) ;
   if((If_DC_cnt>0) || ( maxEv_flg==0 ))   begin
      if( (If_DC < -1000) && (If_DC_retc!=-1))
      begin
        outfile=$fopen(errFileName,"a");
        $strobe("dfwdn5        If_DC   leaving   OCA (  .. -1.000 mA/um ) at %7.4r  %M", $abstime );
        $fwrite(outfile,"dfwdn5        If_DC   leaving   OCA (  .. -1.000 mA/um ) at %7.4r  %M\n", $abstime );
        If_DC_retc=-1;
        If_DC_cnt=If_DC_cnt-1;
        $fclose(outfile);
      end
      if((If_DC >= -1000) &&  (If_DC <= 100) && (If_DC_retc!=0))
      begin
        outfile=$fopen(errFileName,"a");
        $strobe("dfwdn5        If_DC   entering SOCA ( -1.000 mA/um .. 100.000 uA/um ) at %7.4r  %M", $abstime );
        $fwrite(outfile,"dfwdn5        If_DC   entering SOCA ( -1.000 mA/um .. 100.000 uA/um ) at %7.4r  %M\n", $abstime );
        If_DC_retc=0;
        If_DC_cnt=If_DC_cnt-1;
        $fclose(outfile);
      end
      if((If_DC > 100) &&  (If_DC_retc!=1))
      begin
        outfile=$fopen(errFileName,"a");
        $strobe("dfwdn5        If_DC   leaving   OCA ( 100.000 uA/um ..  ) at %7.4r  %M", $abstime );
        $fwrite(outfile,"dfwdn5        If_DC   leaving   OCA ( 100.000 uA/um ..  ) at %7.4r  %M\n", $abstime );
        If_DC_retc=1;
        If_DC_cnt=If_DC_cnt-1;
        $fclose(outfile);
      end
   end
   else
   begin
      if(If_DC_cnt==0)
      begin
        outfile=$fopen(errFileName,"a");
        $strobe("dfwdn5        If_DC   error limit ( %d ) reached at %7.4r  %M", maxEv, $abstime );
        $fwrite(outfile,"dfwdn5        If_DC   error limit ( %d ) reached at %7.4r  %M\n", maxEv, $abstime );
        If_DC_cnt=If_DC_cnt-1;
        $fclose(outfile);
      end
   end

end // analog
endmodule // dfwdn5

// Verilog-A OC Watch for device dfwdnaa Parameters  VAC If_100n If_DC
module dfwdnaa_ahdl(A1,C1,A,C);
parameter tstep_occ=100n;
parameter errFileName="./occ.err";
parameter area = 1u;
parameter m_soa = 1;
parameter maxEv = 25;
parameter maxEv_flg = 0;
inout A1,C1,A,C;
electrical A1,C1,A,C;

integer outfile;
real V_A_C;
real I_C;
real I_A;
real VAC;
integer VAC_retc;
integer VAC_cnt;
real If_100n;
integer If_100n_retc;
integer If_100n_cnt;
real If_DC;
integer If_DC_retc;
integer If_DC_cnt;

analog begin
   $bound_step( tstep_occ );
   @(initial_step) begin
      VAC_retc=0;
      VAC_cnt = maxEv;
      If_100n_retc=0;
      If_100n_cnt = maxEv;
      If_DC_retc=0;
      If_DC_cnt = maxEv;
   end
   V_A_C = V(A,C);
   I_C = I(C1,C);
   I_A = I(A1,A);

//      VAC
   VAC = V_A_C;
   if((VAC_cnt>0) || ( maxEv_flg==0 ))   begin
      if( (VAC < -10) && (VAC_retc!=-1))
      begin
        outfile=$fopen(errFileName,"a");
        $strobe("dfwdnaa       VAC     leaving   OCA (  .. -10.000 V ) at %7.4r  %M", $abstime );
        $fwrite(outfile,"dfwdnaa       VAC     leaving   OCA (  .. -10.000 V ) at %7.4r  %M\n", $abstime );
        VAC_retc=-1;
        VAC_cnt=VAC_cnt-1;
        $fclose(outfile);
      end
      if((VAC >= -10) &&  (VAC <= 1.5) && (VAC_retc!=0))
      begin
        outfile=$fopen(errFileName,"a");
        $strobe("dfwdnaa       VAC     entering SOCA ( -10.000 V .. 1.500 V ) at %7.4r  %M", $abstime );
        $fwrite(outfile,"dfwdnaa       VAC     entering SOCA ( -10.000 V .. 1.500 V ) at %7.4r  %M\n", $abstime );
        VAC_retc=0;
        VAC_cnt=VAC_cnt-1;
        $fclose(outfile);
      end
      if((VAC > 1.5) &&  (VAC_retc!=1))
      begin
        outfile=$fopen(errFileName,"a");
        $strobe("dfwdnaa       VAC     leaving   OCA ( 1.500 V ..  ) at %7.4r  %M", $abstime );
        $fwrite(outfile,"dfwdnaa       VAC     leaving   OCA ( 1.500 V ..  ) at %7.4r  %M\n", $abstime );
        VAC_retc=1;
        VAC_cnt=VAC_cnt-1;
        $fclose(outfile);
      end
   end
   else
   begin
      if(VAC_cnt==0)
      begin
        outfile=$fopen(errFileName,"a");
        $strobe("dfwdnaa       VAC     error limit ( %d ) reached at %7.4r  %M", maxEv, $abstime );
        $fwrite(outfile,"dfwdnaa       VAC     error limit ( %d ) reached at %7.4r  %M\n", maxEv, $abstime );
        VAC_cnt=VAC_cnt-1;
        $fclose(outfile);
      end
   end

//      If_100n
   If_100n = I_A /  ( m_soa *  (  ( area / 9.1e-07 )  - 1e-06 )  ) ;
   if((If_100n_cnt>0) || ( maxEv_flg==0 ))   begin
      if( (If_100n < -1000) && (If_100n_retc!=-1))
      begin
        outfile=$fopen(errFileName,"a");
        $strobe("dfwdnaa       If_100n leaving   OCA (  .. -1.000 mA/um ) at %7.4r  %M", $abstime );
        $fwrite(outfile,"dfwdnaa       If_100n leaving   OCA (  .. -1.000 mA/um ) at %7.4r  %M\n", $abstime );
        If_100n_retc=-1;
        If_100n_cnt=If_100n_cnt-1;
        $fclose(outfile);
      end
      if((If_100n >= -1000) &&  (If_100n <= 1000) && (If_100n_retc!=0))
      begin
        outfile=$fopen(errFileName,"a");
        $strobe("dfwdnaa       If_100n entering SOCA ( -1.000 mA/um .. 1.000 mA/um ) at %7.4r  %M", $abstime );
        $fwrite(outfile,"dfwdnaa       If_100n entering SOCA ( -1.000 mA/um .. 1.000 mA/um ) at %7.4r  %M\n", $abstime );
        If_100n_retc=0;
        If_100n_cnt=If_100n_cnt-1;
        $fclose(outfile);
      end
      if((If_100n > 1000) &&  (If_100n_retc!=1))
      begin
        outfile=$fopen(errFileName,"a");
        $strobe("dfwdnaa       If_100n leaving   OCA ( 1.000 mA/um ..  ) at %7.4r  %M", $abstime );
        $fwrite(outfile,"dfwdnaa       If_100n leaving   OCA ( 1.000 mA/um ..  ) at %7.4r  %M\n", $abstime );
        If_100n_retc=1;
        If_100n_cnt=If_100n_cnt-1;
        $fclose(outfile);
      end
   end
   else
   begin
      if(If_100n_cnt==0)
      begin
        outfile=$fopen(errFileName,"a");
        $strobe("dfwdnaa       If_100n error limit ( %d ) reached at %7.4r  %M", maxEv, $abstime );
        $fwrite(outfile,"dfwdnaa       If_100n error limit ( %d ) reached at %7.4r  %M\n", maxEv, $abstime );
        If_100n_cnt=If_100n_cnt-1;
        $fclose(outfile);
      end
   end

//      If_DC
   If_DC = I_A /  ( m_soa *  (  ( area / 9.1e-07 )  - 1e-06 )  ) ;
   if((If_DC_cnt>0) || ( maxEv_flg==0 ))   begin
      if( (If_DC < -1000) && (If_DC_retc!=-1))
      begin
        outfile=$fopen(errFileName,"a");
        $strobe("dfwdnaa       If_DC   leaving   OCA (  .. -1.000 mA/um ) at %7.4r  %M", $abstime );
        $fwrite(outfile,"dfwdnaa       If_DC   leaving   OCA (  .. -1.000 mA/um ) at %7.4r  %M\n", $abstime );
        If_DC_retc=-1;
        If_DC_cnt=If_DC_cnt-1;
        $fclose(outfile);
      end
      if((If_DC >= -1000) &&  (If_DC <= 100) && (If_DC_retc!=0))
      begin
        outfile=$fopen(errFileName,"a");
        $strobe("dfwdnaa       If_DC   entering SOCA ( -1.000 mA/um .. 100.000 uA/um ) at %7.4r  %M", $abstime );
        $fwrite(outfile,"dfwdnaa       If_DC   entering SOCA ( -1.000 mA/um .. 100.000 uA/um ) at %7.4r  %M\n", $abstime );
        If_DC_retc=0;
        If_DC_cnt=If_DC_cnt-1;
        $fclose(outfile);
      end
      if((If_DC > 100) &&  (If_DC_retc!=1))
      begin
        outfile=$fopen(errFileName,"a");
        $strobe("dfwdnaa       If_DC   leaving   OCA ( 100.000 uA/um ..  ) at %7.4r  %M", $abstime );
        $fwrite(outfile,"dfwdnaa       If_DC   leaving   OCA ( 100.000 uA/um ..  ) at %7.4r  %M\n", $abstime );
        If_DC_retc=1;
        If_DC_cnt=If_DC_cnt-1;
        $fclose(outfile);
      end
   end
   else
   begin
      if(If_DC_cnt==0)
      begin
        outfile=$fopen(errFileName,"a");
        $strobe("dfwdnaa       If_DC   error limit ( %d ) reached at %7.4r  %M", maxEv, $abstime );
        $fwrite(outfile,"dfwdnaa       If_DC   error limit ( %d ) reached at %7.4r  %M\n", maxEv, $abstime );
        If_DC_cnt=If_DC_cnt-1;
        $fclose(outfile);
      end
   end

end // analog
endmodule // dfwdnaa

// Verilog-A OC Watch for device dfwdnab Parameters  VAC If_100n If_DC
module dfwdnab_ahdl(A1,C1,A,C);
parameter tstep_occ=100n;
parameter errFileName="./occ.err";
parameter area = 1u;
parameter m_soa = 1;
parameter maxEv = 25;
parameter maxEv_flg = 0;
inout A1,C1,A,C;
electrical A1,C1,A,C;

integer outfile;
real V_A_C;
real I_C;
real I_A;
real VAC;
integer VAC_retc;
integer VAC_cnt;
real If_100n;
integer If_100n_retc;
integer If_100n_cnt;
real If_DC;
integer If_DC_retc;
integer If_DC_cnt;

analog begin
   $bound_step( tstep_occ );
   @(initial_step) begin
      VAC_retc=0;
      VAC_cnt = maxEv;
      If_100n_retc=0;
      If_100n_cnt = maxEv;
      If_DC_retc=0;
      If_DC_cnt = maxEv;
   end
   V_A_C = V(A,C);
   I_C = I(C1,C);
   I_A = I(A1,A);

//      VAC
   VAC = V_A_C;
   if((VAC_cnt>0) || ( maxEv_flg==0 ))   begin
      if( (VAC < -10) && (VAC_retc!=-1))
      begin
        outfile=$fopen(errFileName,"a");
        $strobe("dfwdnab       VAC     leaving   OCA (  .. -10.000 V ) at %7.4r  %M", $abstime );
        $fwrite(outfile,"dfwdnab       VAC     leaving   OCA (  .. -10.000 V ) at %7.4r  %M\n", $abstime );
        VAC_retc=-1;
        VAC_cnt=VAC_cnt-1;
        $fclose(outfile);
      end
      if((VAC >= -10) &&  (VAC <= 1.5) && (VAC_retc!=0))
      begin
        outfile=$fopen(errFileName,"a");
        $strobe("dfwdnab       VAC     entering SOCA ( -10.000 V .. 1.500 V ) at %7.4r  %M", $abstime );
        $fwrite(outfile,"dfwdnab       VAC     entering SOCA ( -10.000 V .. 1.500 V ) at %7.4r  %M\n", $abstime );
        VAC_retc=0;
        VAC_cnt=VAC_cnt-1;
        $fclose(outfile);
      end
      if((VAC > 1.5) &&  (VAC_retc!=1))
      begin
        outfile=$fopen(errFileName,"a");
        $strobe("dfwdnab       VAC     leaving   OCA ( 1.500 V ..  ) at %7.4r  %M", $abstime );
        $fwrite(outfile,"dfwdnab       VAC     leaving   OCA ( 1.500 V ..  ) at %7.4r  %M\n", $abstime );
        VAC_retc=1;
        VAC_cnt=VAC_cnt-1;
        $fclose(outfile);
      end
   end
   else
   begin
      if(VAC_cnt==0)
      begin
        outfile=$fopen(errFileName,"a");
        $strobe("dfwdnab       VAC     error limit ( %d ) reached at %7.4r  %M", maxEv, $abstime );
        $fwrite(outfile,"dfwdnab       VAC     error limit ( %d ) reached at %7.4r  %M\n", maxEv, $abstime );
        VAC_cnt=VAC_cnt-1;
        $fclose(outfile);
      end
   end

//      If_100n
   If_100n = I_A /  ( m_soa *  (  ( area / 1.83e-06 )  - 1e-06 )  ) ;
   if((If_100n_cnt>0) || ( maxEv_flg==0 ))   begin
      if( (If_100n < -1000) && (If_100n_retc!=-1))
      begin
        outfile=$fopen(errFileName,"a");
        $strobe("dfwdnab       If_100n leaving   OCA (  .. -1.000 mA/um ) at %7.4r  %M", $abstime );
        $fwrite(outfile,"dfwdnab       If_100n leaving   OCA (  .. -1.000 mA/um ) at %7.4r  %M\n", $abstime );
        If_100n_retc=-1;
        If_100n_cnt=If_100n_cnt-1;
        $fclose(outfile);
      end
      if((If_100n >= -1000) &&  (If_100n <= 1000) && (If_100n_retc!=0))
      begin
        outfile=$fopen(errFileName,"a");
        $strobe("dfwdnab       If_100n entering SOCA ( -1.000 mA/um .. 1.000 mA/um ) at %7.4r  %M", $abstime );
        $fwrite(outfile,"dfwdnab       If_100n entering SOCA ( -1.000 mA/um .. 1.000 mA/um ) at %7.4r  %M\n", $abstime );
        If_100n_retc=0;
        If_100n_cnt=If_100n_cnt-1;
        $fclose(outfile);
      end
      if((If_100n > 1000) &&  (If_100n_retc!=1))
      begin
        outfile=$fopen(errFileName,"a");
        $strobe("dfwdnab       If_100n leaving   OCA ( 1.000 mA/um ..  ) at %7.4r  %M", $abstime );
        $fwrite(outfile,"dfwdnab       If_100n leaving   OCA ( 1.000 mA/um ..  ) at %7.4r  %M\n", $abstime );
        If_100n_retc=1;
        If_100n_cnt=If_100n_cnt-1;
        $fclose(outfile);
      end
   end
   else
   begin
      if(If_100n_cnt==0)
      begin
        outfile=$fopen(errFileName,"a");
        $strobe("dfwdnab       If_100n error limit ( %d ) reached at %7.4r  %M", maxEv, $abstime );
        $fwrite(outfile,"dfwdnab       If_100n error limit ( %d ) reached at %7.4r  %M\n", maxEv, $abstime );
        If_100n_cnt=If_100n_cnt-1;
        $fclose(outfile);
      end
   end

//      If_DC
   If_DC = I_A /  ( m_soa *  (  ( area / 1.83e-06 )  - 1e-06 )  ) ;
   if((If_DC_cnt>0) || ( maxEv_flg==0 ))   begin
      if( (If_DC < -1000) && (If_DC_retc!=-1))
      begin
        outfile=$fopen(errFileName,"a");
        $strobe("dfwdnab       If_DC   leaving   OCA (  .. -1.000 mA/um ) at %7.4r  %M", $abstime );
        $fwrite(outfile,"dfwdnab       If_DC   leaving   OCA (  .. -1.000 mA/um ) at %7.4r  %M\n", $abstime );
        If_DC_retc=-1;
        If_DC_cnt=If_DC_cnt-1;
        $fclose(outfile);
      end
      if((If_DC >= -1000) &&  (If_DC <= 100) && (If_DC_retc!=0))
      begin
        outfile=$fopen(errFileName,"a");
        $strobe("dfwdnab       If_DC   entering SOCA ( -1.000 mA/um .. 100.000 uA/um ) at %7.4r  %M", $abstime );
        $fwrite(outfile,"dfwdnab       If_DC   entering SOCA ( -1.000 mA/um .. 100.000 uA/um ) at %7.4r  %M\n", $abstime );
        If_DC_retc=0;
        If_DC_cnt=If_DC_cnt-1;
        $fclose(outfile);
      end
      if((If_DC > 100) &&  (If_DC_retc!=1))
      begin
        outfile=$fopen(errFileName,"a");
        $strobe("dfwdnab       If_DC   leaving   OCA ( 100.000 uA/um ..  ) at %7.4r  %M", $abstime );
        $fwrite(outfile,"dfwdnab       If_DC   leaving   OCA ( 100.000 uA/um ..  ) at %7.4r  %M\n", $abstime );
        If_DC_retc=1;
        If_DC_cnt=If_DC_cnt-1;
        $fclose(outfile);
      end
   end
   else
   begin
      if(If_DC_cnt==0)
      begin
        outfile=$fopen(errFileName,"a");
        $strobe("dfwdnab       If_DC   error limit ( %d ) reached at %7.4r  %M", maxEv, $abstime );
        $fwrite(outfile,"dfwdnab       If_DC   error limit ( %d ) reached at %7.4r  %M\n", maxEv, $abstime );
        If_DC_cnt=If_DC_cnt-1;
        $fclose(outfile);
      end
   end

end // analog
endmodule // dfwdnab

// Verilog-A OC Watch for device dfwdpaa Parameters  VAC If_100n If_DC
module dfwdpaa_ahdl(A1,C1,A,C);
parameter tstep_occ=100n;
parameter errFileName="./occ.err";
parameter area = 1u;
parameter m_soa = 1;
parameter maxEv = 25;
parameter maxEv_flg = 0;
inout A1,C1,A,C;
electrical A1,C1,A,C;

integer outfile;
real V_A_C;
real I_C;
real I_A;
real VAC;
integer VAC_retc;
integer VAC_cnt;
real If_100n;
integer If_100n_retc;
integer If_100n_cnt;
real If_DC;
integer If_DC_retc;
integer If_DC_cnt;

analog begin
   $bound_step( tstep_occ );
   @(initial_step) begin
      VAC_retc=0;
      VAC_cnt = maxEv;
      If_100n_retc=0;
      If_100n_cnt = maxEv;
      If_DC_retc=0;
      If_DC_cnt = maxEv;
   end
   V_A_C = V(A,C);
   I_C = I(C1,C);
   I_A = I(A1,A);

//      VAC
   VAC = V_A_C;
   if((VAC_cnt>0) || ( maxEv_flg==0 ))   begin
      if( (VAC < -10) && (VAC_retc!=-1))
      begin
        outfile=$fopen(errFileName,"a");
        $strobe("dfwdpaa       VAC     leaving   OCA (  .. -10.000 V ) at %7.4r  %M", $abstime );
        $fwrite(outfile,"dfwdpaa       VAC     leaving   OCA (  .. -10.000 V ) at %7.4r  %M\n", $abstime );
        VAC_retc=-1;
        VAC_cnt=VAC_cnt-1;
        $fclose(outfile);
      end
      if((VAC >= -10) &&  (VAC <= 1.5) && (VAC_retc!=0))
      begin
        outfile=$fopen(errFileName,"a");
        $strobe("dfwdpaa       VAC     entering SOCA ( -10.000 V .. 1.500 V ) at %7.4r  %M", $abstime );
        $fwrite(outfile,"dfwdpaa       VAC     entering SOCA ( -10.000 V .. 1.500 V ) at %7.4r  %M\n", $abstime );
        VAC_retc=0;
        VAC_cnt=VAC_cnt-1;
        $fclose(outfile);
      end
      if((VAC > 1.5) &&  (VAC_retc!=1))
      begin
        outfile=$fopen(errFileName,"a");
        $strobe("dfwdpaa       VAC     leaving   OCA ( 1.500 V ..  ) at %7.4r  %M", $abstime );
        $fwrite(outfile,"dfwdpaa       VAC     leaving   OCA ( 1.500 V ..  ) at %7.4r  %M\n", $abstime );
        VAC_retc=1;
        VAC_cnt=VAC_cnt-1;
        $fclose(outfile);
      end
   end
   else
   begin
      if(VAC_cnt==0)
      begin
        outfile=$fopen(errFileName,"a");
        $strobe("dfwdpaa       VAC     error limit ( %d ) reached at %7.4r  %M", maxEv, $abstime );
        $fwrite(outfile,"dfwdpaa       VAC     error limit ( %d ) reached at %7.4r  %M\n", maxEv, $abstime );
        VAC_cnt=VAC_cnt-1;
        $fclose(outfile);
      end
   end

//      If_100n
   If_100n = I_A /  ( m_soa *  (  ( area / 1.27e-06 )  - 1e-06 )  ) ;
   if((If_100n_cnt>0) || ( maxEv_flg==0 ))   begin
      if( (If_100n < -1000) && (If_100n_retc!=-1))
      begin
        outfile=$fopen(errFileName,"a");
        $strobe("dfwdpaa       If_100n leaving   OCA (  .. -1.000 mA/um ) at %7.4r  %M", $abstime );
        $fwrite(outfile,"dfwdpaa       If_100n leaving   OCA (  .. -1.000 mA/um ) at %7.4r  %M\n", $abstime );
        If_100n_retc=-1;
        If_100n_cnt=If_100n_cnt-1;
        $fclose(outfile);
      end
      if((If_100n >= -1000) &&  (If_100n <= 1000) && (If_100n_retc!=0))
      begin
        outfile=$fopen(errFileName,"a");
        $strobe("dfwdpaa       If_100n entering SOCA ( -1.000 mA/um .. 1.000 mA/um ) at %7.4r  %M", $abstime );
        $fwrite(outfile,"dfwdpaa       If_100n entering SOCA ( -1.000 mA/um .. 1.000 mA/um ) at %7.4r  %M\n", $abstime );
        If_100n_retc=0;
        If_100n_cnt=If_100n_cnt-1;
        $fclose(outfile);
      end
      if((If_100n > 1000) &&  (If_100n_retc!=1))
      begin
        outfile=$fopen(errFileName,"a");
        $strobe("dfwdpaa       If_100n leaving   OCA ( 1.000 mA/um ..  ) at %7.4r  %M", $abstime );
        $fwrite(outfile,"dfwdpaa       If_100n leaving   OCA ( 1.000 mA/um ..  ) at %7.4r  %M\n", $abstime );
        If_100n_retc=1;
        If_100n_cnt=If_100n_cnt-1;
        $fclose(outfile);
      end
   end
   else
   begin
      if(If_100n_cnt==0)
      begin
        outfile=$fopen(errFileName,"a");
        $strobe("dfwdpaa       If_100n error limit ( %d ) reached at %7.4r  %M", maxEv, $abstime );
        $fwrite(outfile,"dfwdpaa       If_100n error limit ( %d ) reached at %7.4r  %M\n", maxEv, $abstime );
        If_100n_cnt=If_100n_cnt-1;
        $fclose(outfile);
      end
   end

//      If_DC
   If_DC = I_A /  ( m_soa *  (  ( area / 1.27e-06 )  - 1e-06 )  ) ;
   if((If_DC_cnt>0) || ( maxEv_flg==0 ))   begin
      if( (If_DC < -1000) && (If_DC_retc!=-1))
      begin
        outfile=$fopen(errFileName,"a");
        $strobe("dfwdpaa       If_DC   leaving   OCA (  .. -1.000 mA/um ) at %7.4r  %M", $abstime );
        $fwrite(outfile,"dfwdpaa       If_DC   leaving   OCA (  .. -1.000 mA/um ) at %7.4r  %M\n", $abstime );
        If_DC_retc=-1;
        If_DC_cnt=If_DC_cnt-1;
        $fclose(outfile);
      end
      if((If_DC >= -1000) &&  (If_DC <= 100) && (If_DC_retc!=0))
      begin
        outfile=$fopen(errFileName,"a");
        $strobe("dfwdpaa       If_DC   entering SOCA ( -1.000 mA/um .. 100.000 uA/um ) at %7.4r  %M", $abstime );
        $fwrite(outfile,"dfwdpaa       If_DC   entering SOCA ( -1.000 mA/um .. 100.000 uA/um ) at %7.4r  %M\n", $abstime );
        If_DC_retc=0;
        If_DC_cnt=If_DC_cnt-1;
        $fclose(outfile);
      end
      if((If_DC > 100) &&  (If_DC_retc!=1))
      begin
        outfile=$fopen(errFileName,"a");
        $strobe("dfwdpaa       If_DC   leaving   OCA ( 100.000 uA/um ..  ) at %7.4r  %M", $abstime );
        $fwrite(outfile,"dfwdpaa       If_DC   leaving   OCA ( 100.000 uA/um ..  ) at %7.4r  %M\n", $abstime );
        If_DC_retc=1;
        If_DC_cnt=If_DC_cnt-1;
        $fclose(outfile);
      end
   end
   else
   begin
      if(If_DC_cnt==0)
      begin
        outfile=$fopen(errFileName,"a");
        $strobe("dfwdpaa       If_DC   error limit ( %d ) reached at %7.4r  %M", maxEv, $abstime );
        $fwrite(outfile,"dfwdpaa       If_DC   error limit ( %d ) reached at %7.4r  %M\n", maxEv, $abstime );
        If_DC_cnt=If_DC_cnt-1;
        $fclose(outfile);
      end
   end

end // analog
endmodule // dfwdpaa

// Verilog-A OC Watch for device dfwdpab Parameters  VAC If_100n If_DC
module dfwdpab_ahdl(A1,C1,A,C);
parameter tstep_occ=100n;
parameter errFileName="./occ.err";
parameter area = 1u;
parameter m_soa = 1;
parameter maxEv = 25;
parameter maxEv_flg = 0;
inout A1,C1,A,C;
electrical A1,C1,A,C;

integer outfile;
real V_A_C;
real I_C;
real I_A;
real VAC;
integer VAC_retc;
integer VAC_cnt;
real If_100n;
integer If_100n_retc;
integer If_100n_cnt;
real If_DC;
integer If_DC_retc;
integer If_DC_cnt;

analog begin
   $bound_step( tstep_occ );
   @(initial_step) begin
      VAC_retc=0;
      VAC_cnt = maxEv;
      If_100n_retc=0;
      If_100n_cnt = maxEv;
      If_DC_retc=0;
      If_DC_cnt = maxEv;
   end
   V_A_C = V(A,C);
   I_C = I(C1,C);
   I_A = I(A1,A);

//      VAC
   VAC = V_A_C;
   if((VAC_cnt>0) || ( maxEv_flg==0 ))   begin
      if( (VAC < -10) && (VAC_retc!=-1))
      begin
        outfile=$fopen(errFileName,"a");
        $strobe("dfwdpab       VAC     leaving   OCA (  .. -10.000 V ) at %7.4r  %M", $abstime );
        $fwrite(outfile,"dfwdpab       VAC     leaving   OCA (  .. -10.000 V ) at %7.4r  %M\n", $abstime );
        VAC_retc=-1;
        VAC_cnt=VAC_cnt-1;
        $fclose(outfile);
      end
      if((VAC >= -10) &&  (VAC <= 1.5) && (VAC_retc!=0))
      begin
        outfile=$fopen(errFileName,"a");
        $strobe("dfwdpab       VAC     entering SOCA ( -10.000 V .. 1.500 V ) at %7.4r  %M", $abstime );
        $fwrite(outfile,"dfwdpab       VAC     entering SOCA ( -10.000 V .. 1.500 V ) at %7.4r  %M\n", $abstime );
        VAC_retc=0;
        VAC_cnt=VAC_cnt-1;
        $fclose(outfile);
      end
      if((VAC > 1.5) &&  (VAC_retc!=1))
      begin
        outfile=$fopen(errFileName,"a");
        $strobe("dfwdpab       VAC     leaving   OCA ( 1.500 V ..  ) at %7.4r  %M", $abstime );
        $fwrite(outfile,"dfwdpab       VAC     leaving   OCA ( 1.500 V ..  ) at %7.4r  %M\n", $abstime );
        VAC_retc=1;
        VAC_cnt=VAC_cnt-1;
        $fclose(outfile);
      end
   end
   else
   begin
      if(VAC_cnt==0)
      begin
        outfile=$fopen(errFileName,"a");
        $strobe("dfwdpab       VAC     error limit ( %d ) reached at %7.4r  %M", maxEv, $abstime );
        $fwrite(outfile,"dfwdpab       VAC     error limit ( %d ) reached at %7.4r  %M\n", maxEv, $abstime );
        VAC_cnt=VAC_cnt-1;
        $fclose(outfile);
      end
   end

//      If_100n
   If_100n = I_A /  ( m_soa *  (  ( area / 1.27e-06 )  - 1e-06 )  ) ;
   if((If_100n_cnt>0) || ( maxEv_flg==0 ))   begin
      if( (If_100n < -1000) && (If_100n_retc!=-1))
      begin
        outfile=$fopen(errFileName,"a");
        $strobe("dfwdpab       If_100n leaving   OCA (  .. -1.000 mA/um ) at %7.4r  %M", $abstime );
        $fwrite(outfile,"dfwdpab       If_100n leaving   OCA (  .. -1.000 mA/um ) at %7.4r  %M\n", $abstime );
        If_100n_retc=-1;
        If_100n_cnt=If_100n_cnt-1;
        $fclose(outfile);
      end
      if((If_100n >= -1000) &&  (If_100n <= 1000) && (If_100n_retc!=0))
      begin
        outfile=$fopen(errFileName,"a");
        $strobe("dfwdpab       If_100n entering SOCA ( -1.000 mA/um .. 1.000 mA/um ) at %7.4r  %M", $abstime );
        $fwrite(outfile,"dfwdpab       If_100n entering SOCA ( -1.000 mA/um .. 1.000 mA/um ) at %7.4r  %M\n", $abstime );
        If_100n_retc=0;
        If_100n_cnt=If_100n_cnt-1;
        $fclose(outfile);
      end
      if((If_100n > 1000) &&  (If_100n_retc!=1))
      begin
        outfile=$fopen(errFileName,"a");
        $strobe("dfwdpab       If_100n leaving   OCA ( 1.000 mA/um ..  ) at %7.4r  %M", $abstime );
        $fwrite(outfile,"dfwdpab       If_100n leaving   OCA ( 1.000 mA/um ..  ) at %7.4r  %M\n", $abstime );
        If_100n_retc=1;
        If_100n_cnt=If_100n_cnt-1;
        $fclose(outfile);
      end
   end
   else
   begin
      if(If_100n_cnt==0)
      begin
        outfile=$fopen(errFileName,"a");
        $strobe("dfwdpab       If_100n error limit ( %d ) reached at %7.4r  %M", maxEv, $abstime );
        $fwrite(outfile,"dfwdpab       If_100n error limit ( %d ) reached at %7.4r  %M\n", maxEv, $abstime );
        If_100n_cnt=If_100n_cnt-1;
        $fclose(outfile);
      end
   end

//      If_DC
   If_DC = I_A /  ( m_soa *  (  ( area / 1.27e-06 )  - 1e-06 )  ) ;
   if((If_DC_cnt>0) || ( maxEv_flg==0 ))   begin
      if( (If_DC < -1000) && (If_DC_retc!=-1))
      begin
        outfile=$fopen(errFileName,"a");
        $strobe("dfwdpab       If_DC   leaving   OCA (  .. -1.000 mA/um ) at %7.4r  %M", $abstime );
        $fwrite(outfile,"dfwdpab       If_DC   leaving   OCA (  .. -1.000 mA/um ) at %7.4r  %M\n", $abstime );
        If_DC_retc=-1;
        If_DC_cnt=If_DC_cnt-1;
        $fclose(outfile);
      end
      if((If_DC >= -1000) &&  (If_DC <= 100) && (If_DC_retc!=0))
      begin
        outfile=$fopen(errFileName,"a");
        $strobe("dfwdpab       If_DC   entering SOCA ( -1.000 mA/um .. 100.000 uA/um ) at %7.4r  %M", $abstime );
        $fwrite(outfile,"dfwdpab       If_DC   entering SOCA ( -1.000 mA/um .. 100.000 uA/um ) at %7.4r  %M\n", $abstime );
        If_DC_retc=0;
        If_DC_cnt=If_DC_cnt-1;
        $fclose(outfile);
      end
      if((If_DC > 100) &&  (If_DC_retc!=1))
      begin
        outfile=$fopen(errFileName,"a");
        $strobe("dfwdpab       If_DC   leaving   OCA ( 100.000 uA/um ..  ) at %7.4r  %M", $abstime );
        $fwrite(outfile,"dfwdpab       If_DC   leaving   OCA ( 100.000 uA/um ..  ) at %7.4r  %M\n", $abstime );
        If_DC_retc=1;
        If_DC_cnt=If_DC_cnt-1;
        $fclose(outfile);
      end
   end
   else
   begin
      if(If_DC_cnt==0)
      begin
        outfile=$fopen(errFileName,"a");
        $strobe("dfwdpab       If_DC   error limit ( %d ) reached at %7.4r  %M", maxEv, $abstime );
        $fwrite(outfile,"dfwdpab       If_DC   error limit ( %d ) reached at %7.4r  %M\n", maxEv, $abstime );
        If_DC_cnt=If_DC_cnt-1;
        $fclose(outfile);
      end
   end

end // analog
endmodule // dfwdpab

// Verilog-A OC Watch for device dfwdnb Parameters  VAC If_100n If_DC
module dfwdnb_ahdl(A1,C1,A,C);
parameter tstep_occ=100n;
parameter errFileName="./occ.err";
parameter area = 1u;
parameter m_soa = 1;
parameter maxEv = 25;
parameter maxEv_flg = 0;
inout A1,C1,A,C;
electrical A1,C1,A,C;

integer outfile;
real V_A_C;
real I_C;
real I_A;
real VAC;
integer VAC_retc;
integer VAC_cnt;
real If_100n;
integer If_100n_retc;
integer If_100n_cnt;
real If_DC;
integer If_DC_retc;
integer If_DC_cnt;

analog begin
   $bound_step( tstep_occ );
   @(initial_step) begin
      VAC_retc=0;
      VAC_cnt = maxEv;
      If_100n_retc=0;
      If_100n_cnt = maxEv;
      If_DC_retc=0;
      If_DC_cnt = maxEv;
   end
   V_A_C = V(A,C);
   I_C = I(C1,C);
   I_A = I(A1,A);

//      VAC
   VAC = V_A_C;
   if((VAC_cnt>0) || ( maxEv_flg==0 ))   begin
      if( (VAC < -12) && (VAC_retc!=-1))
      begin
        outfile=$fopen(errFileName,"a");
        $strobe("dfwdnb        VAC     leaving   OCA (  .. -12.000 V ) at %7.4r  %M", $abstime );
        $fwrite(outfile,"dfwdnb        VAC     leaving   OCA (  .. -12.000 V ) at %7.4r  %M\n", $abstime );
        VAC_retc=-1;
        VAC_cnt=VAC_cnt-1;
        $fclose(outfile);
      end
      if((VAC >= -12) &&  (VAC <= 1.5) && (VAC_retc!=0))
      begin
        outfile=$fopen(errFileName,"a");
        $strobe("dfwdnb        VAC     entering SOCA ( -12.000 V .. 1.500 V ) at %7.4r  %M", $abstime );
        $fwrite(outfile,"dfwdnb        VAC     entering SOCA ( -12.000 V .. 1.500 V ) at %7.4r  %M\n", $abstime );
        VAC_retc=0;
        VAC_cnt=VAC_cnt-1;
        $fclose(outfile);
      end
      if((VAC > 1.5) &&  (VAC_retc!=1))
      begin
        outfile=$fopen(errFileName,"a");
        $strobe("dfwdnb        VAC     leaving   OCA ( 1.500 V ..  ) at %7.4r  %M", $abstime );
        $fwrite(outfile,"dfwdnb        VAC     leaving   OCA ( 1.500 V ..  ) at %7.4r  %M\n", $abstime );
        VAC_retc=1;
        VAC_cnt=VAC_cnt-1;
        $fclose(outfile);
      end
   end
   else
   begin
      if(VAC_cnt==0)
      begin
        outfile=$fopen(errFileName,"a");
        $strobe("dfwdnb        VAC     error limit ( %d ) reached at %7.4r  %M", maxEv, $abstime );
        $fwrite(outfile,"dfwdnb        VAC     error limit ( %d ) reached at %7.4r  %M\n", maxEv, $abstime );
        VAC_cnt=VAC_cnt-1;
        $fclose(outfile);
      end
   end

//      If_100n
   If_100n = I_A /  ( m_soa * area / 9.8e-07 ) ;
   if((If_100n_cnt>0) || ( maxEv_flg==0 ))   begin
      if( (If_100n < -1000) && (If_100n_retc!=-1))
      begin
        outfile=$fopen(errFileName,"a");
        $strobe("dfwdnb        If_100n leaving   OCA (  .. -1.000 mA/um ) at %7.4r  %M", $abstime );
        $fwrite(outfile,"dfwdnb        If_100n leaving   OCA (  .. -1.000 mA/um ) at %7.4r  %M\n", $abstime );
        If_100n_retc=-1;
        If_100n_cnt=If_100n_cnt-1;
        $fclose(outfile);
      end
      if((If_100n >= -1000) &&  (If_100n <= 1000) && (If_100n_retc!=0))
      begin
        outfile=$fopen(errFileName,"a");
        $strobe("dfwdnb        If_100n entering SOCA ( -1.000 mA/um .. 1.000 mA/um ) at %7.4r  %M", $abstime );
        $fwrite(outfile,"dfwdnb        If_100n entering SOCA ( -1.000 mA/um .. 1.000 mA/um ) at %7.4r  %M\n", $abstime );
        If_100n_retc=0;
        If_100n_cnt=If_100n_cnt-1;
        $fclose(outfile);
      end
      if((If_100n > 1000) &&  (If_100n_retc!=1))
      begin
        outfile=$fopen(errFileName,"a");
        $strobe("dfwdnb        If_100n leaving   OCA ( 1.000 mA/um ..  ) at %7.4r  %M", $abstime );
        $fwrite(outfile,"dfwdnb        If_100n leaving   OCA ( 1.000 mA/um ..  ) at %7.4r  %M\n", $abstime );
        If_100n_retc=1;
        If_100n_cnt=If_100n_cnt-1;
        $fclose(outfile);
      end
   end
   else
   begin
      if(If_100n_cnt==0)
      begin
        outfile=$fopen(errFileName,"a");
        $strobe("dfwdnb        If_100n error limit ( %d ) reached at %7.4r  %M", maxEv, $abstime );
        $fwrite(outfile,"dfwdnb        If_100n error limit ( %d ) reached at %7.4r  %M\n", maxEv, $abstime );
        If_100n_cnt=If_100n_cnt-1;
        $fclose(outfile);
      end
   end

//      If_DC
   If_DC = I_A /  ( m_soa * area / 9.8e-07 ) ;
   if((If_DC_cnt>0) || ( maxEv_flg==0 ))   begin
      if( (If_DC < -1000) && (If_DC_retc!=-1))
      begin
        outfile=$fopen(errFileName,"a");
        $strobe("dfwdnb        If_DC   leaving   OCA (  .. -1.000 mA/um ) at %7.4r  %M", $abstime );
        $fwrite(outfile,"dfwdnb        If_DC   leaving   OCA (  .. -1.000 mA/um ) at %7.4r  %M\n", $abstime );
        If_DC_retc=-1;
        If_DC_cnt=If_DC_cnt-1;
        $fclose(outfile);
      end
      if((If_DC >= -1000) &&  (If_DC <= 100) && (If_DC_retc!=0))
      begin
        outfile=$fopen(errFileName,"a");
        $strobe("dfwdnb        If_DC   entering SOCA ( -1.000 mA/um .. 100.000 uA/um ) at %7.4r  %M", $abstime );
        $fwrite(outfile,"dfwdnb        If_DC   entering SOCA ( -1.000 mA/um .. 100.000 uA/um ) at %7.4r  %M\n", $abstime );
        If_DC_retc=0;
        If_DC_cnt=If_DC_cnt-1;
        $fclose(outfile);
      end
      if((If_DC > 100) &&  (If_DC_retc!=1))
      begin
        outfile=$fopen(errFileName,"a");
        $strobe("dfwdnb        If_DC   leaving   OCA ( 100.000 uA/um ..  ) at %7.4r  %M", $abstime );
        $fwrite(outfile,"dfwdnb        If_DC   leaving   OCA ( 100.000 uA/um ..  ) at %7.4r  %M\n", $abstime );
        If_DC_retc=1;
        If_DC_cnt=If_DC_cnt-1;
        $fclose(outfile);
      end
   end
   else
   begin
      if(If_DC_cnt==0)
      begin
        outfile=$fopen(errFileName,"a");
        $strobe("dfwdnb        If_DC   error limit ( %d ) reached at %7.4r  %M", maxEv, $abstime );
        $fwrite(outfile,"dfwdnb        If_DC   error limit ( %d ) reached at %7.4r  %M\n", maxEv, $abstime );
        If_DC_cnt=If_DC_cnt-1;
        $fclose(outfile);
      end
   end

end // analog
endmodule // dfwdnb

// Verilog-A OC Watch for device dfwdnc Parameters  VAC If_100n If_DC
module dfwdnc_ahdl(A1,C1,A,C);
parameter tstep_occ=100n;
parameter errFileName="./occ.err";
parameter area = 1u;
parameter m_soa = 1;
parameter maxEv = 25;
parameter maxEv_flg = 0;
inout A1,C1,A,C;
electrical A1,C1,A,C;

integer outfile;
real V_A_C;
real I_C;
real I_A;
real VAC;
integer VAC_retc;
integer VAC_cnt;
real If_100n;
integer If_100n_retc;
integer If_100n_cnt;
real If_DC;
integer If_DC_retc;
integer If_DC_cnt;

analog begin
   $bound_step( tstep_occ );
   @(initial_step) begin
      VAC_retc=0;
      VAC_cnt = maxEv;
      If_100n_retc=0;
      If_100n_cnt = maxEv;
      If_DC_retc=0;
      If_DC_cnt = maxEv;
   end
   V_A_C = V(A,C);
   I_C = I(C1,C);
   I_A = I(A1,A);

//      VAC
   VAC = V_A_C;
   if((VAC_cnt>0) || ( maxEv_flg==0 ))   begin
      if( (VAC < -15) && (VAC_retc!=-1))
      begin
        outfile=$fopen(errFileName,"a");
        $strobe("dfwdnc        VAC     leaving   OCA (  .. -15.000 V ) at %7.4r  %M", $abstime );
        $fwrite(outfile,"dfwdnc        VAC     leaving   OCA (  .. -15.000 V ) at %7.4r  %M\n", $abstime );
        VAC_retc=-1;
        VAC_cnt=VAC_cnt-1;
        $fclose(outfile);
      end
      if((VAC >= -15) &&  (VAC <= 1.5) && (VAC_retc!=0))
      begin
        outfile=$fopen(errFileName,"a");
        $strobe("dfwdnc        VAC     entering SOCA ( -15.000 V .. 1.500 V ) at %7.4r  %M", $abstime );
        $fwrite(outfile,"dfwdnc        VAC     entering SOCA ( -15.000 V .. 1.500 V ) at %7.4r  %M\n", $abstime );
        VAC_retc=0;
        VAC_cnt=VAC_cnt-1;
        $fclose(outfile);
      end
      if((VAC > 1.5) &&  (VAC_retc!=1))
      begin
        outfile=$fopen(errFileName,"a");
        $strobe("dfwdnc        VAC     leaving   OCA ( 1.500 V ..  ) at %7.4r  %M", $abstime );
        $fwrite(outfile,"dfwdnc        VAC     leaving   OCA ( 1.500 V ..  ) at %7.4r  %M\n", $abstime );
        VAC_retc=1;
        VAC_cnt=VAC_cnt-1;
        $fclose(outfile);
      end
   end
   else
   begin
      if(VAC_cnt==0)
      begin
        outfile=$fopen(errFileName,"a");
        $strobe("dfwdnc        VAC     error limit ( %d ) reached at %7.4r  %M", maxEv, $abstime );
        $fwrite(outfile,"dfwdnc        VAC     error limit ( %d ) reached at %7.4r  %M\n", maxEv, $abstime );
        VAC_cnt=VAC_cnt-1;
        $fclose(outfile);
      end
   end

//      If_100n
   If_100n = I_A /  ( m_soa * area / 1.08e-06 ) ;
   if((If_100n_cnt>0) || ( maxEv_flg==0 ))   begin
      if( (If_100n < -1000) && (If_100n_retc!=-1))
      begin
        outfile=$fopen(errFileName,"a");
        $strobe("dfwdnc        If_100n leaving   OCA (  .. -1.000 mA/um ) at %7.4r  %M", $abstime );
        $fwrite(outfile,"dfwdnc        If_100n leaving   OCA (  .. -1.000 mA/um ) at %7.4r  %M\n", $abstime );
        If_100n_retc=-1;
        If_100n_cnt=If_100n_cnt-1;
        $fclose(outfile);
      end
      if((If_100n >= -1000) &&  (If_100n <= 1000) && (If_100n_retc!=0))
      begin
        outfile=$fopen(errFileName,"a");
        $strobe("dfwdnc        If_100n entering SOCA ( -1.000 mA/um .. 1.000 mA/um ) at %7.4r  %M", $abstime );
        $fwrite(outfile,"dfwdnc        If_100n entering SOCA ( -1.000 mA/um .. 1.000 mA/um ) at %7.4r  %M\n", $abstime );
        If_100n_retc=0;
        If_100n_cnt=If_100n_cnt-1;
        $fclose(outfile);
      end
      if((If_100n > 1000) &&  (If_100n_retc!=1))
      begin
        outfile=$fopen(errFileName,"a");
        $strobe("dfwdnc        If_100n leaving   OCA ( 1.000 mA/um ..  ) at %7.4r  %M", $abstime );
        $fwrite(outfile,"dfwdnc        If_100n leaving   OCA ( 1.000 mA/um ..  ) at %7.4r  %M\n", $abstime );
        If_100n_retc=1;
        If_100n_cnt=If_100n_cnt-1;
        $fclose(outfile);
      end
   end
   else
   begin
      if(If_100n_cnt==0)
      begin
        outfile=$fopen(errFileName,"a");
        $strobe("dfwdnc        If_100n error limit ( %d ) reached at %7.4r  %M", maxEv, $abstime );
        $fwrite(outfile,"dfwdnc        If_100n error limit ( %d ) reached at %7.4r  %M\n", maxEv, $abstime );
        If_100n_cnt=If_100n_cnt-1;
        $fclose(outfile);
      end
   end

//      If_DC
   If_DC = I_A /  ( m_soa * area / 1.08e-06 ) ;
   if((If_DC_cnt>0) || ( maxEv_flg==0 ))   begin
      if( (If_DC < -1000) && (If_DC_retc!=-1))
      begin
        outfile=$fopen(errFileName,"a");
        $strobe("dfwdnc        If_DC   leaving   OCA (  .. -1.000 mA/um ) at %7.4r  %M", $abstime );
        $fwrite(outfile,"dfwdnc        If_DC   leaving   OCA (  .. -1.000 mA/um ) at %7.4r  %M\n", $abstime );
        If_DC_retc=-1;
        If_DC_cnt=If_DC_cnt-1;
        $fclose(outfile);
      end
      if((If_DC >= -1000) &&  (If_DC <= 100) && (If_DC_retc!=0))
      begin
        outfile=$fopen(errFileName,"a");
        $strobe("dfwdnc        If_DC   entering SOCA ( -1.000 mA/um .. 100.000 uA/um ) at %7.4r  %M", $abstime );
        $fwrite(outfile,"dfwdnc        If_DC   entering SOCA ( -1.000 mA/um .. 100.000 uA/um ) at %7.4r  %M\n", $abstime );
        If_DC_retc=0;
        If_DC_cnt=If_DC_cnt-1;
        $fclose(outfile);
      end
      if((If_DC > 100) &&  (If_DC_retc!=1))
      begin
        outfile=$fopen(errFileName,"a");
        $strobe("dfwdnc        If_DC   leaving   OCA ( 100.000 uA/um ..  ) at %7.4r  %M", $abstime );
        $fwrite(outfile,"dfwdnc        If_DC   leaving   OCA ( 100.000 uA/um ..  ) at %7.4r  %M\n", $abstime );
        If_DC_retc=1;
        If_DC_cnt=If_DC_cnt-1;
        $fclose(outfile);
      end
   end
   else
   begin
      if(If_DC_cnt==0)
      begin
        outfile=$fopen(errFileName,"a");
        $strobe("dfwdnc        If_DC   error limit ( %d ) reached at %7.4r  %M", maxEv, $abstime );
        $fwrite(outfile,"dfwdnc        If_DC   error limit ( %d ) reached at %7.4r  %M\n", maxEv, $abstime );
        If_DC_cnt=If_DC_cnt-1;
        $fclose(outfile);
      end
   end

end // analog
endmodule // dfwdnc

// Verilog-A OC Watch for device dfwdnd Parameters  VAC If_100n If_DC
module dfwdnd_ahdl(A1,C1,A,C);
parameter tstep_occ=100n;
parameter errFileName="./occ.err";
parameter area = 1u;
parameter m_soa = 1;
parameter maxEv = 25;
parameter maxEv_flg = 0;
inout A1,C1,A,C;
electrical A1,C1,A,C;

integer outfile;
real V_A_C;
real I_C;
real I_A;
real VAC;
integer VAC_retc;
integer VAC_cnt;
real If_100n;
integer If_100n_retc;
integer If_100n_cnt;
real If_DC;
integer If_DC_retc;
integer If_DC_cnt;

analog begin
   $bound_step( tstep_occ );
   @(initial_step) begin
      VAC_retc=0;
      VAC_cnt = maxEv;
      If_100n_retc=0;
      If_100n_cnt = maxEv;
      If_DC_retc=0;
      If_DC_cnt = maxEv;
   end
   V_A_C = V(A,C);
   I_C = I(C1,C);
   I_A = I(A1,A);

//      VAC
   VAC = V_A_C;
   if((VAC_cnt>0) || ( maxEv_flg==0 ))   begin
      if( (VAC < -20) && (VAC_retc!=-1))
      begin
        outfile=$fopen(errFileName,"a");
        $strobe("dfwdnd        VAC     leaving   OCA (  .. -20.000 V ) at %7.4r  %M", $abstime );
        $fwrite(outfile,"dfwdnd        VAC     leaving   OCA (  .. -20.000 V ) at %7.4r  %M\n", $abstime );
        VAC_retc=-1;
        VAC_cnt=VAC_cnt-1;
        $fclose(outfile);
      end
      if((VAC >= -20) &&  (VAC <= 1.5) && (VAC_retc!=0))
      begin
        outfile=$fopen(errFileName,"a");
        $strobe("dfwdnd        VAC     entering SOCA ( -20.000 V .. 1.500 V ) at %7.4r  %M", $abstime );
        $fwrite(outfile,"dfwdnd        VAC     entering SOCA ( -20.000 V .. 1.500 V ) at %7.4r  %M\n", $abstime );
        VAC_retc=0;
        VAC_cnt=VAC_cnt-1;
        $fclose(outfile);
      end
      if((VAC > 1.5) &&  (VAC_retc!=1))
      begin
        outfile=$fopen(errFileName,"a");
        $strobe("dfwdnd        VAC     leaving   OCA ( 1.500 V ..  ) at %7.4r  %M", $abstime );
        $fwrite(outfile,"dfwdnd        VAC     leaving   OCA ( 1.500 V ..  ) at %7.4r  %M\n", $abstime );
        VAC_retc=1;
        VAC_cnt=VAC_cnt-1;
        $fclose(outfile);
      end
   end
   else
   begin
      if(VAC_cnt==0)
      begin
        outfile=$fopen(errFileName,"a");
        $strobe("dfwdnd        VAC     error limit ( %d ) reached at %7.4r  %M", maxEv, $abstime );
        $fwrite(outfile,"dfwdnd        VAC     error limit ( %d ) reached at %7.4r  %M\n", maxEv, $abstime );
        VAC_cnt=VAC_cnt-1;
        $fclose(outfile);
      end
   end

//      If_100n
   If_100n = I_A /  ( m_soa * area / 1.11e-06 ) ;
   if((If_100n_cnt>0) || ( maxEv_flg==0 ))   begin
      if( (If_100n < -1000) && (If_100n_retc!=-1))
      begin
        outfile=$fopen(errFileName,"a");
        $strobe("dfwdnd        If_100n leaving   OCA (  .. -1.000 mA/um ) at %7.4r  %M", $abstime );
        $fwrite(outfile,"dfwdnd        If_100n leaving   OCA (  .. -1.000 mA/um ) at %7.4r  %M\n", $abstime );
        If_100n_retc=-1;
        If_100n_cnt=If_100n_cnt-1;
        $fclose(outfile);
      end
      if((If_100n >= -1000) &&  (If_100n <= 1000) && (If_100n_retc!=0))
      begin
        outfile=$fopen(errFileName,"a");
        $strobe("dfwdnd        If_100n entering SOCA ( -1.000 mA/um .. 1.000 mA/um ) at %7.4r  %M", $abstime );
        $fwrite(outfile,"dfwdnd        If_100n entering SOCA ( -1.000 mA/um .. 1.000 mA/um ) at %7.4r  %M\n", $abstime );
        If_100n_retc=0;
        If_100n_cnt=If_100n_cnt-1;
        $fclose(outfile);
      end
      if((If_100n > 1000) &&  (If_100n_retc!=1))
      begin
        outfile=$fopen(errFileName,"a");
        $strobe("dfwdnd        If_100n leaving   OCA ( 1.000 mA/um ..  ) at %7.4r  %M", $abstime );
        $fwrite(outfile,"dfwdnd        If_100n leaving   OCA ( 1.000 mA/um ..  ) at %7.4r  %M\n", $abstime );
        If_100n_retc=1;
        If_100n_cnt=If_100n_cnt-1;
        $fclose(outfile);
      end
   end
   else
   begin
      if(If_100n_cnt==0)
      begin
        outfile=$fopen(errFileName,"a");
        $strobe("dfwdnd        If_100n error limit ( %d ) reached at %7.4r  %M", maxEv, $abstime );
        $fwrite(outfile,"dfwdnd        If_100n error limit ( %d ) reached at %7.4r  %M\n", maxEv, $abstime );
        If_100n_cnt=If_100n_cnt-1;
        $fclose(outfile);
      end
   end

//      If_DC
   If_DC = I_A /  ( m_soa * area / 1.11e-06 ) ;
   if((If_DC_cnt>0) || ( maxEv_flg==0 ))   begin
      if( (If_DC < -1000) && (If_DC_retc!=-1))
      begin
        outfile=$fopen(errFileName,"a");
        $strobe("dfwdnd        If_DC   leaving   OCA (  .. -1.000 mA/um ) at %7.4r  %M", $abstime );
        $fwrite(outfile,"dfwdnd        If_DC   leaving   OCA (  .. -1.000 mA/um ) at %7.4r  %M\n", $abstime );
        If_DC_retc=-1;
        If_DC_cnt=If_DC_cnt-1;
        $fclose(outfile);
      end
      if((If_DC >= -1000) &&  (If_DC <= 100) && (If_DC_retc!=0))
      begin
        outfile=$fopen(errFileName,"a");
        $strobe("dfwdnd        If_DC   entering SOCA ( -1.000 mA/um .. 100.000 uA/um ) at %7.4r  %M", $abstime );
        $fwrite(outfile,"dfwdnd        If_DC   entering SOCA ( -1.000 mA/um .. 100.000 uA/um ) at %7.4r  %M\n", $abstime );
        If_DC_retc=0;
        If_DC_cnt=If_DC_cnt-1;
        $fclose(outfile);
      end
      if((If_DC > 100) &&  (If_DC_retc!=1))
      begin
        outfile=$fopen(errFileName,"a");
        $strobe("dfwdnd        If_DC   leaving   OCA ( 100.000 uA/um ..  ) at %7.4r  %M", $abstime );
        $fwrite(outfile,"dfwdnd        If_DC   leaving   OCA ( 100.000 uA/um ..  ) at %7.4r  %M\n", $abstime );
        If_DC_retc=1;
        If_DC_cnt=If_DC_cnt-1;
        $fclose(outfile);
      end
   end
   else
   begin
      if(If_DC_cnt==0)
      begin
        outfile=$fopen(errFileName,"a");
        $strobe("dfwdnd        If_DC   error limit ( %d ) reached at %7.4r  %M", maxEv, $abstime );
        $fwrite(outfile,"dfwdnd        If_DC   error limit ( %d ) reached at %7.4r  %M\n", maxEv, $abstime );
        If_DC_cnt=If_DC_cnt-1;
        $fclose(outfile);
      end
   end

end // analog
endmodule // dfwdnd

// Verilog-A OC Watch for device dfwdne Parameters  VAC If_100n If_DC
module dfwdne_ahdl(A1,C1,A,C);
parameter tstep_occ=100n;
parameter errFileName="./occ.err";
parameter area = 1u;
parameter m_soa = 1;
parameter maxEv = 25;
parameter maxEv_flg = 0;
inout A1,C1,A,C;
electrical A1,C1,A,C;

integer outfile;
real V_A_C;
real I_C;
real I_A;
real VAC;
integer VAC_retc;
integer VAC_cnt;
real If_100n;
integer If_100n_retc;
integer If_100n_cnt;
real If_DC;
integer If_DC_retc;
integer If_DC_cnt;

analog begin
   $bound_step( tstep_occ );
   @(initial_step) begin
      VAC_retc=0;
      VAC_cnt = maxEv;
      If_100n_retc=0;
      If_100n_cnt = maxEv;
      If_DC_retc=0;
      If_DC_cnt = maxEv;
   end
   V_A_C = V(A,C);
   I_C = I(C1,C);
   I_A = I(A1,A);

//      VAC
   VAC = V_A_C;
   if((VAC_cnt>0) || ( maxEv_flg==0 ))   begin
      if( (VAC < -25) && (VAC_retc!=-1))
      begin
        outfile=$fopen(errFileName,"a");
        $strobe("dfwdne        VAC     leaving   OCA (  .. -25.000 V ) at %7.4r  %M", $abstime );
        $fwrite(outfile,"dfwdne        VAC     leaving   OCA (  .. -25.000 V ) at %7.4r  %M\n", $abstime );
        VAC_retc=-1;
        VAC_cnt=VAC_cnt-1;
        $fclose(outfile);
      end
      if((VAC >= -25) &&  (VAC <= 1.5) && (VAC_retc!=0))
      begin
        outfile=$fopen(errFileName,"a");
        $strobe("dfwdne        VAC     entering SOCA ( -25.000 V .. 1.500 V ) at %7.4r  %M", $abstime );
        $fwrite(outfile,"dfwdne        VAC     entering SOCA ( -25.000 V .. 1.500 V ) at %7.4r  %M\n", $abstime );
        VAC_retc=0;
        VAC_cnt=VAC_cnt-1;
        $fclose(outfile);
      end
      if((VAC > 1.5) &&  (VAC_retc!=1))
      begin
        outfile=$fopen(errFileName,"a");
        $strobe("dfwdne        VAC     leaving   OCA ( 1.500 V ..  ) at %7.4r  %M", $abstime );
        $fwrite(outfile,"dfwdne        VAC     leaving   OCA ( 1.500 V ..  ) at %7.4r  %M\n", $abstime );
        VAC_retc=1;
        VAC_cnt=VAC_cnt-1;
        $fclose(outfile);
      end
   end
   else
   begin
      if(VAC_cnt==0)
      begin
        outfile=$fopen(errFileName,"a");
        $strobe("dfwdne        VAC     error limit ( %d ) reached at %7.4r  %M", maxEv, $abstime );
        $fwrite(outfile,"dfwdne        VAC     error limit ( %d ) reached at %7.4r  %M\n", maxEv, $abstime );
        VAC_cnt=VAC_cnt-1;
        $fclose(outfile);
      end
   end

//      If_100n
   If_100n = I_A /  ( m_soa * area / 1.41e-06 ) ;
   if((If_100n_cnt>0) || ( maxEv_flg==0 ))   begin
      if( (If_100n < -1000) && (If_100n_retc!=-1))
      begin
        outfile=$fopen(errFileName,"a");
        $strobe("dfwdne        If_100n leaving   OCA (  .. -1.000 mA/um ) at %7.4r  %M", $abstime );
        $fwrite(outfile,"dfwdne        If_100n leaving   OCA (  .. -1.000 mA/um ) at %7.4r  %M\n", $abstime );
        If_100n_retc=-1;
        If_100n_cnt=If_100n_cnt-1;
        $fclose(outfile);
      end
      if((If_100n >= -1000) &&  (If_100n <= 1000) && (If_100n_retc!=0))
      begin
        outfile=$fopen(errFileName,"a");
        $strobe("dfwdne        If_100n entering SOCA ( -1.000 mA/um .. 1.000 mA/um ) at %7.4r  %M", $abstime );
        $fwrite(outfile,"dfwdne        If_100n entering SOCA ( -1.000 mA/um .. 1.000 mA/um ) at %7.4r  %M\n", $abstime );
        If_100n_retc=0;
        If_100n_cnt=If_100n_cnt-1;
        $fclose(outfile);
      end
      if((If_100n > 1000) &&  (If_100n_retc!=1))
      begin
        outfile=$fopen(errFileName,"a");
        $strobe("dfwdne        If_100n leaving   OCA ( 1.000 mA/um ..  ) at %7.4r  %M", $abstime );
        $fwrite(outfile,"dfwdne        If_100n leaving   OCA ( 1.000 mA/um ..  ) at %7.4r  %M\n", $abstime );
        If_100n_retc=1;
        If_100n_cnt=If_100n_cnt-1;
        $fclose(outfile);
      end
   end
   else
   begin
      if(If_100n_cnt==0)
      begin
        outfile=$fopen(errFileName,"a");
        $strobe("dfwdne        If_100n error limit ( %d ) reached at %7.4r  %M", maxEv, $abstime );
        $fwrite(outfile,"dfwdne        If_100n error limit ( %d ) reached at %7.4r  %M\n", maxEv, $abstime );
        If_100n_cnt=If_100n_cnt-1;
        $fclose(outfile);
      end
   end

//      If_DC
   If_DC = I_A /  ( m_soa * area / 1.41e-06 ) ;
   if((If_DC_cnt>0) || ( maxEv_flg==0 ))   begin
      if( (If_DC < -1000) && (If_DC_retc!=-1))
      begin
        outfile=$fopen(errFileName,"a");
        $strobe("dfwdne        If_DC   leaving   OCA (  .. -1.000 mA/um ) at %7.4r  %M", $abstime );
        $fwrite(outfile,"dfwdne        If_DC   leaving   OCA (  .. -1.000 mA/um ) at %7.4r  %M\n", $abstime );
        If_DC_retc=-1;
        If_DC_cnt=If_DC_cnt-1;
        $fclose(outfile);
      end
      if((If_DC >= -1000) &&  (If_DC <= 100) && (If_DC_retc!=0))
      begin
        outfile=$fopen(errFileName,"a");
        $strobe("dfwdne        If_DC   entering SOCA ( -1.000 mA/um .. 100.000 uA/um ) at %7.4r  %M", $abstime );
        $fwrite(outfile,"dfwdne        If_DC   entering SOCA ( -1.000 mA/um .. 100.000 uA/um ) at %7.4r  %M\n", $abstime );
        If_DC_retc=0;
        If_DC_cnt=If_DC_cnt-1;
        $fclose(outfile);
      end
      if((If_DC > 100) &&  (If_DC_retc!=1))
      begin
        outfile=$fopen(errFileName,"a");
        $strobe("dfwdne        If_DC   leaving   OCA ( 100.000 uA/um ..  ) at %7.4r  %M", $abstime );
        $fwrite(outfile,"dfwdne        If_DC   leaving   OCA ( 100.000 uA/um ..  ) at %7.4r  %M\n", $abstime );
        If_DC_retc=1;
        If_DC_cnt=If_DC_cnt-1;
        $fclose(outfile);
      end
   end
   else
   begin
      if(If_DC_cnt==0)
      begin
        outfile=$fopen(errFileName,"a");
        $strobe("dfwdne        If_DC   error limit ( %d ) reached at %7.4r  %M", maxEv, $abstime );
        $fwrite(outfile,"dfwdne        If_DC   error limit ( %d ) reached at %7.4r  %M\n", maxEv, $abstime );
        If_DC_cnt=If_DC_cnt-1;
        $fclose(outfile);
      end
   end

end // analog
endmodule // dfwdne

// Verilog-A OC Watch for device dfwdnf Parameters  VAC If_100n If_DC
module dfwdnf_ahdl(A1,C1,A,C);
parameter tstep_occ=100n;
parameter errFileName="./occ.err";
parameter area = 1u;
parameter m_soa = 1;
parameter maxEv = 25;
parameter maxEv_flg = 0;
inout A1,C1,A,C;
electrical A1,C1,A,C;

integer outfile;
real V_A_C;
real I_C;
real I_A;
real VAC;
integer VAC_retc;
integer VAC_cnt;
real If_100n;
integer If_100n_retc;
integer If_100n_cnt;
real If_DC;
integer If_DC_retc;
integer If_DC_cnt;

analog begin
   $bound_step( tstep_occ );
   @(initial_step) begin
      VAC_retc=0;
      VAC_cnt = maxEv;
      If_100n_retc=0;
      If_100n_cnt = maxEv;
      If_DC_retc=0;
      If_DC_cnt = maxEv;
   end
   V_A_C = V(A,C);
   I_C = I(C1,C);
   I_A = I(A1,A);

//      VAC
   VAC = V_A_C;
   if((VAC_cnt>0) || ( maxEv_flg==0 ))   begin
      if( (VAC < -32) && (VAC_retc!=-1))
      begin
        outfile=$fopen(errFileName,"a");
        $strobe("dfwdnf        VAC     leaving   OCA (  .. -32.000 V ) at %7.4r  %M", $abstime );
        $fwrite(outfile,"dfwdnf        VAC     leaving   OCA (  .. -32.000 V ) at %7.4r  %M\n", $abstime );
        VAC_retc=-1;
        VAC_cnt=VAC_cnt-1;
        $fclose(outfile);
      end
      if((VAC >= -32) &&  (VAC <= 1.5) && (VAC_retc!=0))
      begin
        outfile=$fopen(errFileName,"a");
        $strobe("dfwdnf        VAC     entering SOCA ( -32.000 V .. 1.500 V ) at %7.4r  %M", $abstime );
        $fwrite(outfile,"dfwdnf        VAC     entering SOCA ( -32.000 V .. 1.500 V ) at %7.4r  %M\n", $abstime );
        VAC_retc=0;
        VAC_cnt=VAC_cnt-1;
        $fclose(outfile);
      end
      if((VAC > 1.5) &&  (VAC_retc!=1))
      begin
        outfile=$fopen(errFileName,"a");
        $strobe("dfwdnf        VAC     leaving   OCA ( 1.500 V ..  ) at %7.4r  %M", $abstime );
        $fwrite(outfile,"dfwdnf        VAC     leaving   OCA ( 1.500 V ..  ) at %7.4r  %M\n", $abstime );
        VAC_retc=1;
        VAC_cnt=VAC_cnt-1;
        $fclose(outfile);
      end
   end
   else
   begin
      if(VAC_cnt==0)
      begin
        outfile=$fopen(errFileName,"a");
        $strobe("dfwdnf        VAC     error limit ( %d ) reached at %7.4r  %M", maxEv, $abstime );
        $fwrite(outfile,"dfwdnf        VAC     error limit ( %d ) reached at %7.4r  %M\n", maxEv, $abstime );
        VAC_cnt=VAC_cnt-1;
        $fclose(outfile);
      end
   end

//      If_100n
   If_100n = I_A /  ( m_soa * area / 1.81e-06 ) ;
   if((If_100n_cnt>0) || ( maxEv_flg==0 ))   begin
      if( (If_100n < -1000) && (If_100n_retc!=-1))
      begin
        outfile=$fopen(errFileName,"a");
        $strobe("dfwdnf        If_100n leaving   OCA (  .. -1.000 mA/um ) at %7.4r  %M", $abstime );
        $fwrite(outfile,"dfwdnf        If_100n leaving   OCA (  .. -1.000 mA/um ) at %7.4r  %M\n", $abstime );
        If_100n_retc=-1;
        If_100n_cnt=If_100n_cnt-1;
        $fclose(outfile);
      end
      if((If_100n >= -1000) &&  (If_100n <= 1000) && (If_100n_retc!=0))
      begin
        outfile=$fopen(errFileName,"a");
        $strobe("dfwdnf        If_100n entering SOCA ( -1.000 mA/um .. 1.000 mA/um ) at %7.4r  %M", $abstime );
        $fwrite(outfile,"dfwdnf        If_100n entering SOCA ( -1.000 mA/um .. 1.000 mA/um ) at %7.4r  %M\n", $abstime );
        If_100n_retc=0;
        If_100n_cnt=If_100n_cnt-1;
        $fclose(outfile);
      end
      if((If_100n > 1000) &&  (If_100n_retc!=1))
      begin
        outfile=$fopen(errFileName,"a");
        $strobe("dfwdnf        If_100n leaving   OCA ( 1.000 mA/um ..  ) at %7.4r  %M", $abstime );
        $fwrite(outfile,"dfwdnf        If_100n leaving   OCA ( 1.000 mA/um ..  ) at %7.4r  %M\n", $abstime );
        If_100n_retc=1;
        If_100n_cnt=If_100n_cnt-1;
        $fclose(outfile);
      end
   end
   else
   begin
      if(If_100n_cnt==0)
      begin
        outfile=$fopen(errFileName,"a");
        $strobe("dfwdnf        If_100n error limit ( %d ) reached at %7.4r  %M", maxEv, $abstime );
        $fwrite(outfile,"dfwdnf        If_100n error limit ( %d ) reached at %7.4r  %M\n", maxEv, $abstime );
        If_100n_cnt=If_100n_cnt-1;
        $fclose(outfile);
      end
   end

//      If_DC
   If_DC = I_A /  ( m_soa * area / 1.81e-06 ) ;
   if((If_DC_cnt>0) || ( maxEv_flg==0 ))   begin
      if( (If_DC < -1000) && (If_DC_retc!=-1))
      begin
        outfile=$fopen(errFileName,"a");
        $strobe("dfwdnf        If_DC   leaving   OCA (  .. -1.000 mA/um ) at %7.4r  %M", $abstime );
        $fwrite(outfile,"dfwdnf        If_DC   leaving   OCA (  .. -1.000 mA/um ) at %7.4r  %M\n", $abstime );
        If_DC_retc=-1;
        If_DC_cnt=If_DC_cnt-1;
        $fclose(outfile);
      end
      if((If_DC >= -1000) &&  (If_DC <= 100) && (If_DC_retc!=0))
      begin
        outfile=$fopen(errFileName,"a");
        $strobe("dfwdnf        If_DC   entering SOCA ( -1.000 mA/um .. 100.000 uA/um ) at %7.4r  %M", $abstime );
        $fwrite(outfile,"dfwdnf        If_DC   entering SOCA ( -1.000 mA/um .. 100.000 uA/um ) at %7.4r  %M\n", $abstime );
        If_DC_retc=0;
        If_DC_cnt=If_DC_cnt-1;
        $fclose(outfile);
      end
      if((If_DC > 100) &&  (If_DC_retc!=1))
      begin
        outfile=$fopen(errFileName,"a");
        $strobe("dfwdnf        If_DC   leaving   OCA ( 100.000 uA/um ..  ) at %7.4r  %M", $abstime );
        $fwrite(outfile,"dfwdnf        If_DC   leaving   OCA ( 100.000 uA/um ..  ) at %7.4r  %M\n", $abstime );
        If_DC_retc=1;
        If_DC_cnt=If_DC_cnt-1;
        $fclose(outfile);
      end
   end
   else
   begin
      if(If_DC_cnt==0)
      begin
        outfile=$fopen(errFileName,"a");
        $strobe("dfwdnf        If_DC   error limit ( %d ) reached at %7.4r  %M", maxEv, $abstime );
        $fwrite(outfile,"dfwdnf        If_DC   error limit ( %d ) reached at %7.4r  %M\n", maxEv, $abstime );
        If_DC_cnt=If_DC_cnt-1;
        $fclose(outfile);
      end
   end

end // analog
endmodule // dfwdnf

// Verilog-A OC Watch for device dfwdpb Parameters  VAC If_100n If_DC
module dfwdpb_ahdl(A1,C1,A,C);
parameter tstep_occ=100n;
parameter errFileName="./occ.err";
parameter area = 1u;
parameter m_soa = 1;
parameter maxEv = 25;
parameter maxEv_flg = 0;
inout A1,C1,A,C;
electrical A1,C1,A,C;

integer outfile;
real V_A_C;
real I_C;
real I_A;
real VAC;
integer VAC_retc;
integer VAC_cnt;
real If_100n;
integer If_100n_retc;
integer If_100n_cnt;
real If_DC;
integer If_DC_retc;
integer If_DC_cnt;

analog begin
   $bound_step( tstep_occ );
   @(initial_step) begin
      VAC_retc=0;
      VAC_cnt = maxEv;
      If_100n_retc=0;
      If_100n_cnt = maxEv;
      If_DC_retc=0;
      If_DC_cnt = maxEv;
   end
   V_A_C = V(A,C);
   I_C = I(C1,C);
   I_A = I(A1,A);

//      VAC
   VAC = V_A_C;
   if((VAC_cnt>0) || ( maxEv_flg==0 ))   begin
      if( (VAC < -12) && (VAC_retc!=-1))
      begin
        outfile=$fopen(errFileName,"a");
        $strobe("dfwdpb        VAC     leaving   OCA (  .. -12.000 V ) at %7.4r  %M", $abstime );
        $fwrite(outfile,"dfwdpb        VAC     leaving   OCA (  .. -12.000 V ) at %7.4r  %M\n", $abstime );
        VAC_retc=-1;
        VAC_cnt=VAC_cnt-1;
        $fclose(outfile);
      end
      if((VAC >= -12) &&  (VAC <= 1.5) && (VAC_retc!=0))
      begin
        outfile=$fopen(errFileName,"a");
        $strobe("dfwdpb        VAC     entering SOCA ( -12.000 V .. 1.500 V ) at %7.4r  %M", $abstime );
        $fwrite(outfile,"dfwdpb        VAC     entering SOCA ( -12.000 V .. 1.500 V ) at %7.4r  %M\n", $abstime );
        VAC_retc=0;
        VAC_cnt=VAC_cnt-1;
        $fclose(outfile);
      end
      if((VAC > 1.5) &&  (VAC_retc!=1))
      begin
        outfile=$fopen(errFileName,"a");
        $strobe("dfwdpb        VAC     leaving   OCA ( 1.500 V ..  ) at %7.4r  %M", $abstime );
        $fwrite(outfile,"dfwdpb        VAC     leaving   OCA ( 1.500 V ..  ) at %7.4r  %M\n", $abstime );
        VAC_retc=1;
        VAC_cnt=VAC_cnt-1;
        $fclose(outfile);
      end
   end
   else
   begin
      if(VAC_cnt==0)
      begin
        outfile=$fopen(errFileName,"a");
        $strobe("dfwdpb        VAC     error limit ( %d ) reached at %7.4r  %M", maxEv, $abstime );
        $fwrite(outfile,"dfwdpb        VAC     error limit ( %d ) reached at %7.4r  %M\n", maxEv, $abstime );
        VAC_cnt=VAC_cnt-1;
        $fclose(outfile);
      end
   end

//      If_100n
   If_100n = I_A /  ( m_soa * area / 9.3e-07 ) ;
   if((If_100n_cnt>0) || ( maxEv_flg==0 ))   begin
      if( (If_100n < -1000) && (If_100n_retc!=-1))
      begin
        outfile=$fopen(errFileName,"a");
        $strobe("dfwdpb        If_100n leaving   OCA (  .. -1.000 mA/um ) at %7.4r  %M", $abstime );
        $fwrite(outfile,"dfwdpb        If_100n leaving   OCA (  .. -1.000 mA/um ) at %7.4r  %M\n", $abstime );
        If_100n_retc=-1;
        If_100n_cnt=If_100n_cnt-1;
        $fclose(outfile);
      end
      if((If_100n >= -1000) &&  (If_100n <= 1000) && (If_100n_retc!=0))
      begin
        outfile=$fopen(errFileName,"a");
        $strobe("dfwdpb        If_100n entering SOCA ( -1.000 mA/um .. 1.000 mA/um ) at %7.4r  %M", $abstime );
        $fwrite(outfile,"dfwdpb        If_100n entering SOCA ( -1.000 mA/um .. 1.000 mA/um ) at %7.4r  %M\n", $abstime );
        If_100n_retc=0;
        If_100n_cnt=If_100n_cnt-1;
        $fclose(outfile);
      end
      if((If_100n > 1000) &&  (If_100n_retc!=1))
      begin
        outfile=$fopen(errFileName,"a");
        $strobe("dfwdpb        If_100n leaving   OCA ( 1.000 mA/um ..  ) at %7.4r  %M", $abstime );
        $fwrite(outfile,"dfwdpb        If_100n leaving   OCA ( 1.000 mA/um ..  ) at %7.4r  %M\n", $abstime );
        If_100n_retc=1;
        If_100n_cnt=If_100n_cnt-1;
        $fclose(outfile);
      end
   end
   else
   begin
      if(If_100n_cnt==0)
      begin
        outfile=$fopen(errFileName,"a");
        $strobe("dfwdpb        If_100n error limit ( %d ) reached at %7.4r  %M", maxEv, $abstime );
        $fwrite(outfile,"dfwdpb        If_100n error limit ( %d ) reached at %7.4r  %M\n", maxEv, $abstime );
        If_100n_cnt=If_100n_cnt-1;
        $fclose(outfile);
      end
   end

//      If_DC
   If_DC = I_A /  ( m_soa * area / 9.3e-07 ) ;
   if((If_DC_cnt>0) || ( maxEv_flg==0 ))   begin
      if( (If_DC < -1000) && (If_DC_retc!=-1))
      begin
        outfile=$fopen(errFileName,"a");
        $strobe("dfwdpb        If_DC   leaving   OCA (  .. -1.000 mA/um ) at %7.4r  %M", $abstime );
        $fwrite(outfile,"dfwdpb        If_DC   leaving   OCA (  .. -1.000 mA/um ) at %7.4r  %M\n", $abstime );
        If_DC_retc=-1;
        If_DC_cnt=If_DC_cnt-1;
        $fclose(outfile);
      end
      if((If_DC >= -1000) &&  (If_DC <= 100) && (If_DC_retc!=0))
      begin
        outfile=$fopen(errFileName,"a");
        $strobe("dfwdpb        If_DC   entering SOCA ( -1.000 mA/um .. 100.000 uA/um ) at %7.4r  %M", $abstime );
        $fwrite(outfile,"dfwdpb        If_DC   entering SOCA ( -1.000 mA/um .. 100.000 uA/um ) at %7.4r  %M\n", $abstime );
        If_DC_retc=0;
        If_DC_cnt=If_DC_cnt-1;
        $fclose(outfile);
      end
      if((If_DC > 100) &&  (If_DC_retc!=1))
      begin
        outfile=$fopen(errFileName,"a");
        $strobe("dfwdpb        If_DC   leaving   OCA ( 100.000 uA/um ..  ) at %7.4r  %M", $abstime );
        $fwrite(outfile,"dfwdpb        If_DC   leaving   OCA ( 100.000 uA/um ..  ) at %7.4r  %M\n", $abstime );
        If_DC_retc=1;
        If_DC_cnt=If_DC_cnt-1;
        $fclose(outfile);
      end
   end
   else
   begin
      if(If_DC_cnt==0)
      begin
        outfile=$fopen(errFileName,"a");
        $strobe("dfwdpb        If_DC   error limit ( %d ) reached at %7.4r  %M", maxEv, $abstime );
        $fwrite(outfile,"dfwdpb        If_DC   error limit ( %d ) reached at %7.4r  %M\n", maxEv, $abstime );
        If_DC_cnt=If_DC_cnt-1;
        $fclose(outfile);
      end
   end

end // analog
endmodule // dfwdpb

// Verilog-A OC Watch for device dfwdpd Parameters  VAC If_100n If_DC
module dfwdpd_ahdl(A1,C1,A,C);
parameter tstep_occ=100n;
parameter errFileName="./occ.err";
parameter area = 1u;
parameter m_soa = 1;
parameter maxEv = 25;
parameter maxEv_flg = 0;
inout A1,C1,A,C;
electrical A1,C1,A,C;

integer outfile;
real V_A_C;
real I_C;
real I_A;
real VAC;
integer VAC_retc;
integer VAC_cnt;
real If_100n;
integer If_100n_retc;
integer If_100n_cnt;
real If_DC;
integer If_DC_retc;
integer If_DC_cnt;

analog begin
   $bound_step( tstep_occ );
   @(initial_step) begin
      VAC_retc=0;
      VAC_cnt = maxEv;
      If_100n_retc=0;
      If_100n_cnt = maxEv;
      If_DC_retc=0;
      If_DC_cnt = maxEv;
   end
   V_A_C = V(A,C);
   I_C = I(C1,C);
   I_A = I(A1,A);

//      VAC
   VAC = V_A_C;
   if((VAC_cnt>0) || ( maxEv_flg==0 ))   begin
      if( (VAC < -18) && (VAC_retc!=-1))
      begin
        outfile=$fopen(errFileName,"a");
        $strobe("dfwdpd        VAC     leaving   OCA (  .. -18.000 V ) at %7.4r  %M", $abstime );
        $fwrite(outfile,"dfwdpd        VAC     leaving   OCA (  .. -18.000 V ) at %7.4r  %M\n", $abstime );
        VAC_retc=-1;
        VAC_cnt=VAC_cnt-1;
        $fclose(outfile);
      end
      if((VAC >= -18) &&  (VAC <= 1.5) && (VAC_retc!=0))
      begin
        outfile=$fopen(errFileName,"a");
        $strobe("dfwdpd        VAC     entering SOCA ( -18.000 V .. 1.500 V ) at %7.4r  %M", $abstime );
        $fwrite(outfile,"dfwdpd        VAC     entering SOCA ( -18.000 V .. 1.500 V ) at %7.4r  %M\n", $abstime );
        VAC_retc=0;
        VAC_cnt=VAC_cnt-1;
        $fclose(outfile);
      end
      if((VAC > 1.5) &&  (VAC_retc!=1))
      begin
        outfile=$fopen(errFileName,"a");
        $strobe("dfwdpd        VAC     leaving   OCA ( 1.500 V ..  ) at %7.4r  %M", $abstime );
        $fwrite(outfile,"dfwdpd        VAC     leaving   OCA ( 1.500 V ..  ) at %7.4r  %M\n", $abstime );
        VAC_retc=1;
        VAC_cnt=VAC_cnt-1;
        $fclose(outfile);
      end
   end
   else
   begin
      if(VAC_cnt==0)
      begin
        outfile=$fopen(errFileName,"a");
        $strobe("dfwdpd        VAC     error limit ( %d ) reached at %7.4r  %M", maxEv, $abstime );
        $fwrite(outfile,"dfwdpd        VAC     error limit ( %d ) reached at %7.4r  %M\n", maxEv, $abstime );
        VAC_cnt=VAC_cnt-1;
        $fclose(outfile);
      end
   end

//      If_100n
   If_100n = I_A /  ( m_soa * area / 1e-06 ) ;
   if((If_100n_cnt>0) || ( maxEv_flg==0 ))   begin
      if( (If_100n < -1000) && (If_100n_retc!=-1))
      begin
        outfile=$fopen(errFileName,"a");
        $strobe("dfwdpd        If_100n leaving   OCA (  .. -1.000 mA/um ) at %7.4r  %M", $abstime );
        $fwrite(outfile,"dfwdpd        If_100n leaving   OCA (  .. -1.000 mA/um ) at %7.4r  %M\n", $abstime );
        If_100n_retc=-1;
        If_100n_cnt=If_100n_cnt-1;
        $fclose(outfile);
      end
      if((If_100n >= -1000) &&  (If_100n <= 1000) && (If_100n_retc!=0))
      begin
        outfile=$fopen(errFileName,"a");
        $strobe("dfwdpd        If_100n entering SOCA ( -1.000 mA/um .. 1.000 mA/um ) at %7.4r  %M", $abstime );
        $fwrite(outfile,"dfwdpd        If_100n entering SOCA ( -1.000 mA/um .. 1.000 mA/um ) at %7.4r  %M\n", $abstime );
        If_100n_retc=0;
        If_100n_cnt=If_100n_cnt-1;
        $fclose(outfile);
      end
      if((If_100n > 1000) &&  (If_100n_retc!=1))
      begin
        outfile=$fopen(errFileName,"a");
        $strobe("dfwdpd        If_100n leaving   OCA ( 1.000 mA/um ..  ) at %7.4r  %M", $abstime );
        $fwrite(outfile,"dfwdpd        If_100n leaving   OCA ( 1.000 mA/um ..  ) at %7.4r  %M\n", $abstime );
        If_100n_retc=1;
        If_100n_cnt=If_100n_cnt-1;
        $fclose(outfile);
      end
   end
   else
   begin
      if(If_100n_cnt==0)
      begin
        outfile=$fopen(errFileName,"a");
        $strobe("dfwdpd        If_100n error limit ( %d ) reached at %7.4r  %M", maxEv, $abstime );
        $fwrite(outfile,"dfwdpd        If_100n error limit ( %d ) reached at %7.4r  %M\n", maxEv, $abstime );
        If_100n_cnt=If_100n_cnt-1;
        $fclose(outfile);
      end
   end

//      If_DC
   If_DC = I_A /  ( m_soa * area / 1e-06 ) ;
   if((If_DC_cnt>0) || ( maxEv_flg==0 ))   begin
      if( (If_DC < -1000) && (If_DC_retc!=-1))
      begin
        outfile=$fopen(errFileName,"a");
        $strobe("dfwdpd        If_DC   leaving   OCA (  .. -1.000 mA/um ) at %7.4r  %M", $abstime );
        $fwrite(outfile,"dfwdpd        If_DC   leaving   OCA (  .. -1.000 mA/um ) at %7.4r  %M\n", $abstime );
        If_DC_retc=-1;
        If_DC_cnt=If_DC_cnt-1;
        $fclose(outfile);
      end
      if((If_DC >= -1000) &&  (If_DC <= 100) && (If_DC_retc!=0))
      begin
        outfile=$fopen(errFileName,"a");
        $strobe("dfwdpd        If_DC   entering SOCA ( -1.000 mA/um .. 100.000 uA/um ) at %7.4r  %M", $abstime );
        $fwrite(outfile,"dfwdpd        If_DC   entering SOCA ( -1.000 mA/um .. 100.000 uA/um ) at %7.4r  %M\n", $abstime );
        If_DC_retc=0;
        If_DC_cnt=If_DC_cnt-1;
        $fclose(outfile);
      end
      if((If_DC > 100) &&  (If_DC_retc!=1))
      begin
        outfile=$fopen(errFileName,"a");
        $strobe("dfwdpd        If_DC   leaving   OCA ( 100.000 uA/um ..  ) at %7.4r  %M", $abstime );
        $fwrite(outfile,"dfwdpd        If_DC   leaving   OCA ( 100.000 uA/um ..  ) at %7.4r  %M\n", $abstime );
        If_DC_retc=1;
        If_DC_cnt=If_DC_cnt-1;
        $fclose(outfile);
      end
   end
   else
   begin
      if(If_DC_cnt==0)
      begin
        outfile=$fopen(errFileName,"a");
        $strobe("dfwdpd        If_DC   error limit ( %d ) reached at %7.4r  %M", maxEv, $abstime );
        $fwrite(outfile,"dfwdpd        If_DC   error limit ( %d ) reached at %7.4r  %M\n", maxEv, $abstime );
        If_DC_cnt=If_DC_cnt-1;
        $fclose(outfile);
      end
   end

end // analog
endmodule // dfwdpd

// Verilog-A OC Watch for device dfwdpe Parameters  VAC If_100n If_DC
module dfwdpe_ahdl(A1,C1,A,C);
parameter tstep_occ=100n;
parameter errFileName="./occ.err";
parameter area = 1u;
parameter m_soa = 1;
parameter maxEv = 25;
parameter maxEv_flg = 0;
inout A1,C1,A,C;
electrical A1,C1,A,C;

integer outfile;
real V_A_C;
real I_C;
real I_A;
real VAC;
integer VAC_retc;
integer VAC_cnt;
real If_100n;
integer If_100n_retc;
integer If_100n_cnt;
real If_DC;
integer If_DC_retc;
integer If_DC_cnt;

analog begin
   $bound_step( tstep_occ );
   @(initial_step) begin
      VAC_retc=0;
      VAC_cnt = maxEv;
      If_100n_retc=0;
      If_100n_cnt = maxEv;
      If_DC_retc=0;
      If_DC_cnt = maxEv;
   end
   V_A_C = V(A,C);
   I_C = I(C1,C);
   I_A = I(A1,A);

//      VAC
   VAC = V_A_C;
   if((VAC_cnt>0) || ( maxEv_flg==0 ))   begin
      if( (VAC < -25) && (VAC_retc!=-1))
      begin
        outfile=$fopen(errFileName,"a");
        $strobe("dfwdpe        VAC     leaving   OCA (  .. -25.000 V ) at %7.4r  %M", $abstime );
        $fwrite(outfile,"dfwdpe        VAC     leaving   OCA (  .. -25.000 V ) at %7.4r  %M\n", $abstime );
        VAC_retc=-1;
        VAC_cnt=VAC_cnt-1;
        $fclose(outfile);
      end
      if((VAC >= -25) &&  (VAC <= 1.5) && (VAC_retc!=0))
      begin
        outfile=$fopen(errFileName,"a");
        $strobe("dfwdpe        VAC     entering SOCA ( -25.000 V .. 1.500 V ) at %7.4r  %M", $abstime );
        $fwrite(outfile,"dfwdpe        VAC     entering SOCA ( -25.000 V .. 1.500 V ) at %7.4r  %M\n", $abstime );
        VAC_retc=0;
        VAC_cnt=VAC_cnt-1;
        $fclose(outfile);
      end
      if((VAC > 1.5) &&  (VAC_retc!=1))
      begin
        outfile=$fopen(errFileName,"a");
        $strobe("dfwdpe        VAC     leaving   OCA ( 1.500 V ..  ) at %7.4r  %M", $abstime );
        $fwrite(outfile,"dfwdpe        VAC     leaving   OCA ( 1.500 V ..  ) at %7.4r  %M\n", $abstime );
        VAC_retc=1;
        VAC_cnt=VAC_cnt-1;
        $fclose(outfile);
      end
   end
   else
   begin
      if(VAC_cnt==0)
      begin
        outfile=$fopen(errFileName,"a");
        $strobe("dfwdpe        VAC     error limit ( %d ) reached at %7.4r  %M", maxEv, $abstime );
        $fwrite(outfile,"dfwdpe        VAC     error limit ( %d ) reached at %7.4r  %M\n", maxEv, $abstime );
        VAC_cnt=VAC_cnt-1;
        $fclose(outfile);
      end
   end

//      If_100n
   If_100n = I_A /  ( m_soa * area / 1.3e-06 ) ;
   if((If_100n_cnt>0) || ( maxEv_flg==0 ))   begin
      if( (If_100n < -1000) && (If_100n_retc!=-1))
      begin
        outfile=$fopen(errFileName,"a");
        $strobe("dfwdpe        If_100n leaving   OCA (  .. -1.000 mA/um ) at %7.4r  %M", $abstime );
        $fwrite(outfile,"dfwdpe        If_100n leaving   OCA (  .. -1.000 mA/um ) at %7.4r  %M\n", $abstime );
        If_100n_retc=-1;
        If_100n_cnt=If_100n_cnt-1;
        $fclose(outfile);
      end
      if((If_100n >= -1000) &&  (If_100n <= 1000) && (If_100n_retc!=0))
      begin
        outfile=$fopen(errFileName,"a");
        $strobe("dfwdpe        If_100n entering SOCA ( -1.000 mA/um .. 1.000 mA/um ) at %7.4r  %M", $abstime );
        $fwrite(outfile,"dfwdpe        If_100n entering SOCA ( -1.000 mA/um .. 1.000 mA/um ) at %7.4r  %M\n", $abstime );
        If_100n_retc=0;
        If_100n_cnt=If_100n_cnt-1;
        $fclose(outfile);
      end
      if((If_100n > 1000) &&  (If_100n_retc!=1))
      begin
        outfile=$fopen(errFileName,"a");
        $strobe("dfwdpe        If_100n leaving   OCA ( 1.000 mA/um ..  ) at %7.4r  %M", $abstime );
        $fwrite(outfile,"dfwdpe        If_100n leaving   OCA ( 1.000 mA/um ..  ) at %7.4r  %M\n", $abstime );
        If_100n_retc=1;
        If_100n_cnt=If_100n_cnt-1;
        $fclose(outfile);
      end
   end
   else
   begin
      if(If_100n_cnt==0)
      begin
        outfile=$fopen(errFileName,"a");
        $strobe("dfwdpe        If_100n error limit ( %d ) reached at %7.4r  %M", maxEv, $abstime );
        $fwrite(outfile,"dfwdpe        If_100n error limit ( %d ) reached at %7.4r  %M\n", maxEv, $abstime );
        If_100n_cnt=If_100n_cnt-1;
        $fclose(outfile);
      end
   end

//      If_DC
   If_DC = I_A /  ( m_soa * area / 1.3e-06 ) ;
   if((If_DC_cnt>0) || ( maxEv_flg==0 ))   begin
      if( (If_DC < -1000) && (If_DC_retc!=-1))
      begin
        outfile=$fopen(errFileName,"a");
        $strobe("dfwdpe        If_DC   leaving   OCA (  .. -1.000 mA/um ) at %7.4r  %M", $abstime );
        $fwrite(outfile,"dfwdpe        If_DC   leaving   OCA (  .. -1.000 mA/um ) at %7.4r  %M\n", $abstime );
        If_DC_retc=-1;
        If_DC_cnt=If_DC_cnt-1;
        $fclose(outfile);
      end
      if((If_DC >= -1000) &&  (If_DC <= 100) && (If_DC_retc!=0))
      begin
        outfile=$fopen(errFileName,"a");
        $strobe("dfwdpe        If_DC   entering SOCA ( -1.000 mA/um .. 100.000 uA/um ) at %7.4r  %M", $abstime );
        $fwrite(outfile,"dfwdpe        If_DC   entering SOCA ( -1.000 mA/um .. 100.000 uA/um ) at %7.4r  %M\n", $abstime );
        If_DC_retc=0;
        If_DC_cnt=If_DC_cnt-1;
        $fclose(outfile);
      end
      if((If_DC > 100) &&  (If_DC_retc!=1))
      begin
        outfile=$fopen(errFileName,"a");
        $strobe("dfwdpe        If_DC   leaving   OCA ( 100.000 uA/um ..  ) at %7.4r  %M", $abstime );
        $fwrite(outfile,"dfwdpe        If_DC   leaving   OCA ( 100.000 uA/um ..  ) at %7.4r  %M\n", $abstime );
        If_DC_retc=1;
        If_DC_cnt=If_DC_cnt-1;
        $fclose(outfile);
      end
   end
   else
   begin
      if(If_DC_cnt==0)
      begin
        outfile=$fopen(errFileName,"a");
        $strobe("dfwdpe        If_DC   error limit ( %d ) reached at %7.4r  %M", maxEv, $abstime );
        $fwrite(outfile,"dfwdpe        If_DC   error limit ( %d ) reached at %7.4r  %M\n", maxEv, $abstime );
        If_DC_cnt=If_DC_cnt-1;
        $fclose(outfile);
      end
   end

end // analog
endmodule // dfwdpe

// Verilog-A OC Watch for device dfwdpf Parameters  VAC If_100n If_DC
module dfwdpf_ahdl(A1,C1,A,C);
parameter tstep_occ=100n;
parameter errFileName="./occ.err";
parameter area = 1u;
parameter m_soa = 1;
parameter maxEv = 25;
parameter maxEv_flg = 0;
inout A1,C1,A,C;
electrical A1,C1,A,C;

integer outfile;
real V_A_C;
real I_C;
real I_A;
real VAC;
integer VAC_retc;
integer VAC_cnt;
real If_100n;
integer If_100n_retc;
integer If_100n_cnt;
real If_DC;
integer If_DC_retc;
integer If_DC_cnt;

analog begin
   $bound_step( tstep_occ );
   @(initial_step) begin
      VAC_retc=0;
      VAC_cnt = maxEv;
      If_100n_retc=0;
      If_100n_cnt = maxEv;
      If_DC_retc=0;
      If_DC_cnt = maxEv;
   end
   V_A_C = V(A,C);
   I_C = I(C1,C);
   I_A = I(A1,A);

//      VAC
   VAC = V_A_C;
   if((VAC_cnt>0) || ( maxEv_flg==0 ))   begin
      if( (VAC < -32) && (VAC_retc!=-1))
      begin
        outfile=$fopen(errFileName,"a");
        $strobe("dfwdpf        VAC     leaving   OCA (  .. -32.000 V ) at %7.4r  %M", $abstime );
        $fwrite(outfile,"dfwdpf        VAC     leaving   OCA (  .. -32.000 V ) at %7.4r  %M\n", $abstime );
        VAC_retc=-1;
        VAC_cnt=VAC_cnt-1;
        $fclose(outfile);
      end
      if((VAC >= -32) &&  (VAC <= 1.5) && (VAC_retc!=0))
      begin
        outfile=$fopen(errFileName,"a");
        $strobe("dfwdpf        VAC     entering SOCA ( -32.000 V .. 1.500 V ) at %7.4r  %M", $abstime );
        $fwrite(outfile,"dfwdpf        VAC     entering SOCA ( -32.000 V .. 1.500 V ) at %7.4r  %M\n", $abstime );
        VAC_retc=0;
        VAC_cnt=VAC_cnt-1;
        $fclose(outfile);
      end
      if((VAC > 1.5) &&  (VAC_retc!=1))
      begin
        outfile=$fopen(errFileName,"a");
        $strobe("dfwdpf        VAC     leaving   OCA ( 1.500 V ..  ) at %7.4r  %M", $abstime );
        $fwrite(outfile,"dfwdpf        VAC     leaving   OCA ( 1.500 V ..  ) at %7.4r  %M\n", $abstime );
        VAC_retc=1;
        VAC_cnt=VAC_cnt-1;
        $fclose(outfile);
      end
   end
   else
   begin
      if(VAC_cnt==0)
      begin
        outfile=$fopen(errFileName,"a");
        $strobe("dfwdpf        VAC     error limit ( %d ) reached at %7.4r  %M", maxEv, $abstime );
        $fwrite(outfile,"dfwdpf        VAC     error limit ( %d ) reached at %7.4r  %M\n", maxEv, $abstime );
        VAC_cnt=VAC_cnt-1;
        $fclose(outfile);
      end
   end

//      If_100n
   If_100n = I_A /  ( m_soa * area / 2e-06 ) ;
   if((If_100n_cnt>0) || ( maxEv_flg==0 ))   begin
      if( (If_100n < -1000) && (If_100n_retc!=-1))
      begin
        outfile=$fopen(errFileName,"a");
        $strobe("dfwdpf        If_100n leaving   OCA (  .. -1.000 mA/um ) at %7.4r  %M", $abstime );
        $fwrite(outfile,"dfwdpf        If_100n leaving   OCA (  .. -1.000 mA/um ) at %7.4r  %M\n", $abstime );
        If_100n_retc=-1;
        If_100n_cnt=If_100n_cnt-1;
        $fclose(outfile);
      end
      if((If_100n >= -1000) &&  (If_100n <= 1000) && (If_100n_retc!=0))
      begin
        outfile=$fopen(errFileName,"a");
        $strobe("dfwdpf        If_100n entering SOCA ( -1.000 mA/um .. 1.000 mA/um ) at %7.4r  %M", $abstime );
        $fwrite(outfile,"dfwdpf        If_100n entering SOCA ( -1.000 mA/um .. 1.000 mA/um ) at %7.4r  %M\n", $abstime );
        If_100n_retc=0;
        If_100n_cnt=If_100n_cnt-1;
        $fclose(outfile);
      end
      if((If_100n > 1000) &&  (If_100n_retc!=1))
      begin
        outfile=$fopen(errFileName,"a");
        $strobe("dfwdpf        If_100n leaving   OCA ( 1.000 mA/um ..  ) at %7.4r  %M", $abstime );
        $fwrite(outfile,"dfwdpf        If_100n leaving   OCA ( 1.000 mA/um ..  ) at %7.4r  %M\n", $abstime );
        If_100n_retc=1;
        If_100n_cnt=If_100n_cnt-1;
        $fclose(outfile);
      end
   end
   else
   begin
      if(If_100n_cnt==0)
      begin
        outfile=$fopen(errFileName,"a");
        $strobe("dfwdpf        If_100n error limit ( %d ) reached at %7.4r  %M", maxEv, $abstime );
        $fwrite(outfile,"dfwdpf        If_100n error limit ( %d ) reached at %7.4r  %M\n", maxEv, $abstime );
        If_100n_cnt=If_100n_cnt-1;
        $fclose(outfile);
      end
   end

//      If_DC
   If_DC = I_A /  ( m_soa * area / 2e-06 ) ;
   if((If_DC_cnt>0) || ( maxEv_flg==0 ))   begin
      if( (If_DC < -1000) && (If_DC_retc!=-1))
      begin
        outfile=$fopen(errFileName,"a");
        $strobe("dfwdpf        If_DC   leaving   OCA (  .. -1.000 mA/um ) at %7.4r  %M", $abstime );
        $fwrite(outfile,"dfwdpf        If_DC   leaving   OCA (  .. -1.000 mA/um ) at %7.4r  %M\n", $abstime );
        If_DC_retc=-1;
        If_DC_cnt=If_DC_cnt-1;
        $fclose(outfile);
      end
      if((If_DC >= -1000) &&  (If_DC <= 100) && (If_DC_retc!=0))
      begin
        outfile=$fopen(errFileName,"a");
        $strobe("dfwdpf        If_DC   entering SOCA ( -1.000 mA/um .. 100.000 uA/um ) at %7.4r  %M", $abstime );
        $fwrite(outfile,"dfwdpf        If_DC   entering SOCA ( -1.000 mA/um .. 100.000 uA/um ) at %7.4r  %M\n", $abstime );
        If_DC_retc=0;
        If_DC_cnt=If_DC_cnt-1;
        $fclose(outfile);
      end
      if((If_DC > 100) &&  (If_DC_retc!=1))
      begin
        outfile=$fopen(errFileName,"a");
        $strobe("dfwdpf        If_DC   leaving   OCA ( 100.000 uA/um ..  ) at %7.4r  %M", $abstime );
        $fwrite(outfile,"dfwdpf        If_DC   leaving   OCA ( 100.000 uA/um ..  ) at %7.4r  %M\n", $abstime );
        If_DC_retc=1;
        If_DC_cnt=If_DC_cnt-1;
        $fclose(outfile);
      end
   end
   else
   begin
      if(If_DC_cnt==0)
      begin
        outfile=$fopen(errFileName,"a");
        $strobe("dfwdpf        If_DC   error limit ( %d ) reached at %7.4r  %M", maxEv, $abstime );
        $fwrite(outfile,"dfwdpf        If_DC   error limit ( %d ) reached at %7.4r  %M\n", maxEv, $abstime );
        If_DC_cnt=If_DC_cnt-1;
        $fclose(outfile);
      end
   end

end // analog
endmodule // dfwdpf

// Verilog-A OC Watch for device dfwdnt Parameters  VAC If_100n If_DC
module dfwdnt_ahdl(A1,C1,A,C);
parameter tstep_occ=100n;
parameter errFileName="./occ.err";
parameter area = 1u;
parameter m_soa = 1;
parameter maxEv = 25;
parameter maxEv_flg = 0;
inout A1,C1,A,C;
electrical A1,C1,A,C;

integer outfile;
real V_A_C;
real I_C;
real I_A;
real VAC;
integer VAC_retc;
integer VAC_cnt;
real If_100n;
integer If_100n_retc;
integer If_100n_cnt;
real If_DC;
integer If_DC_retc;
integer If_DC_cnt;

analog begin
   $bound_step( tstep_occ );
   @(initial_step) begin
      VAC_retc=0;
      VAC_cnt = maxEv;
      If_100n_retc=0;
      If_100n_cnt = maxEv;
      If_DC_retc=0;
      If_DC_cnt = maxEv;
   end
   V_A_C = V(A,C);
   I_C = I(C1,C);
   I_A = I(A1,A);

//      VAC
   VAC = V_A_C;
   if((VAC_cnt>0) || ( maxEv_flg==0 ))   begin
      if( (VAC < -40) && (VAC_retc!=-1))
      begin
        outfile=$fopen(errFileName,"a");
        $strobe("dfwdnt        VAC     leaving   OCA (  .. -40.000 V ) at %7.4r  %M", $abstime );
        $fwrite(outfile,"dfwdnt        VAC     leaving   OCA (  .. -40.000 V ) at %7.4r  %M\n", $abstime );
        VAC_retc=-1;
        VAC_cnt=VAC_cnt-1;
        $fclose(outfile);
      end
      if((VAC >= -40) &&  (VAC <= 1.5) && (VAC_retc!=0))
      begin
        outfile=$fopen(errFileName,"a");
        $strobe("dfwdnt        VAC     entering SOCA ( -40.000 V .. 1.500 V ) at %7.4r  %M", $abstime );
        $fwrite(outfile,"dfwdnt        VAC     entering SOCA ( -40.000 V .. 1.500 V ) at %7.4r  %M\n", $abstime );
        VAC_retc=0;
        VAC_cnt=VAC_cnt-1;
        $fclose(outfile);
      end
      if((VAC > 1.5) &&  (VAC_retc!=1))
      begin
        outfile=$fopen(errFileName,"a");
        $strobe("dfwdnt        VAC     leaving   OCA ( 1.500 V ..  ) at %7.4r  %M", $abstime );
        $fwrite(outfile,"dfwdnt        VAC     leaving   OCA ( 1.500 V ..  ) at %7.4r  %M\n", $abstime );
        VAC_retc=1;
        VAC_cnt=VAC_cnt-1;
        $fclose(outfile);
      end
   end
   else
   begin
      if(VAC_cnt==0)
      begin
        outfile=$fopen(errFileName,"a");
        $strobe("dfwdnt        VAC     error limit ( %d ) reached at %7.4r  %M", maxEv, $abstime );
        $fwrite(outfile,"dfwdnt        VAC     error limit ( %d ) reached at %7.4r  %M\n", maxEv, $abstime );
        VAC_cnt=VAC_cnt-1;
        $fclose(outfile);
      end
   end

//      If_100n
   If_100n = I_A /  ( m_soa * area / 3.36e-06 ) ;
   if((If_100n_cnt>0) || ( maxEv_flg==0 ))   begin
      if( (If_100n < -1000) && (If_100n_retc!=-1))
      begin
        outfile=$fopen(errFileName,"a");
        $strobe("dfwdnt        If_100n leaving   OCA (  .. -1.000 mA/um ) at %7.4r  %M", $abstime );
        $fwrite(outfile,"dfwdnt        If_100n leaving   OCA (  .. -1.000 mA/um ) at %7.4r  %M\n", $abstime );
        If_100n_retc=-1;
        If_100n_cnt=If_100n_cnt-1;
        $fclose(outfile);
      end
      if((If_100n >= -1000) &&  (If_100n <= 1000) && (If_100n_retc!=0))
      begin
        outfile=$fopen(errFileName,"a");
        $strobe("dfwdnt        If_100n entering SOCA ( -1.000 mA/um .. 1.000 mA/um ) at %7.4r  %M", $abstime );
        $fwrite(outfile,"dfwdnt        If_100n entering SOCA ( -1.000 mA/um .. 1.000 mA/um ) at %7.4r  %M\n", $abstime );
        If_100n_retc=0;
        If_100n_cnt=If_100n_cnt-1;
        $fclose(outfile);
      end
      if((If_100n > 1000) &&  (If_100n_retc!=1))
      begin
        outfile=$fopen(errFileName,"a");
        $strobe("dfwdnt        If_100n leaving   OCA ( 1.000 mA/um ..  ) at %7.4r  %M", $abstime );
        $fwrite(outfile,"dfwdnt        If_100n leaving   OCA ( 1.000 mA/um ..  ) at %7.4r  %M\n", $abstime );
        If_100n_retc=1;
        If_100n_cnt=If_100n_cnt-1;
        $fclose(outfile);
      end
   end
   else
   begin
      if(If_100n_cnt==0)
      begin
        outfile=$fopen(errFileName,"a");
        $strobe("dfwdnt        If_100n error limit ( %d ) reached at %7.4r  %M", maxEv, $abstime );
        $fwrite(outfile,"dfwdnt        If_100n error limit ( %d ) reached at %7.4r  %M\n", maxEv, $abstime );
        If_100n_cnt=If_100n_cnt-1;
        $fclose(outfile);
      end
   end

//      If_DC
   If_DC = I_A /  ( m_soa * area / 3.36e-06 ) ;
   if((If_DC_cnt>0) || ( maxEv_flg==0 ))   begin
      if( (If_DC < -1000) && (If_DC_retc!=-1))
      begin
        outfile=$fopen(errFileName,"a");
        $strobe("dfwdnt        If_DC   leaving   OCA (  .. -1.000 mA/um ) at %7.4r  %M", $abstime );
        $fwrite(outfile,"dfwdnt        If_DC   leaving   OCA (  .. -1.000 mA/um ) at %7.4r  %M\n", $abstime );
        If_DC_retc=-1;
        If_DC_cnt=If_DC_cnt-1;
        $fclose(outfile);
      end
      if((If_DC >= -1000) &&  (If_DC <= 100) && (If_DC_retc!=0))
      begin
        outfile=$fopen(errFileName,"a");
        $strobe("dfwdnt        If_DC   entering SOCA ( -1.000 mA/um .. 100.000 uA/um ) at %7.4r  %M", $abstime );
        $fwrite(outfile,"dfwdnt        If_DC   entering SOCA ( -1.000 mA/um .. 100.000 uA/um ) at %7.4r  %M\n", $abstime );
        If_DC_retc=0;
        If_DC_cnt=If_DC_cnt-1;
        $fclose(outfile);
      end
      if((If_DC > 100) &&  (If_DC_retc!=1))
      begin
        outfile=$fopen(errFileName,"a");
        $strobe("dfwdnt        If_DC   leaving   OCA ( 100.000 uA/um ..  ) at %7.4r  %M", $abstime );
        $fwrite(outfile,"dfwdnt        If_DC   leaving   OCA ( 100.000 uA/um ..  ) at %7.4r  %M\n", $abstime );
        If_DC_retc=1;
        If_DC_cnt=If_DC_cnt-1;
        $fclose(outfile);
      end
   end
   else
   begin
      if(If_DC_cnt==0)
      begin
        outfile=$fopen(errFileName,"a");
        $strobe("dfwdnt        If_DC   error limit ( %d ) reached at %7.4r  %M", maxEv, $abstime );
        $fwrite(outfile,"dfwdnt        If_DC   error limit ( %d ) reached at %7.4r  %M\n", maxEv, $abstime );
        If_DC_cnt=If_DC_cnt-1;
        $fclose(outfile);
      end
   end

end // analog
endmodule // dfwdnt

// Verilog-A OC Watch for device dfwdnu Parameters  VAC If_100n If_DC
module dfwdnu_ahdl(A1,C1,A,C);
parameter tstep_occ=100n;
parameter errFileName="./occ.err";
parameter area = 1u;
parameter m_soa = 1;
parameter maxEv = 25;
parameter maxEv_flg = 0;
inout A1,C1,A,C;
electrical A1,C1,A,C;

integer outfile;
real V_A_C;
real I_C;
real I_A;
real VAC;
integer VAC_retc;
integer VAC_cnt;
real If_100n;
integer If_100n_retc;
integer If_100n_cnt;
real If_DC;
integer If_DC_retc;
integer If_DC_cnt;

analog begin
   $bound_step( tstep_occ );
   @(initial_step) begin
      VAC_retc=0;
      VAC_cnt = maxEv;
      If_100n_retc=0;
      If_100n_cnt = maxEv;
      If_DC_retc=0;
      If_DC_cnt = maxEv;
   end
   V_A_C = V(A,C);
   I_C = I(C1,C);
   I_A = I(A1,A);

//      VAC
   VAC = V_A_C;
   if((VAC_cnt>0) || ( maxEv_flg==0 ))   begin
      if( (VAC < -60) && (VAC_retc!=-1))
      begin
        outfile=$fopen(errFileName,"a");
        $strobe("dfwdnu        VAC     leaving   OCA (  .. -60.000 V ) at %7.4r  %M", $abstime );
        $fwrite(outfile,"dfwdnu        VAC     leaving   OCA (  .. -60.000 V ) at %7.4r  %M\n", $abstime );
        VAC_retc=-1;
        VAC_cnt=VAC_cnt-1;
        $fclose(outfile);
      end
      if((VAC >= -60) &&  (VAC <= 1.5) && (VAC_retc!=0))
      begin
        outfile=$fopen(errFileName,"a");
        $strobe("dfwdnu        VAC     entering SOCA ( -60.000 V .. 1.500 V ) at %7.4r  %M", $abstime );
        $fwrite(outfile,"dfwdnu        VAC     entering SOCA ( -60.000 V .. 1.500 V ) at %7.4r  %M\n", $abstime );
        VAC_retc=0;
        VAC_cnt=VAC_cnt-1;
        $fclose(outfile);
      end
      if((VAC > 1.5) &&  (VAC_retc!=1))
      begin
        outfile=$fopen(errFileName,"a");
        $strobe("dfwdnu        VAC     leaving   OCA ( 1.500 V ..  ) at %7.4r  %M", $abstime );
        $fwrite(outfile,"dfwdnu        VAC     leaving   OCA ( 1.500 V ..  ) at %7.4r  %M\n", $abstime );
        VAC_retc=1;
        VAC_cnt=VAC_cnt-1;
        $fclose(outfile);
      end
   end
   else
   begin
      if(VAC_cnt==0)
      begin
        outfile=$fopen(errFileName,"a");
        $strobe("dfwdnu        VAC     error limit ( %d ) reached at %7.4r  %M", maxEv, $abstime );
        $fwrite(outfile,"dfwdnu        VAC     error limit ( %d ) reached at %7.4r  %M\n", maxEv, $abstime );
        VAC_cnt=VAC_cnt-1;
        $fclose(outfile);
      end
   end

//      If_100n
   If_100n = I_A /  ( m_soa * area / 5.41e-06 ) ;
   if((If_100n_cnt>0) || ( maxEv_flg==0 ))   begin
      if( (If_100n < -1000) && (If_100n_retc!=-1))
      begin
        outfile=$fopen(errFileName,"a");
        $strobe("dfwdnu        If_100n leaving   OCA (  .. -1.000 mA/um ) at %7.4r  %M", $abstime );
        $fwrite(outfile,"dfwdnu        If_100n leaving   OCA (  .. -1.000 mA/um ) at %7.4r  %M\n", $abstime );
        If_100n_retc=-1;
        If_100n_cnt=If_100n_cnt-1;
        $fclose(outfile);
      end
      if((If_100n >= -1000) &&  (If_100n <= 1000) && (If_100n_retc!=0))
      begin
        outfile=$fopen(errFileName,"a");
        $strobe("dfwdnu        If_100n entering SOCA ( -1.000 mA/um .. 1.000 mA/um ) at %7.4r  %M", $abstime );
        $fwrite(outfile,"dfwdnu        If_100n entering SOCA ( -1.000 mA/um .. 1.000 mA/um ) at %7.4r  %M\n", $abstime );
        If_100n_retc=0;
        If_100n_cnt=If_100n_cnt-1;
        $fclose(outfile);
      end
      if((If_100n > 1000) &&  (If_100n_retc!=1))
      begin
        outfile=$fopen(errFileName,"a");
        $strobe("dfwdnu        If_100n leaving   OCA ( 1.000 mA/um ..  ) at %7.4r  %M", $abstime );
        $fwrite(outfile,"dfwdnu        If_100n leaving   OCA ( 1.000 mA/um ..  ) at %7.4r  %M\n", $abstime );
        If_100n_retc=1;
        If_100n_cnt=If_100n_cnt-1;
        $fclose(outfile);
      end
   end
   else
   begin
      if(If_100n_cnt==0)
      begin
        outfile=$fopen(errFileName,"a");
        $strobe("dfwdnu        If_100n error limit ( %d ) reached at %7.4r  %M", maxEv, $abstime );
        $fwrite(outfile,"dfwdnu        If_100n error limit ( %d ) reached at %7.4r  %M\n", maxEv, $abstime );
        If_100n_cnt=If_100n_cnt-1;
        $fclose(outfile);
      end
   end

//      If_DC
   If_DC = I_A /  ( m_soa * area / 5.41e-06 ) ;
   if((If_DC_cnt>0) || ( maxEv_flg==0 ))   begin
      if( (If_DC < -1000) && (If_DC_retc!=-1))
      begin
        outfile=$fopen(errFileName,"a");
        $strobe("dfwdnu        If_DC   leaving   OCA (  .. -1.000 mA/um ) at %7.4r  %M", $abstime );
        $fwrite(outfile,"dfwdnu        If_DC   leaving   OCA (  .. -1.000 mA/um ) at %7.4r  %M\n", $abstime );
        If_DC_retc=-1;
        If_DC_cnt=If_DC_cnt-1;
        $fclose(outfile);
      end
      if((If_DC >= -1000) &&  (If_DC <= 100) && (If_DC_retc!=0))
      begin
        outfile=$fopen(errFileName,"a");
        $strobe("dfwdnu        If_DC   entering SOCA ( -1.000 mA/um .. 100.000 uA/um ) at %7.4r  %M", $abstime );
        $fwrite(outfile,"dfwdnu        If_DC   entering SOCA ( -1.000 mA/um .. 100.000 uA/um ) at %7.4r  %M\n", $abstime );
        If_DC_retc=0;
        If_DC_cnt=If_DC_cnt-1;
        $fclose(outfile);
      end
      if((If_DC > 100) &&  (If_DC_retc!=1))
      begin
        outfile=$fopen(errFileName,"a");
        $strobe("dfwdnu        If_DC   leaving   OCA ( 100.000 uA/um ..  ) at %7.4r  %M", $abstime );
        $fwrite(outfile,"dfwdnu        If_DC   leaving   OCA ( 100.000 uA/um ..  ) at %7.4r  %M\n", $abstime );
        If_DC_retc=1;
        If_DC_cnt=If_DC_cnt-1;
        $fclose(outfile);
      end
   end
   else
   begin
      if(If_DC_cnt==0)
      begin
        outfile=$fopen(errFileName,"a");
        $strobe("dfwdnu        If_DC   error limit ( %d ) reached at %7.4r  %M", maxEv, $abstime );
        $fwrite(outfile,"dfwdnu        If_DC   error limit ( %d ) reached at %7.4r  %M\n", maxEv, $abstime );
        If_DC_cnt=If_DC_cnt-1;
        $fclose(outfile);
      end
   end

end // analog
endmodule // dfwdnu

// Verilog-A OC Watch for device dfwdnha Parameters  VAC If_100n If_DC
module dfwdnha_ahdl(A1,C1,A,C);
parameter tstep_occ=100n;
parameter errFileName="./occ.err";
parameter area = 1u;
parameter m_soa = 1;
parameter maxEv = 25;
parameter maxEv_flg = 0;
inout A1,C1,A,C;
electrical A1,C1,A,C;

integer outfile;
real V_A_C;
real I_C;
real I_A;
real VAC;
integer VAC_retc;
integer VAC_cnt;
real If_100n;
integer If_100n_retc;
integer If_100n_cnt;
real If_DC;
integer If_DC_retc;
integer If_DC_cnt;

analog begin
   $bound_step( tstep_occ );
   @(initial_step) begin
      VAC_retc=0;
      VAC_cnt = maxEv;
      If_100n_retc=0;
      If_100n_cnt = maxEv;
      If_DC_retc=0;
      If_DC_cnt = maxEv;
   end
   V_A_C = V(A,C);
   I_C = I(C1,C);
   I_A = I(A1,A);

//      VAC
   VAC = V_A_C;
   if((VAC_cnt>0) || ( maxEv_flg==0 ))   begin
      if( (VAC < -40) && (VAC_retc!=-1))
      begin
        outfile=$fopen(errFileName,"a");
        $strobe("dfwdnha       VAC     leaving   OCA (  .. -40.000 V ) at %7.4r  %M", $abstime );
        $fwrite(outfile,"dfwdnha       VAC     leaving   OCA (  .. -40.000 V ) at %7.4r  %M\n", $abstime );
        VAC_retc=-1;
        VAC_cnt=VAC_cnt-1;
        $fclose(outfile);
      end
      if((VAC >= -40) &&  (VAC <= 1.5) && (VAC_retc!=0))
      begin
        outfile=$fopen(errFileName,"a");
        $strobe("dfwdnha       VAC     entering SOCA ( -40.000 V .. 1.500 V ) at %7.4r  %M", $abstime );
        $fwrite(outfile,"dfwdnha       VAC     entering SOCA ( -40.000 V .. 1.500 V ) at %7.4r  %M\n", $abstime );
        VAC_retc=0;
        VAC_cnt=VAC_cnt-1;
        $fclose(outfile);
      end
      if((VAC > 1.5) &&  (VAC_retc!=1))
      begin
        outfile=$fopen(errFileName,"a");
        $strobe("dfwdnha       VAC     leaving   OCA ( 1.500 V ..  ) at %7.4r  %M", $abstime );
        $fwrite(outfile,"dfwdnha       VAC     leaving   OCA ( 1.500 V ..  ) at %7.4r  %M\n", $abstime );
        VAC_retc=1;
        VAC_cnt=VAC_cnt-1;
        $fclose(outfile);
      end
   end
   else
   begin
      if(VAC_cnt==0)
      begin
        outfile=$fopen(errFileName,"a");
        $strobe("dfwdnha       VAC     error limit ( %d ) reached at %7.4r  %M", maxEv, $abstime );
        $fwrite(outfile,"dfwdnha       VAC     error limit ( %d ) reached at %7.4r  %M\n", maxEv, $abstime );
        VAC_cnt=VAC_cnt-1;
        $fclose(outfile);
      end
   end

//      If_100n
   If_100n = I_A /  ( m_soa * area / 2.56e-06 ) ;
   if((If_100n_cnt>0) || ( maxEv_flg==0 ))   begin
      if( (If_100n < -1000) && (If_100n_retc!=-1))
      begin
        outfile=$fopen(errFileName,"a");
        $strobe("dfwdnha       If_100n leaving   OCA (  .. -1.000 mA/um ) at %7.4r  %M", $abstime );
        $fwrite(outfile,"dfwdnha       If_100n leaving   OCA (  .. -1.000 mA/um ) at %7.4r  %M\n", $abstime );
        If_100n_retc=-1;
        If_100n_cnt=If_100n_cnt-1;
        $fclose(outfile);
      end
      if((If_100n >= -1000) &&  (If_100n <= 1000) && (If_100n_retc!=0))
      begin
        outfile=$fopen(errFileName,"a");
        $strobe("dfwdnha       If_100n entering SOCA ( -1.000 mA/um .. 1.000 mA/um ) at %7.4r  %M", $abstime );
        $fwrite(outfile,"dfwdnha       If_100n entering SOCA ( -1.000 mA/um .. 1.000 mA/um ) at %7.4r  %M\n", $abstime );
        If_100n_retc=0;
        If_100n_cnt=If_100n_cnt-1;
        $fclose(outfile);
      end
      if((If_100n > 1000) &&  (If_100n_retc!=1))
      begin
        outfile=$fopen(errFileName,"a");
        $strobe("dfwdnha       If_100n leaving   OCA ( 1.000 mA/um ..  ) at %7.4r  %M", $abstime );
        $fwrite(outfile,"dfwdnha       If_100n leaving   OCA ( 1.000 mA/um ..  ) at %7.4r  %M\n", $abstime );
        If_100n_retc=1;
        If_100n_cnt=If_100n_cnt-1;
        $fclose(outfile);
      end
   end
   else
   begin
      if(If_100n_cnt==0)
      begin
        outfile=$fopen(errFileName,"a");
        $strobe("dfwdnha       If_100n error limit ( %d ) reached at %7.4r  %M", maxEv, $abstime );
        $fwrite(outfile,"dfwdnha       If_100n error limit ( %d ) reached at %7.4r  %M\n", maxEv, $abstime );
        If_100n_cnt=If_100n_cnt-1;
        $fclose(outfile);
      end
   end

//      If_DC
   If_DC = I_A /  ( m_soa * area / 2.56e-06 ) ;
   if((If_DC_cnt>0) || ( maxEv_flg==0 ))   begin
      if( (If_DC < -1000) && (If_DC_retc!=-1))
      begin
        outfile=$fopen(errFileName,"a");
        $strobe("dfwdnha       If_DC   leaving   OCA (  .. -1.000 mA/um ) at %7.4r  %M", $abstime );
        $fwrite(outfile,"dfwdnha       If_DC   leaving   OCA (  .. -1.000 mA/um ) at %7.4r  %M\n", $abstime );
        If_DC_retc=-1;
        If_DC_cnt=If_DC_cnt-1;
        $fclose(outfile);
      end
      if((If_DC >= -1000) &&  (If_DC <= 100) && (If_DC_retc!=0))
      begin
        outfile=$fopen(errFileName,"a");
        $strobe("dfwdnha       If_DC   entering SOCA ( -1.000 mA/um .. 100.000 uA/um ) at %7.4r  %M", $abstime );
        $fwrite(outfile,"dfwdnha       If_DC   entering SOCA ( -1.000 mA/um .. 100.000 uA/um ) at %7.4r  %M\n", $abstime );
        If_DC_retc=0;
        If_DC_cnt=If_DC_cnt-1;
        $fclose(outfile);
      end
      if((If_DC > 100) &&  (If_DC_retc!=1))
      begin
        outfile=$fopen(errFileName,"a");
        $strobe("dfwdnha       If_DC   leaving   OCA ( 100.000 uA/um ..  ) at %7.4r  %M", $abstime );
        $fwrite(outfile,"dfwdnha       If_DC   leaving   OCA ( 100.000 uA/um ..  ) at %7.4r  %M\n", $abstime );
        If_DC_retc=1;
        If_DC_cnt=If_DC_cnt-1;
        $fclose(outfile);
      end
   end
   else
   begin
      if(If_DC_cnt==0)
      begin
        outfile=$fopen(errFileName,"a");
        $strobe("dfwdnha       If_DC   error limit ( %d ) reached at %7.4r  %M", maxEv, $abstime );
        $fwrite(outfile,"dfwdnha       If_DC   error limit ( %d ) reached at %7.4r  %M\n", maxEv, $abstime );
        If_DC_cnt=If_DC_cnt-1;
        $fclose(outfile);
      end
   end

end // analog
endmodule // dfwdnha

// Verilog-A OC Watch for device dfwdnhb Parameters  VAC If_100n If_DC
module dfwdnhb_ahdl(A1,C1,A,C);
parameter tstep_occ=100n;
parameter errFileName="./occ.err";
parameter area = 1u;
parameter m_soa = 1;
parameter maxEv = 25;
parameter maxEv_flg = 0;
inout A1,C1,A,C;
electrical A1,C1,A,C;

integer outfile;
real V_A_C;
real I_C;
real I_A;
real VAC;
integer VAC_retc;
integer VAC_cnt;
real If_100n;
integer If_100n_retc;
integer If_100n_cnt;
real If_DC;
integer If_DC_retc;
integer If_DC_cnt;

analog begin
   $bound_step( tstep_occ );
   @(initial_step) begin
      VAC_retc=0;
      VAC_cnt = maxEv;
      If_100n_retc=0;
      If_100n_cnt = maxEv;
      If_DC_retc=0;
      If_DC_cnt = maxEv;
   end
   V_A_C = V(A,C);
   I_C = I(C1,C);
   I_A = I(A1,A);

//      VAC
   VAC = V_A_C;
   if((VAC_cnt>0) || ( maxEv_flg==0 ))   begin
      if( (VAC < -60) && (VAC_retc!=-1))
      begin
        outfile=$fopen(errFileName,"a");
        $strobe("dfwdnhb       VAC     leaving   OCA (  .. -60.000 V ) at %7.4r  %M", $abstime );
        $fwrite(outfile,"dfwdnhb       VAC     leaving   OCA (  .. -60.000 V ) at %7.4r  %M\n", $abstime );
        VAC_retc=-1;
        VAC_cnt=VAC_cnt-1;
        $fclose(outfile);
      end
      if((VAC >= -60) &&  (VAC <= 1.5) && (VAC_retc!=0))
      begin
        outfile=$fopen(errFileName,"a");
        $strobe("dfwdnhb       VAC     entering SOCA ( -60.000 V .. 1.500 V ) at %7.4r  %M", $abstime );
        $fwrite(outfile,"dfwdnhb       VAC     entering SOCA ( -60.000 V .. 1.500 V ) at %7.4r  %M\n", $abstime );
        VAC_retc=0;
        VAC_cnt=VAC_cnt-1;
        $fclose(outfile);
      end
      if((VAC > 1.5) &&  (VAC_retc!=1))
      begin
        outfile=$fopen(errFileName,"a");
        $strobe("dfwdnhb       VAC     leaving   OCA ( 1.500 V ..  ) at %7.4r  %M", $abstime );
        $fwrite(outfile,"dfwdnhb       VAC     leaving   OCA ( 1.500 V ..  ) at %7.4r  %M\n", $abstime );
        VAC_retc=1;
        VAC_cnt=VAC_cnt-1;
        $fclose(outfile);
      end
   end
   else
   begin
      if(VAC_cnt==0)
      begin
        outfile=$fopen(errFileName,"a");
        $strobe("dfwdnhb       VAC     error limit ( %d ) reached at %7.4r  %M", maxEv, $abstime );
        $fwrite(outfile,"dfwdnhb       VAC     error limit ( %d ) reached at %7.4r  %M\n", maxEv, $abstime );
        VAC_cnt=VAC_cnt-1;
        $fclose(outfile);
      end
   end

//      If_100n
   If_100n = I_A /  ( m_soa * area / 3.66e-06 ) ;
   if((If_100n_cnt>0) || ( maxEv_flg==0 ))   begin
      if( (If_100n < -1000) && (If_100n_retc!=-1))
      begin
        outfile=$fopen(errFileName,"a");
        $strobe("dfwdnhb       If_100n leaving   OCA (  .. -1.000 mA/um ) at %7.4r  %M", $abstime );
        $fwrite(outfile,"dfwdnhb       If_100n leaving   OCA (  .. -1.000 mA/um ) at %7.4r  %M\n", $abstime );
        If_100n_retc=-1;
        If_100n_cnt=If_100n_cnt-1;
        $fclose(outfile);
      end
      if((If_100n >= -1000) &&  (If_100n <= 1000) && (If_100n_retc!=0))
      begin
        outfile=$fopen(errFileName,"a");
        $strobe("dfwdnhb       If_100n entering SOCA ( -1.000 mA/um .. 1.000 mA/um ) at %7.4r  %M", $abstime );
        $fwrite(outfile,"dfwdnhb       If_100n entering SOCA ( -1.000 mA/um .. 1.000 mA/um ) at %7.4r  %M\n", $abstime );
        If_100n_retc=0;
        If_100n_cnt=If_100n_cnt-1;
        $fclose(outfile);
      end
      if((If_100n > 1000) &&  (If_100n_retc!=1))
      begin
        outfile=$fopen(errFileName,"a");
        $strobe("dfwdnhb       If_100n leaving   OCA ( 1.000 mA/um ..  ) at %7.4r  %M", $abstime );
        $fwrite(outfile,"dfwdnhb       If_100n leaving   OCA ( 1.000 mA/um ..  ) at %7.4r  %M\n", $abstime );
        If_100n_retc=1;
        If_100n_cnt=If_100n_cnt-1;
        $fclose(outfile);
      end
   end
   else
   begin
      if(If_100n_cnt==0)
      begin
        outfile=$fopen(errFileName,"a");
        $strobe("dfwdnhb       If_100n error limit ( %d ) reached at %7.4r  %M", maxEv, $abstime );
        $fwrite(outfile,"dfwdnhb       If_100n error limit ( %d ) reached at %7.4r  %M\n", maxEv, $abstime );
        If_100n_cnt=If_100n_cnt-1;
        $fclose(outfile);
      end
   end

//      If_DC
   If_DC = I_A /  ( m_soa * area / 3.66e-06 ) ;
   if((If_DC_cnt>0) || ( maxEv_flg==0 ))   begin
      if( (If_DC < -1000) && (If_DC_retc!=-1))
      begin
        outfile=$fopen(errFileName,"a");
        $strobe("dfwdnhb       If_DC   leaving   OCA (  .. -1.000 mA/um ) at %7.4r  %M", $abstime );
        $fwrite(outfile,"dfwdnhb       If_DC   leaving   OCA (  .. -1.000 mA/um ) at %7.4r  %M\n", $abstime );
        If_DC_retc=-1;
        If_DC_cnt=If_DC_cnt-1;
        $fclose(outfile);
      end
      if((If_DC >= -1000) &&  (If_DC <= 100) && (If_DC_retc!=0))
      begin
        outfile=$fopen(errFileName,"a");
        $strobe("dfwdnhb       If_DC   entering SOCA ( -1.000 mA/um .. 100.000 uA/um ) at %7.4r  %M", $abstime );
        $fwrite(outfile,"dfwdnhb       If_DC   entering SOCA ( -1.000 mA/um .. 100.000 uA/um ) at %7.4r  %M\n", $abstime );
        If_DC_retc=0;
        If_DC_cnt=If_DC_cnt-1;
        $fclose(outfile);
      end
      if((If_DC > 100) &&  (If_DC_retc!=1))
      begin
        outfile=$fopen(errFileName,"a");
        $strobe("dfwdnhb       If_DC   leaving   OCA ( 100.000 uA/um ..  ) at %7.4r  %M", $abstime );
        $fwrite(outfile,"dfwdnhb       If_DC   leaving   OCA ( 100.000 uA/um ..  ) at %7.4r  %M\n", $abstime );
        If_DC_retc=1;
        If_DC_cnt=If_DC_cnt-1;
        $fclose(outfile);
      end
   end
   else
   begin
      if(If_DC_cnt==0)
      begin
        outfile=$fopen(errFileName,"a");
        $strobe("dfwdnhb       If_DC   error limit ( %d ) reached at %7.4r  %M", maxEv, $abstime );
        $fwrite(outfile,"dfwdnhb       If_DC   error limit ( %d ) reached at %7.4r  %M\n", maxEv, $abstime );
        If_DC_cnt=If_DC_cnt-1;
        $fclose(outfile);
      end
   end

end // analog
endmodule // dfwdnhb

// Verilog-A OC Watch for device dfwdphb Parameters  VAC If_100n If_DC
module dfwdphb_ahdl(A1,C1,A,C);
parameter tstep_occ=100n;
parameter errFileName="./occ.err";
parameter area = 1u;
parameter m_soa = 1;
parameter maxEv = 25;
parameter maxEv_flg = 0;
inout A1,C1,A,C;
electrical A1,C1,A,C;

integer outfile;
real V_A_C;
real I_C;
real I_A;
real VAC;
integer VAC_retc;
integer VAC_cnt;
real If_100n;
integer If_100n_retc;
integer If_100n_cnt;
real If_DC;
integer If_DC_retc;
integer If_DC_cnt;

analog begin
   $bound_step( tstep_occ );
   @(initial_step) begin
      VAC_retc=0;
      VAC_cnt = maxEv;
      If_100n_retc=0;
      If_100n_cnt = maxEv;
      If_DC_retc=0;
      If_DC_cnt = maxEv;
   end
   V_A_C = V(A,C);
   I_C = I(C1,C);
   I_A = I(A1,A);

//      VAC
   VAC = V_A_C;
   if((VAC_cnt>0) || ( maxEv_flg==0 ))   begin
      if( (VAC < -60) && (VAC_retc!=-1))
      begin
        outfile=$fopen(errFileName,"a");
        $strobe("dfwdphb       VAC     leaving   OCA (  .. -60.000 V ) at %7.4r  %M", $abstime );
        $fwrite(outfile,"dfwdphb       VAC     leaving   OCA (  .. -60.000 V ) at %7.4r  %M\n", $abstime );
        VAC_retc=-1;
        VAC_cnt=VAC_cnt-1;
        $fclose(outfile);
      end
      if((VAC >= -60) &&  (VAC <= 1.5) && (VAC_retc!=0))
      begin
        outfile=$fopen(errFileName,"a");
        $strobe("dfwdphb       VAC     entering SOCA ( -60.000 V .. 1.500 V ) at %7.4r  %M", $abstime );
        $fwrite(outfile,"dfwdphb       VAC     entering SOCA ( -60.000 V .. 1.500 V ) at %7.4r  %M\n", $abstime );
        VAC_retc=0;
        VAC_cnt=VAC_cnt-1;
        $fclose(outfile);
      end
      if((VAC > 1.5) &&  (VAC_retc!=1))
      begin
        outfile=$fopen(errFileName,"a");
        $strobe("dfwdphb       VAC     leaving   OCA ( 1.500 V ..  ) at %7.4r  %M", $abstime );
        $fwrite(outfile,"dfwdphb       VAC     leaving   OCA ( 1.500 V ..  ) at %7.4r  %M\n", $abstime );
        VAC_retc=1;
        VAC_cnt=VAC_cnt-1;
        $fclose(outfile);
      end
   end
   else
   begin
      if(VAC_cnt==0)
      begin
        outfile=$fopen(errFileName,"a");
        $strobe("dfwdphb       VAC     error limit ( %d ) reached at %7.4r  %M", maxEv, $abstime );
        $fwrite(outfile,"dfwdphb       VAC     error limit ( %d ) reached at %7.4r  %M\n", maxEv, $abstime );
        VAC_cnt=VAC_cnt-1;
        $fclose(outfile);
      end
   end

//      If_100n
   If_100n = I_A /  ( m_soa * area / 3.66e-06 ) ;
   if((If_100n_cnt>0) || ( maxEv_flg==0 ))   begin
      if( (If_100n < -1000) && (If_100n_retc!=-1))
      begin
        outfile=$fopen(errFileName,"a");
        $strobe("dfwdphb       If_100n leaving   OCA (  .. -1.000 mA/um ) at %7.4r  %M", $abstime );
        $fwrite(outfile,"dfwdphb       If_100n leaving   OCA (  .. -1.000 mA/um ) at %7.4r  %M\n", $abstime );
        If_100n_retc=-1;
        If_100n_cnt=If_100n_cnt-1;
        $fclose(outfile);
      end
      if((If_100n >= -1000) &&  (If_100n <= 1000) && (If_100n_retc!=0))
      begin
        outfile=$fopen(errFileName,"a");
        $strobe("dfwdphb       If_100n entering SOCA ( -1.000 mA/um .. 1.000 mA/um ) at %7.4r  %M", $abstime );
        $fwrite(outfile,"dfwdphb       If_100n entering SOCA ( -1.000 mA/um .. 1.000 mA/um ) at %7.4r  %M\n", $abstime );
        If_100n_retc=0;
        If_100n_cnt=If_100n_cnt-1;
        $fclose(outfile);
      end
      if((If_100n > 1000) &&  (If_100n_retc!=1))
      begin
        outfile=$fopen(errFileName,"a");
        $strobe("dfwdphb       If_100n leaving   OCA ( 1.000 mA/um ..  ) at %7.4r  %M", $abstime );
        $fwrite(outfile,"dfwdphb       If_100n leaving   OCA ( 1.000 mA/um ..  ) at %7.4r  %M\n", $abstime );
        If_100n_retc=1;
        If_100n_cnt=If_100n_cnt-1;
        $fclose(outfile);
      end
   end
   else
   begin
      if(If_100n_cnt==0)
      begin
        outfile=$fopen(errFileName,"a");
        $strobe("dfwdphb       If_100n error limit ( %d ) reached at %7.4r  %M", maxEv, $abstime );
        $fwrite(outfile,"dfwdphb       If_100n error limit ( %d ) reached at %7.4r  %M\n", maxEv, $abstime );
        If_100n_cnt=If_100n_cnt-1;
        $fclose(outfile);
      end
   end

//      If_DC
   If_DC = I_A /  ( m_soa * area / 3.66e-06 ) ;
   if((If_DC_cnt>0) || ( maxEv_flg==0 ))   begin
      if( (If_DC < -1000) && (If_DC_retc!=-1))
      begin
        outfile=$fopen(errFileName,"a");
        $strobe("dfwdphb       If_DC   leaving   OCA (  .. -1.000 mA/um ) at %7.4r  %M", $abstime );
        $fwrite(outfile,"dfwdphb       If_DC   leaving   OCA (  .. -1.000 mA/um ) at %7.4r  %M\n", $abstime );
        If_DC_retc=-1;
        If_DC_cnt=If_DC_cnt-1;
        $fclose(outfile);
      end
      if((If_DC >= -1000) &&  (If_DC <= 100) && (If_DC_retc!=0))
      begin
        outfile=$fopen(errFileName,"a");
        $strobe("dfwdphb       If_DC   entering SOCA ( -1.000 mA/um .. 100.000 uA/um ) at %7.4r  %M", $abstime );
        $fwrite(outfile,"dfwdphb       If_DC   entering SOCA ( -1.000 mA/um .. 100.000 uA/um ) at %7.4r  %M\n", $abstime );
        If_DC_retc=0;
        If_DC_cnt=If_DC_cnt-1;
        $fclose(outfile);
      end
      if((If_DC > 100) &&  (If_DC_retc!=1))
      begin
        outfile=$fopen(errFileName,"a");
        $strobe("dfwdphb       If_DC   leaving   OCA ( 100.000 uA/um ..  ) at %7.4r  %M", $abstime );
        $fwrite(outfile,"dfwdphb       If_DC   leaving   OCA ( 100.000 uA/um ..  ) at %7.4r  %M\n", $abstime );
        If_DC_retc=1;
        If_DC_cnt=If_DC_cnt-1;
        $fclose(outfile);
      end
   end
   else
   begin
      if(If_DC_cnt==0)
      begin
        outfile=$fopen(errFileName,"a");
        $strobe("dfwdphb       If_DC   error limit ( %d ) reached at %7.4r  %M", maxEv, $abstime );
        $fwrite(outfile,"dfwdphb       If_DC   error limit ( %d ) reached at %7.4r  %M\n", maxEv, $abstime );
        If_DC_cnt=If_DC_cnt-1;
        $fclose(outfile);
      end
   end

end // analog
endmodule // dfwdphb

// Verilog-A OC Watch for device dfwdnhc Parameters  VAC If_100n If_DC
module dfwdnhc_ahdl(A1,C1,A,C);
parameter tstep_occ=100n;
parameter errFileName="./occ.err";
parameter area = 1u;
parameter m_soa = 1;
parameter maxEv = 25;
parameter maxEv_flg = 0;
inout A1,C1,A,C;
electrical A1,C1,A,C;

integer outfile;
real V_A_C;
real I_C;
real I_A;
real VAC;
integer VAC_retc;
integer VAC_cnt;
real If_100n;
integer If_100n_retc;
integer If_100n_cnt;
real If_DC;
integer If_DC_retc;
integer If_DC_cnt;

analog begin
   $bound_step( tstep_occ );
   @(initial_step) begin
      VAC_retc=0;
      VAC_cnt = maxEv;
      If_100n_retc=0;
      If_100n_cnt = maxEv;
      If_DC_retc=0;
      If_DC_cnt = maxEv;
   end
   V_A_C = V(A,C);
   I_C = I(C1,C);
   I_A = I(A1,A);

//      VAC
   VAC = V_A_C;
   if((VAC_cnt>0) || ( maxEv_flg==0 ))   begin
      if( (VAC < -70) && (VAC_retc!=-1))
      begin
        outfile=$fopen(errFileName,"a");
        $strobe("dfwdnhc       VAC     leaving   OCA (  .. -70.000 V ) at %7.4r  %M", $abstime );
        $fwrite(outfile,"dfwdnhc       VAC     leaving   OCA (  .. -70.000 V ) at %7.4r  %M\n", $abstime );
        VAC_retc=-1;
        VAC_cnt=VAC_cnt-1;
        $fclose(outfile);
      end
      if((VAC >= -70) &&  (VAC <= 1.5) && (VAC_retc!=0))
      begin
        outfile=$fopen(errFileName,"a");
        $strobe("dfwdnhc       VAC     entering SOCA ( -70.000 V .. 1.500 V ) at %7.4r  %M", $abstime );
        $fwrite(outfile,"dfwdnhc       VAC     entering SOCA ( -70.000 V .. 1.500 V ) at %7.4r  %M\n", $abstime );
        VAC_retc=0;
        VAC_cnt=VAC_cnt-1;
        $fclose(outfile);
      end
      if((VAC > 1.5) &&  (VAC_retc!=1))
      begin
        outfile=$fopen(errFileName,"a");
        $strobe("dfwdnhc       VAC     leaving   OCA ( 1.500 V ..  ) at %7.4r  %M", $abstime );
        $fwrite(outfile,"dfwdnhc       VAC     leaving   OCA ( 1.500 V ..  ) at %7.4r  %M\n", $abstime );
        VAC_retc=1;
        VAC_cnt=VAC_cnt-1;
        $fclose(outfile);
      end
   end
   else
   begin
      if(VAC_cnt==0)
      begin
        outfile=$fopen(errFileName,"a");
        $strobe("dfwdnhc       VAC     error limit ( %d ) reached at %7.4r  %M", maxEv, $abstime );
        $fwrite(outfile,"dfwdnhc       VAC     error limit ( %d ) reached at %7.4r  %M\n", maxEv, $abstime );
        VAC_cnt=VAC_cnt-1;
        $fclose(outfile);
      end
   end

//      If_100n
   If_100n = I_A /  ( m_soa * area / 4.16e-06 ) ;
   if((If_100n_cnt>0) || ( maxEv_flg==0 ))   begin
      if( (If_100n < -1000) && (If_100n_retc!=-1))
      begin
        outfile=$fopen(errFileName,"a");
        $strobe("dfwdnhc       If_100n leaving   OCA (  .. -1.000 mA/um ) at %7.4r  %M", $abstime );
        $fwrite(outfile,"dfwdnhc       If_100n leaving   OCA (  .. -1.000 mA/um ) at %7.4r  %M\n", $abstime );
        If_100n_retc=-1;
        If_100n_cnt=If_100n_cnt-1;
        $fclose(outfile);
      end
      if((If_100n >= -1000) &&  (If_100n <= 1000) && (If_100n_retc!=0))
      begin
        outfile=$fopen(errFileName,"a");
        $strobe("dfwdnhc       If_100n entering SOCA ( -1.000 mA/um .. 1.000 mA/um ) at %7.4r  %M", $abstime );
        $fwrite(outfile,"dfwdnhc       If_100n entering SOCA ( -1.000 mA/um .. 1.000 mA/um ) at %7.4r  %M\n", $abstime );
        If_100n_retc=0;
        If_100n_cnt=If_100n_cnt-1;
        $fclose(outfile);
      end
      if((If_100n > 1000) &&  (If_100n_retc!=1))
      begin
        outfile=$fopen(errFileName,"a");
        $strobe("dfwdnhc       If_100n leaving   OCA ( 1.000 mA/um ..  ) at %7.4r  %M", $abstime );
        $fwrite(outfile,"dfwdnhc       If_100n leaving   OCA ( 1.000 mA/um ..  ) at %7.4r  %M\n", $abstime );
        If_100n_retc=1;
        If_100n_cnt=If_100n_cnt-1;
        $fclose(outfile);
      end
   end
   else
   begin
      if(If_100n_cnt==0)
      begin
        outfile=$fopen(errFileName,"a");
        $strobe("dfwdnhc       If_100n error limit ( %d ) reached at %7.4r  %M", maxEv, $abstime );
        $fwrite(outfile,"dfwdnhc       If_100n error limit ( %d ) reached at %7.4r  %M\n", maxEv, $abstime );
        If_100n_cnt=If_100n_cnt-1;
        $fclose(outfile);
      end
   end

//      If_DC
   If_DC = I_A /  ( m_soa * area / 4.16e-06 ) ;
   if((If_DC_cnt>0) || ( maxEv_flg==0 ))   begin
      if( (If_DC < -1000) && (If_DC_retc!=-1))
      begin
        outfile=$fopen(errFileName,"a");
        $strobe("dfwdnhc       If_DC   leaving   OCA (  .. -1.000 mA/um ) at %7.4r  %M", $abstime );
        $fwrite(outfile,"dfwdnhc       If_DC   leaving   OCA (  .. -1.000 mA/um ) at %7.4r  %M\n", $abstime );
        If_DC_retc=-1;
        If_DC_cnt=If_DC_cnt-1;
        $fclose(outfile);
      end
      if((If_DC >= -1000) &&  (If_DC <= 100) && (If_DC_retc!=0))
      begin
        outfile=$fopen(errFileName,"a");
        $strobe("dfwdnhc       If_DC   entering SOCA ( -1.000 mA/um .. 100.000 uA/um ) at %7.4r  %M", $abstime );
        $fwrite(outfile,"dfwdnhc       If_DC   entering SOCA ( -1.000 mA/um .. 100.000 uA/um ) at %7.4r  %M\n", $abstime );
        If_DC_retc=0;
        If_DC_cnt=If_DC_cnt-1;
        $fclose(outfile);
      end
      if((If_DC > 100) &&  (If_DC_retc!=1))
      begin
        outfile=$fopen(errFileName,"a");
        $strobe("dfwdnhc       If_DC   leaving   OCA ( 100.000 uA/um ..  ) at %7.4r  %M", $abstime );
        $fwrite(outfile,"dfwdnhc       If_DC   leaving   OCA ( 100.000 uA/um ..  ) at %7.4r  %M\n", $abstime );
        If_DC_retc=1;
        If_DC_cnt=If_DC_cnt-1;
        $fclose(outfile);
      end
   end
   else
   begin
      if(If_DC_cnt==0)
      begin
        outfile=$fopen(errFileName,"a");
        $strobe("dfwdnhc       If_DC   error limit ( %d ) reached at %7.4r  %M", maxEv, $abstime );
        $fwrite(outfile,"dfwdnhc       If_DC   error limit ( %d ) reached at %7.4r  %M\n", maxEv, $abstime );
        If_DC_cnt=If_DC_cnt-1;
        $fclose(outfile);
      end
   end

end // analog
endmodule // dfwdnhc

// Verilog-A OC Watch for device dfwdnhd Parameters  VAC If_100n If_DC
module dfwdnhd_ahdl(A1,C1,A,C);
parameter tstep_occ=100n;
parameter errFileName="./occ.err";
parameter area = 1u;
parameter m_soa = 1;
parameter maxEv = 25;
parameter maxEv_flg = 0;
inout A1,C1,A,C;
electrical A1,C1,A,C;

integer outfile;
real V_A_C;
real I_C;
real I_A;
real VAC;
integer VAC_retc;
integer VAC_cnt;
real If_100n;
integer If_100n_retc;
integer If_100n_cnt;
real If_DC;
integer If_DC_retc;
integer If_DC_cnt;

analog begin
   $bound_step( tstep_occ );
   @(initial_step) begin
      VAC_retc=0;
      VAC_cnt = maxEv;
      If_100n_retc=0;
      If_100n_cnt = maxEv;
      If_DC_retc=0;
      If_DC_cnt = maxEv;
   end
   V_A_C = V(A,C);
   I_C = I(C1,C);
   I_A = I(A1,A);

//      VAC
   VAC = V_A_C;
   if((VAC_cnt>0) || ( maxEv_flg==0 ))   begin
      if( (VAC < -85) && (VAC_retc!=-1))
      begin
        outfile=$fopen(errFileName,"a");
        $strobe("dfwdnhd       VAC     leaving   OCA (  .. -85.000 V ) at %7.4r  %M", $abstime );
        $fwrite(outfile,"dfwdnhd       VAC     leaving   OCA (  .. -85.000 V ) at %7.4r  %M\n", $abstime );
        VAC_retc=-1;
        VAC_cnt=VAC_cnt-1;
        $fclose(outfile);
      end
      if((VAC >= -85) &&  (VAC <= 1.5) && (VAC_retc!=0))
      begin
        outfile=$fopen(errFileName,"a");
        $strobe("dfwdnhd       VAC     entering SOCA ( -85.000 V .. 1.500 V ) at %7.4r  %M", $abstime );
        $fwrite(outfile,"dfwdnhd       VAC     entering SOCA ( -85.000 V .. 1.500 V ) at %7.4r  %M\n", $abstime );
        VAC_retc=0;
        VAC_cnt=VAC_cnt-1;
        $fclose(outfile);
      end
      if((VAC > 1.5) &&  (VAC_retc!=1))
      begin
        outfile=$fopen(errFileName,"a");
        $strobe("dfwdnhd       VAC     leaving   OCA ( 1.500 V ..  ) at %7.4r  %M", $abstime );
        $fwrite(outfile,"dfwdnhd       VAC     leaving   OCA ( 1.500 V ..  ) at %7.4r  %M\n", $abstime );
        VAC_retc=1;
        VAC_cnt=VAC_cnt-1;
        $fclose(outfile);
      end
   end
   else
   begin
      if(VAC_cnt==0)
      begin
        outfile=$fopen(errFileName,"a");
        $strobe("dfwdnhd       VAC     error limit ( %d ) reached at %7.4r  %M", maxEv, $abstime );
        $fwrite(outfile,"dfwdnhd       VAC     error limit ( %d ) reached at %7.4r  %M\n", maxEv, $abstime );
        VAC_cnt=VAC_cnt-1;
        $fclose(outfile);
      end
   end

//      If_100n
   If_100n = I_A /  ( m_soa * area / 4.96e-06 ) ;
   if((If_100n_cnt>0) || ( maxEv_flg==0 ))   begin
      if( (If_100n < -1000) && (If_100n_retc!=-1))
      begin
        outfile=$fopen(errFileName,"a");
        $strobe("dfwdnhd       If_100n leaving   OCA (  .. -1.000 mA/um ) at %7.4r  %M", $abstime );
        $fwrite(outfile,"dfwdnhd       If_100n leaving   OCA (  .. -1.000 mA/um ) at %7.4r  %M\n", $abstime );
        If_100n_retc=-1;
        If_100n_cnt=If_100n_cnt-1;
        $fclose(outfile);
      end
      if((If_100n >= -1000) &&  (If_100n <= 1000) && (If_100n_retc!=0))
      begin
        outfile=$fopen(errFileName,"a");
        $strobe("dfwdnhd       If_100n entering SOCA ( -1.000 mA/um .. 1.000 mA/um ) at %7.4r  %M", $abstime );
        $fwrite(outfile,"dfwdnhd       If_100n entering SOCA ( -1.000 mA/um .. 1.000 mA/um ) at %7.4r  %M\n", $abstime );
        If_100n_retc=0;
        If_100n_cnt=If_100n_cnt-1;
        $fclose(outfile);
      end
      if((If_100n > 1000) &&  (If_100n_retc!=1))
      begin
        outfile=$fopen(errFileName,"a");
        $strobe("dfwdnhd       If_100n leaving   OCA ( 1.000 mA/um ..  ) at %7.4r  %M", $abstime );
        $fwrite(outfile,"dfwdnhd       If_100n leaving   OCA ( 1.000 mA/um ..  ) at %7.4r  %M\n", $abstime );
        If_100n_retc=1;
        If_100n_cnt=If_100n_cnt-1;
        $fclose(outfile);
      end
   end
   else
   begin
      if(If_100n_cnt==0)
      begin
        outfile=$fopen(errFileName,"a");
        $strobe("dfwdnhd       If_100n error limit ( %d ) reached at %7.4r  %M", maxEv, $abstime );
        $fwrite(outfile,"dfwdnhd       If_100n error limit ( %d ) reached at %7.4r  %M\n", maxEv, $abstime );
        If_100n_cnt=If_100n_cnt-1;
        $fclose(outfile);
      end
   end

//      If_DC
   If_DC = I_A /  ( m_soa * area / 4.96e-06 ) ;
   if((If_DC_cnt>0) || ( maxEv_flg==0 ))   begin
      if( (If_DC < -1000) && (If_DC_retc!=-1))
      begin
        outfile=$fopen(errFileName,"a");
        $strobe("dfwdnhd       If_DC   leaving   OCA (  .. -1.000 mA/um ) at %7.4r  %M", $abstime );
        $fwrite(outfile,"dfwdnhd       If_DC   leaving   OCA (  .. -1.000 mA/um ) at %7.4r  %M\n", $abstime );
        If_DC_retc=-1;
        If_DC_cnt=If_DC_cnt-1;
        $fclose(outfile);
      end
      if((If_DC >= -1000) &&  (If_DC <= 100) && (If_DC_retc!=0))
      begin
        outfile=$fopen(errFileName,"a");
        $strobe("dfwdnhd       If_DC   entering SOCA ( -1.000 mA/um .. 100.000 uA/um ) at %7.4r  %M", $abstime );
        $fwrite(outfile,"dfwdnhd       If_DC   entering SOCA ( -1.000 mA/um .. 100.000 uA/um ) at %7.4r  %M\n", $abstime );
        If_DC_retc=0;
        If_DC_cnt=If_DC_cnt-1;
        $fclose(outfile);
      end
      if((If_DC > 100) &&  (If_DC_retc!=1))
      begin
        outfile=$fopen(errFileName,"a");
        $strobe("dfwdnhd       If_DC   leaving   OCA ( 100.000 uA/um ..  ) at %7.4r  %M", $abstime );
        $fwrite(outfile,"dfwdnhd       If_DC   leaving   OCA ( 100.000 uA/um ..  ) at %7.4r  %M\n", $abstime );
        If_DC_retc=1;
        If_DC_cnt=If_DC_cnt-1;
        $fclose(outfile);
      end
   end
   else
   begin
      if(If_DC_cnt==0)
      begin
        outfile=$fopen(errFileName,"a");
        $strobe("dfwdnhd       If_DC   error limit ( %d ) reached at %7.4r  %M", maxEv, $abstime );
        $fwrite(outfile,"dfwdnhd       If_DC   error limit ( %d ) reached at %7.4r  %M\n", maxEv, $abstime );
        If_DC_cnt=If_DC_cnt-1;
        $fclose(outfile);
      end
   end

end // analog
endmodule // dfwdnhd

// Verilog-A OC Watch for device dfwdnhe Parameters  VAC If_100n If_DC
module dfwdnhe_ahdl(A1,C1,A,C);
parameter tstep_occ=100n;
parameter errFileName="./occ.err";
parameter area = 1u;
parameter m_soa = 1;
parameter maxEv = 25;
parameter maxEv_flg = 0;
inout A1,C1,A,C;
electrical A1,C1,A,C;

integer outfile;
real V_A_C;
real I_C;
real I_A;
real VAC;
integer VAC_retc;
integer VAC_cnt;
real If_100n;
integer If_100n_retc;
integer If_100n_cnt;
real If_DC;
integer If_DC_retc;
integer If_DC_cnt;

analog begin
   $bound_step( tstep_occ );
   @(initial_step) begin
      VAC_retc=0;
      VAC_cnt = maxEv;
      If_100n_retc=0;
      If_100n_cnt = maxEv;
      If_DC_retc=0;
      If_DC_cnt = maxEv;
   end
   V_A_C = V(A,C);
   I_C = I(C1,C);
   I_A = I(A1,A);

//      VAC
   VAC = V_A_C;
   if((VAC_cnt>0) || ( maxEv_flg==0 ))   begin
      if( (VAC < -100) && (VAC_retc!=-1))
      begin
        outfile=$fopen(errFileName,"a");
        $strobe("dfwdnhe       VAC     leaving   OCA (  .. -100.000 V ) at %7.4r  %M", $abstime );
        $fwrite(outfile,"dfwdnhe       VAC     leaving   OCA (  .. -100.000 V ) at %7.4r  %M\n", $abstime );
        VAC_retc=-1;
        VAC_cnt=VAC_cnt-1;
        $fclose(outfile);
      end
      if((VAC >= -100) &&  (VAC <= 1.5) && (VAC_retc!=0))
      begin
        outfile=$fopen(errFileName,"a");
        $strobe("dfwdnhe       VAC     entering SOCA ( -100.000 V .. 1.500 V ) at %7.4r  %M", $abstime );
        $fwrite(outfile,"dfwdnhe       VAC     entering SOCA ( -100.000 V .. 1.500 V ) at %7.4r  %M\n", $abstime );
        VAC_retc=0;
        VAC_cnt=VAC_cnt-1;
        $fclose(outfile);
      end
      if((VAC > 1.5) &&  (VAC_retc!=1))
      begin
        outfile=$fopen(errFileName,"a");
        $strobe("dfwdnhe       VAC     leaving   OCA ( 1.500 V ..  ) at %7.4r  %M", $abstime );
        $fwrite(outfile,"dfwdnhe       VAC     leaving   OCA ( 1.500 V ..  ) at %7.4r  %M\n", $abstime );
        VAC_retc=1;
        VAC_cnt=VAC_cnt-1;
        $fclose(outfile);
      end
   end
   else
   begin
      if(VAC_cnt==0)
      begin
        outfile=$fopen(errFileName,"a");
        $strobe("dfwdnhe       VAC     error limit ( %d ) reached at %7.4r  %M", maxEv, $abstime );
        $fwrite(outfile,"dfwdnhe       VAC     error limit ( %d ) reached at %7.4r  %M\n", maxEv, $abstime );
        VAC_cnt=VAC_cnt-1;
        $fclose(outfile);
      end
   end

//      If_100n
   If_100n = I_A /  ( m_soa * area / 6.16e-06 ) ;
   if((If_100n_cnt>0) || ( maxEv_flg==0 ))   begin
      if( (If_100n < -1000) && (If_100n_retc!=-1))
      begin
        outfile=$fopen(errFileName,"a");
        $strobe("dfwdnhe       If_100n leaving   OCA (  .. -1.000 mA/um ) at %7.4r  %M", $abstime );
        $fwrite(outfile,"dfwdnhe       If_100n leaving   OCA (  .. -1.000 mA/um ) at %7.4r  %M\n", $abstime );
        If_100n_retc=-1;
        If_100n_cnt=If_100n_cnt-1;
        $fclose(outfile);
      end
      if((If_100n >= -1000) &&  (If_100n <= 1000) && (If_100n_retc!=0))
      begin
        outfile=$fopen(errFileName,"a");
        $strobe("dfwdnhe       If_100n entering SOCA ( -1.000 mA/um .. 1.000 mA/um ) at %7.4r  %M", $abstime );
        $fwrite(outfile,"dfwdnhe       If_100n entering SOCA ( -1.000 mA/um .. 1.000 mA/um ) at %7.4r  %M\n", $abstime );
        If_100n_retc=0;
        If_100n_cnt=If_100n_cnt-1;
        $fclose(outfile);
      end
      if((If_100n > 1000) &&  (If_100n_retc!=1))
      begin
        outfile=$fopen(errFileName,"a");
        $strobe("dfwdnhe       If_100n leaving   OCA ( 1.000 mA/um ..  ) at %7.4r  %M", $abstime );
        $fwrite(outfile,"dfwdnhe       If_100n leaving   OCA ( 1.000 mA/um ..  ) at %7.4r  %M\n", $abstime );
        If_100n_retc=1;
        If_100n_cnt=If_100n_cnt-1;
        $fclose(outfile);
      end
   end
   else
   begin
      if(If_100n_cnt==0)
      begin
        outfile=$fopen(errFileName,"a");
        $strobe("dfwdnhe       If_100n error limit ( %d ) reached at %7.4r  %M", maxEv, $abstime );
        $fwrite(outfile,"dfwdnhe       If_100n error limit ( %d ) reached at %7.4r  %M\n", maxEv, $abstime );
        If_100n_cnt=If_100n_cnt-1;
        $fclose(outfile);
      end
   end

//      If_DC
   If_DC = I_A /  ( m_soa * area / 6.16e-06 ) ;
   if((If_DC_cnt>0) || ( maxEv_flg==0 ))   begin
      if( (If_DC < -1000) && (If_DC_retc!=-1))
      begin
        outfile=$fopen(errFileName,"a");
        $strobe("dfwdnhe       If_DC   leaving   OCA (  .. -1.000 mA/um ) at %7.4r  %M", $abstime );
        $fwrite(outfile,"dfwdnhe       If_DC   leaving   OCA (  .. -1.000 mA/um ) at %7.4r  %M\n", $abstime );
        If_DC_retc=-1;
        If_DC_cnt=If_DC_cnt-1;
        $fclose(outfile);
      end
      if((If_DC >= -1000) &&  (If_DC <= 100) && (If_DC_retc!=0))
      begin
        outfile=$fopen(errFileName,"a");
        $strobe("dfwdnhe       If_DC   entering SOCA ( -1.000 mA/um .. 100.000 uA/um ) at %7.4r  %M", $abstime );
        $fwrite(outfile,"dfwdnhe       If_DC   entering SOCA ( -1.000 mA/um .. 100.000 uA/um ) at %7.4r  %M\n", $abstime );
        If_DC_retc=0;
        If_DC_cnt=If_DC_cnt-1;
        $fclose(outfile);
      end
      if((If_DC > 100) &&  (If_DC_retc!=1))
      begin
        outfile=$fopen(errFileName,"a");
        $strobe("dfwdnhe       If_DC   leaving   OCA ( 100.000 uA/um ..  ) at %7.4r  %M", $abstime );
        $fwrite(outfile,"dfwdnhe       If_DC   leaving   OCA ( 100.000 uA/um ..  ) at %7.4r  %M\n", $abstime );
        If_DC_retc=1;
        If_DC_cnt=If_DC_cnt-1;
        $fclose(outfile);
      end
   end
   else
   begin
      if(If_DC_cnt==0)
      begin
        outfile=$fopen(errFileName,"a");
        $strobe("dfwdnhe       If_DC   error limit ( %d ) reached at %7.4r  %M", maxEv, $abstime );
        $fwrite(outfile,"dfwdnhe       If_DC   error limit ( %d ) reached at %7.4r  %M\n", maxEv, $abstime );
        If_DC_cnt=If_DC_cnt-1;
        $fclose(outfile);
      end
   end

end // analog
endmodule // dfwdnhe

// Verilog-A OC Watch for device dfwdphe Parameters  VAC If_100n If_DC
module dfwdphe_ahdl(A1,C1,A,C);
parameter tstep_occ=100n;
parameter errFileName="./occ.err";
parameter area = 1u;
parameter m_soa = 1;
parameter maxEv = 25;
parameter maxEv_flg = 0;
inout A1,C1,A,C;
electrical A1,C1,A,C;

integer outfile;
real V_A_C;
real I_C;
real I_A;
real VAC;
integer VAC_retc;
integer VAC_cnt;
real If_100n;
integer If_100n_retc;
integer If_100n_cnt;
real If_DC;
integer If_DC_retc;
integer If_DC_cnt;

analog begin
   $bound_step( tstep_occ );
   @(initial_step) begin
      VAC_retc=0;
      VAC_cnt = maxEv;
      If_100n_retc=0;
      If_100n_cnt = maxEv;
      If_DC_retc=0;
      If_DC_cnt = maxEv;
   end
   V_A_C = V(A,C);
   I_C = I(C1,C);
   I_A = I(A1,A);

//      VAC
   VAC = V_A_C;
   if((VAC_cnt>0) || ( maxEv_flg==0 ))   begin
      if( (VAC < -100) && (VAC_retc!=-1))
      begin
        outfile=$fopen(errFileName,"a");
        $strobe("dfwdphe       VAC     leaving   OCA (  .. -100.000 V ) at %7.4r  %M", $abstime );
        $fwrite(outfile,"dfwdphe       VAC     leaving   OCA (  .. -100.000 V ) at %7.4r  %M\n", $abstime );
        VAC_retc=-1;
        VAC_cnt=VAC_cnt-1;
        $fclose(outfile);
      end
      if((VAC >= -100) &&  (VAC <= 1.5) && (VAC_retc!=0))
      begin
        outfile=$fopen(errFileName,"a");
        $strobe("dfwdphe       VAC     entering SOCA ( -100.000 V .. 1.500 V ) at %7.4r  %M", $abstime );
        $fwrite(outfile,"dfwdphe       VAC     entering SOCA ( -100.000 V .. 1.500 V ) at %7.4r  %M\n", $abstime );
        VAC_retc=0;
        VAC_cnt=VAC_cnt-1;
        $fclose(outfile);
      end
      if((VAC > 1.5) &&  (VAC_retc!=1))
      begin
        outfile=$fopen(errFileName,"a");
        $strobe("dfwdphe       VAC     leaving   OCA ( 1.500 V ..  ) at %7.4r  %M", $abstime );
        $fwrite(outfile,"dfwdphe       VAC     leaving   OCA ( 1.500 V ..  ) at %7.4r  %M\n", $abstime );
        VAC_retc=1;
        VAC_cnt=VAC_cnt-1;
        $fclose(outfile);
      end
   end
   else
   begin
      if(VAC_cnt==0)
      begin
        outfile=$fopen(errFileName,"a");
        $strobe("dfwdphe       VAC     error limit ( %d ) reached at %7.4r  %M", maxEv, $abstime );
        $fwrite(outfile,"dfwdphe       VAC     error limit ( %d ) reached at %7.4r  %M\n", maxEv, $abstime );
        VAC_cnt=VAC_cnt-1;
        $fclose(outfile);
      end
   end

//      If_100n
   If_100n = I_A /  ( m_soa * area / 6.16e-06 ) ;
   if((If_100n_cnt>0) || ( maxEv_flg==0 ))   begin
      if( (If_100n < -1000) && (If_100n_retc!=-1))
      begin
        outfile=$fopen(errFileName,"a");
        $strobe("dfwdphe       If_100n leaving   OCA (  .. -1.000 mA/um ) at %7.4r  %M", $abstime );
        $fwrite(outfile,"dfwdphe       If_100n leaving   OCA (  .. -1.000 mA/um ) at %7.4r  %M\n", $abstime );
        If_100n_retc=-1;
        If_100n_cnt=If_100n_cnt-1;
        $fclose(outfile);
      end
      if((If_100n >= -1000) &&  (If_100n <= 1000) && (If_100n_retc!=0))
      begin
        outfile=$fopen(errFileName,"a");
        $strobe("dfwdphe       If_100n entering SOCA ( -1.000 mA/um .. 1.000 mA/um ) at %7.4r  %M", $abstime );
        $fwrite(outfile,"dfwdphe       If_100n entering SOCA ( -1.000 mA/um .. 1.000 mA/um ) at %7.4r  %M\n", $abstime );
        If_100n_retc=0;
        If_100n_cnt=If_100n_cnt-1;
        $fclose(outfile);
      end
      if((If_100n > 1000) &&  (If_100n_retc!=1))
      begin
        outfile=$fopen(errFileName,"a");
        $strobe("dfwdphe       If_100n leaving   OCA ( 1.000 mA/um ..  ) at %7.4r  %M", $abstime );
        $fwrite(outfile,"dfwdphe       If_100n leaving   OCA ( 1.000 mA/um ..  ) at %7.4r  %M\n", $abstime );
        If_100n_retc=1;
        If_100n_cnt=If_100n_cnt-1;
        $fclose(outfile);
      end
   end
   else
   begin
      if(If_100n_cnt==0)
      begin
        outfile=$fopen(errFileName,"a");
        $strobe("dfwdphe       If_100n error limit ( %d ) reached at %7.4r  %M", maxEv, $abstime );
        $fwrite(outfile,"dfwdphe       If_100n error limit ( %d ) reached at %7.4r  %M\n", maxEv, $abstime );
        If_100n_cnt=If_100n_cnt-1;
        $fclose(outfile);
      end
   end

//      If_DC
   If_DC = I_A /  ( m_soa * area / 6.16e-06 ) ;
   if((If_DC_cnt>0) || ( maxEv_flg==0 ))   begin
      if( (If_DC < -1000) && (If_DC_retc!=-1))
      begin
        outfile=$fopen(errFileName,"a");
        $strobe("dfwdphe       If_DC   leaving   OCA (  .. -1.000 mA/um ) at %7.4r  %M", $abstime );
        $fwrite(outfile,"dfwdphe       If_DC   leaving   OCA (  .. -1.000 mA/um ) at %7.4r  %M\n", $abstime );
        If_DC_retc=-1;
        If_DC_cnt=If_DC_cnt-1;
        $fclose(outfile);
      end
      if((If_DC >= -1000) &&  (If_DC <= 100) && (If_DC_retc!=0))
      begin
        outfile=$fopen(errFileName,"a");
        $strobe("dfwdphe       If_DC   entering SOCA ( -1.000 mA/um .. 100.000 uA/um ) at %7.4r  %M", $abstime );
        $fwrite(outfile,"dfwdphe       If_DC   entering SOCA ( -1.000 mA/um .. 100.000 uA/um ) at %7.4r  %M\n", $abstime );
        If_DC_retc=0;
        If_DC_cnt=If_DC_cnt-1;
        $fclose(outfile);
      end
      if((If_DC > 100) &&  (If_DC_retc!=1))
      begin
        outfile=$fopen(errFileName,"a");
        $strobe("dfwdphe       If_DC   leaving   OCA ( 100.000 uA/um ..  ) at %7.4r  %M", $abstime );
        $fwrite(outfile,"dfwdphe       If_DC   leaving   OCA ( 100.000 uA/um ..  ) at %7.4r  %M\n", $abstime );
        If_DC_retc=1;
        If_DC_cnt=If_DC_cnt-1;
        $fclose(outfile);
      end
   end
   else
   begin
      if(If_DC_cnt==0)
      begin
        outfile=$fopen(errFileName,"a");
        $strobe("dfwdphe       If_DC   error limit ( %d ) reached at %7.4r  %M", maxEv, $abstime );
        $fwrite(outfile,"dfwdphe       If_DC   error limit ( %d ) reached at %7.4r  %M\n", maxEv, $abstime );
        If_DC_cnt=If_DC_cnt-1;
        $fclose(outfile);
      end
   end

end // analog
endmodule // dfwdphe

// Verilog-A OC Watch for device dfwdnhf Parameters  VAC If_100n If_DC
module dfwdnhf_ahdl(A1,C1,A,C);
parameter tstep_occ=100n;
parameter errFileName="./occ.err";
parameter area = 1u;
parameter m_soa = 1;
parameter maxEv = 25;
parameter maxEv_flg = 0;
inout A1,C1,A,C;
electrical A1,C1,A,C;

integer outfile;
real V_A_C;
real I_C;
real I_A;
real VAC;
integer VAC_retc;
integer VAC_cnt;
real If_100n;
integer If_100n_retc;
integer If_100n_cnt;
real If_DC;
integer If_DC_retc;
integer If_DC_cnt;

analog begin
   $bound_step( tstep_occ );
   @(initial_step) begin
      VAC_retc=0;
      VAC_cnt = maxEv;
      If_100n_retc=0;
      If_100n_cnt = maxEv;
      If_DC_retc=0;
      If_DC_cnt = maxEv;
   end
   V_A_C = V(A,C);
   I_C = I(C1,C);
   I_A = I(A1,A);

//      VAC
   VAC = V_A_C;
   if((VAC_cnt>0) || ( maxEv_flg==0 ))   begin
      if( (VAC < -125) && (VAC_retc!=-1))
      begin
        outfile=$fopen(errFileName,"a");
        $strobe("dfwdnhf       VAC     leaving   OCA (  .. -125.000 V ) at %7.4r  %M", $abstime );
        $fwrite(outfile,"dfwdnhf       VAC     leaving   OCA (  .. -125.000 V ) at %7.4r  %M\n", $abstime );
        VAC_retc=-1;
        VAC_cnt=VAC_cnt-1;
        $fclose(outfile);
      end
      if((VAC >= -125) &&  (VAC <= 1.5) && (VAC_retc!=0))
      begin
        outfile=$fopen(errFileName,"a");
        $strobe("dfwdnhf       VAC     entering SOCA ( -125.000 V .. 1.500 V ) at %7.4r  %M", $abstime );
        $fwrite(outfile,"dfwdnhf       VAC     entering SOCA ( -125.000 V .. 1.500 V ) at %7.4r  %M\n", $abstime );
        VAC_retc=0;
        VAC_cnt=VAC_cnt-1;
        $fclose(outfile);
      end
      if((VAC > 1.5) &&  (VAC_retc!=1))
      begin
        outfile=$fopen(errFileName,"a");
        $strobe("dfwdnhf       VAC     leaving   OCA ( 1.500 V ..  ) at %7.4r  %M", $abstime );
        $fwrite(outfile,"dfwdnhf       VAC     leaving   OCA ( 1.500 V ..  ) at %7.4r  %M\n", $abstime );
        VAC_retc=1;
        VAC_cnt=VAC_cnt-1;
        $fclose(outfile);
      end
   end
   else
   begin
      if(VAC_cnt==0)
      begin
        outfile=$fopen(errFileName,"a");
        $strobe("dfwdnhf       VAC     error limit ( %d ) reached at %7.4r  %M", maxEv, $abstime );
        $fwrite(outfile,"dfwdnhf       VAC     error limit ( %d ) reached at %7.4r  %M\n", maxEv, $abstime );
        VAC_cnt=VAC_cnt-1;
        $fclose(outfile);
      end
   end

//      If_100n
   If_100n = I_A /  ( m_soa * area / 8.16e-06 ) ;
   if((If_100n_cnt>0) || ( maxEv_flg==0 ))   begin
      if( (If_100n < -1000) && (If_100n_retc!=-1))
      begin
        outfile=$fopen(errFileName,"a");
        $strobe("dfwdnhf       If_100n leaving   OCA (  .. -1.000 mA/um ) at %7.4r  %M", $abstime );
        $fwrite(outfile,"dfwdnhf       If_100n leaving   OCA (  .. -1.000 mA/um ) at %7.4r  %M\n", $abstime );
        If_100n_retc=-1;
        If_100n_cnt=If_100n_cnt-1;
        $fclose(outfile);
      end
      if((If_100n >= -1000) &&  (If_100n <= 1000) && (If_100n_retc!=0))
      begin
        outfile=$fopen(errFileName,"a");
        $strobe("dfwdnhf       If_100n entering SOCA ( -1.000 mA/um .. 1.000 mA/um ) at %7.4r  %M", $abstime );
        $fwrite(outfile,"dfwdnhf       If_100n entering SOCA ( -1.000 mA/um .. 1.000 mA/um ) at %7.4r  %M\n", $abstime );
        If_100n_retc=0;
        If_100n_cnt=If_100n_cnt-1;
        $fclose(outfile);
      end
      if((If_100n > 1000) &&  (If_100n_retc!=1))
      begin
        outfile=$fopen(errFileName,"a");
        $strobe("dfwdnhf       If_100n leaving   OCA ( 1.000 mA/um ..  ) at %7.4r  %M", $abstime );
        $fwrite(outfile,"dfwdnhf       If_100n leaving   OCA ( 1.000 mA/um ..  ) at %7.4r  %M\n", $abstime );
        If_100n_retc=1;
        If_100n_cnt=If_100n_cnt-1;
        $fclose(outfile);
      end
   end
   else
   begin
      if(If_100n_cnt==0)
      begin
        outfile=$fopen(errFileName,"a");
        $strobe("dfwdnhf       If_100n error limit ( %d ) reached at %7.4r  %M", maxEv, $abstime );
        $fwrite(outfile,"dfwdnhf       If_100n error limit ( %d ) reached at %7.4r  %M\n", maxEv, $abstime );
        If_100n_cnt=If_100n_cnt-1;
        $fclose(outfile);
      end
   end

//      If_DC
   If_DC = I_A /  ( m_soa * area / 8.16e-06 ) ;
   if((If_DC_cnt>0) || ( maxEv_flg==0 ))   begin
      if( (If_DC < -1000) && (If_DC_retc!=-1))
      begin
        outfile=$fopen(errFileName,"a");
        $strobe("dfwdnhf       If_DC   leaving   OCA (  .. -1.000 mA/um ) at %7.4r  %M", $abstime );
        $fwrite(outfile,"dfwdnhf       If_DC   leaving   OCA (  .. -1.000 mA/um ) at %7.4r  %M\n", $abstime );
        If_DC_retc=-1;
        If_DC_cnt=If_DC_cnt-1;
        $fclose(outfile);
      end
      if((If_DC >= -1000) &&  (If_DC <= 100) && (If_DC_retc!=0))
      begin
        outfile=$fopen(errFileName,"a");
        $strobe("dfwdnhf       If_DC   entering SOCA ( -1.000 mA/um .. 100.000 uA/um ) at %7.4r  %M", $abstime );
        $fwrite(outfile,"dfwdnhf       If_DC   entering SOCA ( -1.000 mA/um .. 100.000 uA/um ) at %7.4r  %M\n", $abstime );
        If_DC_retc=0;
        If_DC_cnt=If_DC_cnt-1;
        $fclose(outfile);
      end
      if((If_DC > 100) &&  (If_DC_retc!=1))
      begin
        outfile=$fopen(errFileName,"a");
        $strobe("dfwdnhf       If_DC   leaving   OCA ( 100.000 uA/um ..  ) at %7.4r  %M", $abstime );
        $fwrite(outfile,"dfwdnhf       If_DC   leaving   OCA ( 100.000 uA/um ..  ) at %7.4r  %M\n", $abstime );
        If_DC_retc=1;
        If_DC_cnt=If_DC_cnt-1;
        $fclose(outfile);
      end
   end
   else
   begin
      if(If_DC_cnt==0)
      begin
        outfile=$fopen(errFileName,"a");
        $strobe("dfwdnhf       If_DC   error limit ( %d ) reached at %7.4r  %M", maxEv, $abstime );
        $fwrite(outfile,"dfwdnhf       If_DC   error limit ( %d ) reached at %7.4r  %M\n", maxEv, $abstime );
        If_DC_cnt=If_DC_cnt-1;
        $fclose(outfile);
      end
   end

end // analog
endmodule // dfwdnhf

// Verilog-A OC Watch for device dfwdpha Parameters  VAC If_100n If_DC
module dfwdpha_ahdl(A1,C1,A,C);
parameter tstep_occ=100n;
parameter errFileName="./occ.err";
parameter area = 1u;
parameter m_soa = 1;
parameter maxEv = 25;
parameter maxEv_flg = 0;
inout A1,C1,A,C;
electrical A1,C1,A,C;

integer outfile;
real V_A_C;
real I_C;
real I_A;
real VAC;
integer VAC_retc;
integer VAC_cnt;
real If_100n;
integer If_100n_retc;
integer If_100n_cnt;
real If_DC;
integer If_DC_retc;
integer If_DC_cnt;

analog begin
   $bound_step( tstep_occ );
   @(initial_step) begin
      VAC_retc=0;
      VAC_cnt = maxEv;
      If_100n_retc=0;
      If_100n_cnt = maxEv;
      If_DC_retc=0;
      If_DC_cnt = maxEv;
   end
   V_A_C = V(A,C);
   I_C = I(C1,C);
   I_A = I(A1,A);

//      VAC
   VAC = V_A_C;
   if((VAC_cnt>0) || ( maxEv_flg==0 ))   begin
      if( (VAC < -40) && (VAC_retc!=-1))
      begin
        outfile=$fopen(errFileName,"a");
        $strobe("dfwdpha       VAC     leaving   OCA (  .. -40.000 V ) at %7.4r  %M", $abstime );
        $fwrite(outfile,"dfwdpha       VAC     leaving   OCA (  .. -40.000 V ) at %7.4r  %M\n", $abstime );
        VAC_retc=-1;
        VAC_cnt=VAC_cnt-1;
        $fclose(outfile);
      end
      if((VAC >= -40) &&  (VAC <= 1.5) && (VAC_retc!=0))
      begin
        outfile=$fopen(errFileName,"a");
        $strobe("dfwdpha       VAC     entering SOCA ( -40.000 V .. 1.500 V ) at %7.4r  %M", $abstime );
        $fwrite(outfile,"dfwdpha       VAC     entering SOCA ( -40.000 V .. 1.500 V ) at %7.4r  %M\n", $abstime );
        VAC_retc=0;
        VAC_cnt=VAC_cnt-1;
        $fclose(outfile);
      end
      if((VAC > 1.5) &&  (VAC_retc!=1))
      begin
        outfile=$fopen(errFileName,"a");
        $strobe("dfwdpha       VAC     leaving   OCA ( 1.500 V ..  ) at %7.4r  %M", $abstime );
        $fwrite(outfile,"dfwdpha       VAC     leaving   OCA ( 1.500 V ..  ) at %7.4r  %M\n", $abstime );
        VAC_retc=1;
        VAC_cnt=VAC_cnt-1;
        $fclose(outfile);
      end
   end
   else
   begin
      if(VAC_cnt==0)
      begin
        outfile=$fopen(errFileName,"a");
        $strobe("dfwdpha       VAC     error limit ( %d ) reached at %7.4r  %M", maxEv, $abstime );
        $fwrite(outfile,"dfwdpha       VAC     error limit ( %d ) reached at %7.4r  %M\n", maxEv, $abstime );
        VAC_cnt=VAC_cnt-1;
        $fclose(outfile);
      end
   end

//      If_100n
   If_100n = I_A /  ( m_soa * area / 2.26e-06 ) ;
   if((If_100n_cnt>0) || ( maxEv_flg==0 ))   begin
      if( (If_100n < -1000) && (If_100n_retc!=-1))
      begin
        outfile=$fopen(errFileName,"a");
        $strobe("dfwdpha       If_100n leaving   OCA (  .. -1.000 mA/um ) at %7.4r  %M", $abstime );
        $fwrite(outfile,"dfwdpha       If_100n leaving   OCA (  .. -1.000 mA/um ) at %7.4r  %M\n", $abstime );
        If_100n_retc=-1;
        If_100n_cnt=If_100n_cnt-1;
        $fclose(outfile);
      end
      if((If_100n >= -1000) &&  (If_100n <= 1000) && (If_100n_retc!=0))
      begin
        outfile=$fopen(errFileName,"a");
        $strobe("dfwdpha       If_100n entering SOCA ( -1.000 mA/um .. 1.000 mA/um ) at %7.4r  %M", $abstime );
        $fwrite(outfile,"dfwdpha       If_100n entering SOCA ( -1.000 mA/um .. 1.000 mA/um ) at %7.4r  %M\n", $abstime );
        If_100n_retc=0;
        If_100n_cnt=If_100n_cnt-1;
        $fclose(outfile);
      end
      if((If_100n > 1000) &&  (If_100n_retc!=1))
      begin
        outfile=$fopen(errFileName,"a");
        $strobe("dfwdpha       If_100n leaving   OCA ( 1.000 mA/um ..  ) at %7.4r  %M", $abstime );
        $fwrite(outfile,"dfwdpha       If_100n leaving   OCA ( 1.000 mA/um ..  ) at %7.4r  %M\n", $abstime );
        If_100n_retc=1;
        If_100n_cnt=If_100n_cnt-1;
        $fclose(outfile);
      end
   end
   else
   begin
      if(If_100n_cnt==0)
      begin
        outfile=$fopen(errFileName,"a");
        $strobe("dfwdpha       If_100n error limit ( %d ) reached at %7.4r  %M", maxEv, $abstime );
        $fwrite(outfile,"dfwdpha       If_100n error limit ( %d ) reached at %7.4r  %M\n", maxEv, $abstime );
        If_100n_cnt=If_100n_cnt-1;
        $fclose(outfile);
      end
   end

//      If_DC
   If_DC = I_A /  ( m_soa * area / 2.26e-06 ) ;
   if((If_DC_cnt>0) || ( maxEv_flg==0 ))   begin
      if( (If_DC < -1000) && (If_DC_retc!=-1))
      begin
        outfile=$fopen(errFileName,"a");
        $strobe("dfwdpha       If_DC   leaving   OCA (  .. -1.000 mA/um ) at %7.4r  %M", $abstime );
        $fwrite(outfile,"dfwdpha       If_DC   leaving   OCA (  .. -1.000 mA/um ) at %7.4r  %M\n", $abstime );
        If_DC_retc=-1;
        If_DC_cnt=If_DC_cnt-1;
        $fclose(outfile);
      end
      if((If_DC >= -1000) &&  (If_DC <= 100) && (If_DC_retc!=0))
      begin
        outfile=$fopen(errFileName,"a");
        $strobe("dfwdpha       If_DC   entering SOCA ( -1.000 mA/um .. 100.000 uA/um ) at %7.4r  %M", $abstime );
        $fwrite(outfile,"dfwdpha       If_DC   entering SOCA ( -1.000 mA/um .. 100.000 uA/um ) at %7.4r  %M\n", $abstime );
        If_DC_retc=0;
        If_DC_cnt=If_DC_cnt-1;
        $fclose(outfile);
      end
      if((If_DC > 100) &&  (If_DC_retc!=1))
      begin
        outfile=$fopen(errFileName,"a");
        $strobe("dfwdpha       If_DC   leaving   OCA ( 100.000 uA/um ..  ) at %7.4r  %M", $abstime );
        $fwrite(outfile,"dfwdpha       If_DC   leaving   OCA ( 100.000 uA/um ..  ) at %7.4r  %M\n", $abstime );
        If_DC_retc=1;
        If_DC_cnt=If_DC_cnt-1;
        $fclose(outfile);
      end
   end
   else
   begin
      if(If_DC_cnt==0)
      begin
        outfile=$fopen(errFileName,"a");
        $strobe("dfwdpha       If_DC   error limit ( %d ) reached at %7.4r  %M", maxEv, $abstime );
        $fwrite(outfile,"dfwdpha       If_DC   error limit ( %d ) reached at %7.4r  %M\n", maxEv, $abstime );
        If_DC_cnt=If_DC_cnt-1;
        $fclose(outfile);
      end
   end

end // analog
endmodule // dfwdpha

// Verilog-A OC Watch for device dfwdphc Parameters  VAC If_100n If_DC
module dfwdphc_ahdl(A1,C1,A,C);
parameter tstep_occ=100n;
parameter errFileName="./occ.err";
parameter area = 1u;
parameter m_soa = 1;
parameter maxEv = 25;
parameter maxEv_flg = 0;
inout A1,C1,A,C;
electrical A1,C1,A,C;

integer outfile;
real V_A_C;
real I_C;
real I_A;
real VAC;
integer VAC_retc;
integer VAC_cnt;
real If_100n;
integer If_100n_retc;
integer If_100n_cnt;
real If_DC;
integer If_DC_retc;
integer If_DC_cnt;

analog begin
   $bound_step( tstep_occ );
   @(initial_step) begin
      VAC_retc=0;
      VAC_cnt = maxEv;
      If_100n_retc=0;
      If_100n_cnt = maxEv;
      If_DC_retc=0;
      If_DC_cnt = maxEv;
   end
   V_A_C = V(A,C);
   I_C = I(C1,C);
   I_A = I(A1,A);

//      VAC
   VAC = V_A_C;
   if((VAC_cnt>0) || ( maxEv_flg==0 ))   begin
      if( (VAC < -70) && (VAC_retc!=-1))
      begin
        outfile=$fopen(errFileName,"a");
        $strobe("dfwdphc       VAC     leaving   OCA (  .. -70.000 V ) at %7.4r  %M", $abstime );
        $fwrite(outfile,"dfwdphc       VAC     leaving   OCA (  .. -70.000 V ) at %7.4r  %M\n", $abstime );
        VAC_retc=-1;
        VAC_cnt=VAC_cnt-1;
        $fclose(outfile);
      end
      if((VAC >= -70) &&  (VAC <= 1.5) && (VAC_retc!=0))
      begin
        outfile=$fopen(errFileName,"a");
        $strobe("dfwdphc       VAC     entering SOCA ( -70.000 V .. 1.500 V ) at %7.4r  %M", $abstime );
        $fwrite(outfile,"dfwdphc       VAC     entering SOCA ( -70.000 V .. 1.500 V ) at %7.4r  %M\n", $abstime );
        VAC_retc=0;
        VAC_cnt=VAC_cnt-1;
        $fclose(outfile);
      end
      if((VAC > 1.5) &&  (VAC_retc!=1))
      begin
        outfile=$fopen(errFileName,"a");
        $strobe("dfwdphc       VAC     leaving   OCA ( 1.500 V ..  ) at %7.4r  %M", $abstime );
        $fwrite(outfile,"dfwdphc       VAC     leaving   OCA ( 1.500 V ..  ) at %7.4r  %M\n", $abstime );
        VAC_retc=1;
        VAC_cnt=VAC_cnt-1;
        $fclose(outfile);
      end
   end
   else
   begin
      if(VAC_cnt==0)
      begin
        outfile=$fopen(errFileName,"a");
        $strobe("dfwdphc       VAC     error limit ( %d ) reached at %7.4r  %M", maxEv, $abstime );
        $fwrite(outfile,"dfwdphc       VAC     error limit ( %d ) reached at %7.4r  %M\n", maxEv, $abstime );
        VAC_cnt=VAC_cnt-1;
        $fclose(outfile);
      end
   end

//      If_100n
   If_100n = I_A /  ( m_soa * area / 4.26e-06 ) ;
   if((If_100n_cnt>0) || ( maxEv_flg==0 ))   begin
      if( (If_100n < -1000) && (If_100n_retc!=-1))
      begin
        outfile=$fopen(errFileName,"a");
        $strobe("dfwdphc       If_100n leaving   OCA (  .. -1.000 mA/um ) at %7.4r  %M", $abstime );
        $fwrite(outfile,"dfwdphc       If_100n leaving   OCA (  .. -1.000 mA/um ) at %7.4r  %M\n", $abstime );
        If_100n_retc=-1;
        If_100n_cnt=If_100n_cnt-1;
        $fclose(outfile);
      end
      if((If_100n >= -1000) &&  (If_100n <= 1000) && (If_100n_retc!=0))
      begin
        outfile=$fopen(errFileName,"a");
        $strobe("dfwdphc       If_100n entering SOCA ( -1.000 mA/um .. 1.000 mA/um ) at %7.4r  %M", $abstime );
        $fwrite(outfile,"dfwdphc       If_100n entering SOCA ( -1.000 mA/um .. 1.000 mA/um ) at %7.4r  %M\n", $abstime );
        If_100n_retc=0;
        If_100n_cnt=If_100n_cnt-1;
        $fclose(outfile);
      end
      if((If_100n > 1000) &&  (If_100n_retc!=1))
      begin
        outfile=$fopen(errFileName,"a");
        $strobe("dfwdphc       If_100n leaving   OCA ( 1.000 mA/um ..  ) at %7.4r  %M", $abstime );
        $fwrite(outfile,"dfwdphc       If_100n leaving   OCA ( 1.000 mA/um ..  ) at %7.4r  %M\n", $abstime );
        If_100n_retc=1;
        If_100n_cnt=If_100n_cnt-1;
        $fclose(outfile);
      end
   end
   else
   begin
      if(If_100n_cnt==0)
      begin
        outfile=$fopen(errFileName,"a");
        $strobe("dfwdphc       If_100n error limit ( %d ) reached at %7.4r  %M", maxEv, $abstime );
        $fwrite(outfile,"dfwdphc       If_100n error limit ( %d ) reached at %7.4r  %M\n", maxEv, $abstime );
        If_100n_cnt=If_100n_cnt-1;
        $fclose(outfile);
      end
   end

//      If_DC
   If_DC = I_A /  ( m_soa * area / 4.26e-06 ) ;
   if((If_DC_cnt>0) || ( maxEv_flg==0 ))   begin
      if( (If_DC < -1000) && (If_DC_retc!=-1))
      begin
        outfile=$fopen(errFileName,"a");
        $strobe("dfwdphc       If_DC   leaving   OCA (  .. -1.000 mA/um ) at %7.4r  %M", $abstime );
        $fwrite(outfile,"dfwdphc       If_DC   leaving   OCA (  .. -1.000 mA/um ) at %7.4r  %M\n", $abstime );
        If_DC_retc=-1;
        If_DC_cnt=If_DC_cnt-1;
        $fclose(outfile);
      end
      if((If_DC >= -1000) &&  (If_DC <= 100) && (If_DC_retc!=0))
      begin
        outfile=$fopen(errFileName,"a");
        $strobe("dfwdphc       If_DC   entering SOCA ( -1.000 mA/um .. 100.000 uA/um ) at %7.4r  %M", $abstime );
        $fwrite(outfile,"dfwdphc       If_DC   entering SOCA ( -1.000 mA/um .. 100.000 uA/um ) at %7.4r  %M\n", $abstime );
        If_DC_retc=0;
        If_DC_cnt=If_DC_cnt-1;
        $fclose(outfile);
      end
      if((If_DC > 100) &&  (If_DC_retc!=1))
      begin
        outfile=$fopen(errFileName,"a");
        $strobe("dfwdphc       If_DC   leaving   OCA ( 100.000 uA/um ..  ) at %7.4r  %M", $abstime );
        $fwrite(outfile,"dfwdphc       If_DC   leaving   OCA ( 100.000 uA/um ..  ) at %7.4r  %M\n", $abstime );
        If_DC_retc=1;
        If_DC_cnt=If_DC_cnt-1;
        $fclose(outfile);
      end
   end
   else
   begin
      if(If_DC_cnt==0)
      begin
        outfile=$fopen(errFileName,"a");
        $strobe("dfwdphc       If_DC   error limit ( %d ) reached at %7.4r  %M", maxEv, $abstime );
        $fwrite(outfile,"dfwdphc       If_DC   error limit ( %d ) reached at %7.4r  %M\n", maxEv, $abstime );
        If_DC_cnt=If_DC_cnt-1;
        $fclose(outfile);
      end
   end

end // analog
endmodule // dfwdphc

// Verilog-A OC Watch for device dfwdphd Parameters  VAC If_100n If_DC
module dfwdphd_ahdl(A1,C1,A,C);
parameter tstep_occ=100n;
parameter errFileName="./occ.err";
parameter area = 1u;
parameter m_soa = 1;
parameter maxEv = 25;
parameter maxEv_flg = 0;
inout A1,C1,A,C;
electrical A1,C1,A,C;

integer outfile;
real V_A_C;
real I_C;
real I_A;
real VAC;
integer VAC_retc;
integer VAC_cnt;
real If_100n;
integer If_100n_retc;
integer If_100n_cnt;
real If_DC;
integer If_DC_retc;
integer If_DC_cnt;

analog begin
   $bound_step( tstep_occ );
   @(initial_step) begin
      VAC_retc=0;
      VAC_cnt = maxEv;
      If_100n_retc=0;
      If_100n_cnt = maxEv;
      If_DC_retc=0;
      If_DC_cnt = maxEv;
   end
   V_A_C = V(A,C);
   I_C = I(C1,C);
   I_A = I(A1,A);

//      VAC
   VAC = V_A_C;
   if((VAC_cnt>0) || ( maxEv_flg==0 ))   begin
      if( (VAC < -85) && (VAC_retc!=-1))
      begin
        outfile=$fopen(errFileName,"a");
        $strobe("dfwdphd       VAC     leaving   OCA (  .. -85.000 V ) at %7.4r  %M", $abstime );
        $fwrite(outfile,"dfwdphd       VAC     leaving   OCA (  .. -85.000 V ) at %7.4r  %M\n", $abstime );
        VAC_retc=-1;
        VAC_cnt=VAC_cnt-1;
        $fclose(outfile);
      end
      if((VAC >= -85) &&  (VAC <= 1.5) && (VAC_retc!=0))
      begin
        outfile=$fopen(errFileName,"a");
        $strobe("dfwdphd       VAC     entering SOCA ( -85.000 V .. 1.500 V ) at %7.4r  %M", $abstime );
        $fwrite(outfile,"dfwdphd       VAC     entering SOCA ( -85.000 V .. 1.500 V ) at %7.4r  %M\n", $abstime );
        VAC_retc=0;
        VAC_cnt=VAC_cnt-1;
        $fclose(outfile);
      end
      if((VAC > 1.5) &&  (VAC_retc!=1))
      begin
        outfile=$fopen(errFileName,"a");
        $strobe("dfwdphd       VAC     leaving   OCA ( 1.500 V ..  ) at %7.4r  %M", $abstime );
        $fwrite(outfile,"dfwdphd       VAC     leaving   OCA ( 1.500 V ..  ) at %7.4r  %M\n", $abstime );
        VAC_retc=1;
        VAC_cnt=VAC_cnt-1;
        $fclose(outfile);
      end
   end
   else
   begin
      if(VAC_cnt==0)
      begin
        outfile=$fopen(errFileName,"a");
        $strobe("dfwdphd       VAC     error limit ( %d ) reached at %7.4r  %M", maxEv, $abstime );
        $fwrite(outfile,"dfwdphd       VAC     error limit ( %d ) reached at %7.4r  %M\n", maxEv, $abstime );
        VAC_cnt=VAC_cnt-1;
        $fclose(outfile);
      end
   end

//      If_100n
   If_100n = I_A /  ( m_soa * area / 5.06e-06 ) ;
   if((If_100n_cnt>0) || ( maxEv_flg==0 ))   begin
      if( (If_100n < -1000) && (If_100n_retc!=-1))
      begin
        outfile=$fopen(errFileName,"a");
        $strobe("dfwdphd       If_100n leaving   OCA (  .. -1.000 mA/um ) at %7.4r  %M", $abstime );
        $fwrite(outfile,"dfwdphd       If_100n leaving   OCA (  .. -1.000 mA/um ) at %7.4r  %M\n", $abstime );
        If_100n_retc=-1;
        If_100n_cnt=If_100n_cnt-1;
        $fclose(outfile);
      end
      if((If_100n >= -1000) &&  (If_100n <= 1000) && (If_100n_retc!=0))
      begin
        outfile=$fopen(errFileName,"a");
        $strobe("dfwdphd       If_100n entering SOCA ( -1.000 mA/um .. 1.000 mA/um ) at %7.4r  %M", $abstime );
        $fwrite(outfile,"dfwdphd       If_100n entering SOCA ( -1.000 mA/um .. 1.000 mA/um ) at %7.4r  %M\n", $abstime );
        If_100n_retc=0;
        If_100n_cnt=If_100n_cnt-1;
        $fclose(outfile);
      end
      if((If_100n > 1000) &&  (If_100n_retc!=1))
      begin
        outfile=$fopen(errFileName,"a");
        $strobe("dfwdphd       If_100n leaving   OCA ( 1.000 mA/um ..  ) at %7.4r  %M", $abstime );
        $fwrite(outfile,"dfwdphd       If_100n leaving   OCA ( 1.000 mA/um ..  ) at %7.4r  %M\n", $abstime );
        If_100n_retc=1;
        If_100n_cnt=If_100n_cnt-1;
        $fclose(outfile);
      end
   end
   else
   begin
      if(If_100n_cnt==0)
      begin
        outfile=$fopen(errFileName,"a");
        $strobe("dfwdphd       If_100n error limit ( %d ) reached at %7.4r  %M", maxEv, $abstime );
        $fwrite(outfile,"dfwdphd       If_100n error limit ( %d ) reached at %7.4r  %M\n", maxEv, $abstime );
        If_100n_cnt=If_100n_cnt-1;
        $fclose(outfile);
      end
   end

//      If_DC
   If_DC = I_A /  ( m_soa * area / 5.06e-06 ) ;
   if((If_DC_cnt>0) || ( maxEv_flg==0 ))   begin
      if( (If_DC < -1000) && (If_DC_retc!=-1))
      begin
        outfile=$fopen(errFileName,"a");
        $strobe("dfwdphd       If_DC   leaving   OCA (  .. -1.000 mA/um ) at %7.4r  %M", $abstime );
        $fwrite(outfile,"dfwdphd       If_DC   leaving   OCA (  .. -1.000 mA/um ) at %7.4r  %M\n", $abstime );
        If_DC_retc=-1;
        If_DC_cnt=If_DC_cnt-1;
        $fclose(outfile);
      end
      if((If_DC >= -1000) &&  (If_DC <= 100) && (If_DC_retc!=0))
      begin
        outfile=$fopen(errFileName,"a");
        $strobe("dfwdphd       If_DC   entering SOCA ( -1.000 mA/um .. 100.000 uA/um ) at %7.4r  %M", $abstime );
        $fwrite(outfile,"dfwdphd       If_DC   entering SOCA ( -1.000 mA/um .. 100.000 uA/um ) at %7.4r  %M\n", $abstime );
        If_DC_retc=0;
        If_DC_cnt=If_DC_cnt-1;
        $fclose(outfile);
      end
      if((If_DC > 100) &&  (If_DC_retc!=1))
      begin
        outfile=$fopen(errFileName,"a");
        $strobe("dfwdphd       If_DC   leaving   OCA ( 100.000 uA/um ..  ) at %7.4r  %M", $abstime );
        $fwrite(outfile,"dfwdphd       If_DC   leaving   OCA ( 100.000 uA/um ..  ) at %7.4r  %M\n", $abstime );
        If_DC_retc=1;
        If_DC_cnt=If_DC_cnt-1;
        $fclose(outfile);
      end
   end
   else
   begin
      if(If_DC_cnt==0)
      begin
        outfile=$fopen(errFileName,"a");
        $strobe("dfwdphd       If_DC   error limit ( %d ) reached at %7.4r  %M", maxEv, $abstime );
        $fwrite(outfile,"dfwdphd       If_DC   error limit ( %d ) reached at %7.4r  %M\n", maxEv, $abstime );
        If_DC_cnt=If_DC_cnt-1;
        $fclose(outfile);
      end
   end

end // analog
endmodule // dfwdphd

// Verilog-A OC Watch for device dfwdphf Parameters  VAC If_100n If_DC
module dfwdphf_ahdl(A1,C1,A,C);
parameter tstep_occ=100n;
parameter errFileName="./occ.err";
parameter area = 1u;
parameter m_soa = 1;
parameter maxEv = 25;
parameter maxEv_flg = 0;
inout A1,C1,A,C;
electrical A1,C1,A,C;

integer outfile;
real V_A_C;
real I_C;
real I_A;
real VAC;
integer VAC_retc;
integer VAC_cnt;
real If_100n;
integer If_100n_retc;
integer If_100n_cnt;
real If_DC;
integer If_DC_retc;
integer If_DC_cnt;

analog begin
   $bound_step( tstep_occ );
   @(initial_step) begin
      VAC_retc=0;
      VAC_cnt = maxEv;
      If_100n_retc=0;
      If_100n_cnt = maxEv;
      If_DC_retc=0;
      If_DC_cnt = maxEv;
   end
   V_A_C = V(A,C);
   I_C = I(C1,C);
   I_A = I(A1,A);

//      VAC
   VAC = V_A_C;
   if((VAC_cnt>0) || ( maxEv_flg==0 ))   begin
      if( (VAC < -125) && (VAC_retc!=-1))
      begin
        outfile=$fopen(errFileName,"a");
        $strobe("dfwdphf       VAC     leaving   OCA (  .. -125.000 V ) at %7.4r  %M", $abstime );
        $fwrite(outfile,"dfwdphf       VAC     leaving   OCA (  .. -125.000 V ) at %7.4r  %M\n", $abstime );
        VAC_retc=-1;
        VAC_cnt=VAC_cnt-1;
        $fclose(outfile);
      end
      if((VAC >= -125) &&  (VAC <= 1.5) && (VAC_retc!=0))
      begin
        outfile=$fopen(errFileName,"a");
        $strobe("dfwdphf       VAC     entering SOCA ( -125.000 V .. 1.500 V ) at %7.4r  %M", $abstime );
        $fwrite(outfile,"dfwdphf       VAC     entering SOCA ( -125.000 V .. 1.500 V ) at %7.4r  %M\n", $abstime );
        VAC_retc=0;
        VAC_cnt=VAC_cnt-1;
        $fclose(outfile);
      end
      if((VAC > 1.5) &&  (VAC_retc!=1))
      begin
        outfile=$fopen(errFileName,"a");
        $strobe("dfwdphf       VAC     leaving   OCA ( 1.500 V ..  ) at %7.4r  %M", $abstime );
        $fwrite(outfile,"dfwdphf       VAC     leaving   OCA ( 1.500 V ..  ) at %7.4r  %M\n", $abstime );
        VAC_retc=1;
        VAC_cnt=VAC_cnt-1;
        $fclose(outfile);
      end
   end
   else
   begin
      if(VAC_cnt==0)
      begin
        outfile=$fopen(errFileName,"a");
        $strobe("dfwdphf       VAC     error limit ( %d ) reached at %7.4r  %M", maxEv, $abstime );
        $fwrite(outfile,"dfwdphf       VAC     error limit ( %d ) reached at %7.4r  %M\n", maxEv, $abstime );
        VAC_cnt=VAC_cnt-1;
        $fclose(outfile);
      end
   end

//      If_100n
   If_100n = I_A /  ( m_soa * area / 9.16e-06 ) ;
   if((If_100n_cnt>0) || ( maxEv_flg==0 ))   begin
      if( (If_100n < -1000) && (If_100n_retc!=-1))
      begin
        outfile=$fopen(errFileName,"a");
        $strobe("dfwdphf       If_100n leaving   OCA (  .. -1.000 mA/um ) at %7.4r  %M", $abstime );
        $fwrite(outfile,"dfwdphf       If_100n leaving   OCA (  .. -1.000 mA/um ) at %7.4r  %M\n", $abstime );
        If_100n_retc=-1;
        If_100n_cnt=If_100n_cnt-1;
        $fclose(outfile);
      end
      if((If_100n >= -1000) &&  (If_100n <= 1000) && (If_100n_retc!=0))
      begin
        outfile=$fopen(errFileName,"a");
        $strobe("dfwdphf       If_100n entering SOCA ( -1.000 mA/um .. 1.000 mA/um ) at %7.4r  %M", $abstime );
        $fwrite(outfile,"dfwdphf       If_100n entering SOCA ( -1.000 mA/um .. 1.000 mA/um ) at %7.4r  %M\n", $abstime );
        If_100n_retc=0;
        If_100n_cnt=If_100n_cnt-1;
        $fclose(outfile);
      end
      if((If_100n > 1000) &&  (If_100n_retc!=1))
      begin
        outfile=$fopen(errFileName,"a");
        $strobe("dfwdphf       If_100n leaving   OCA ( 1.000 mA/um ..  ) at %7.4r  %M", $abstime );
        $fwrite(outfile,"dfwdphf       If_100n leaving   OCA ( 1.000 mA/um ..  ) at %7.4r  %M\n", $abstime );
        If_100n_retc=1;
        If_100n_cnt=If_100n_cnt-1;
        $fclose(outfile);
      end
   end
   else
   begin
      if(If_100n_cnt==0)
      begin
        outfile=$fopen(errFileName,"a");
        $strobe("dfwdphf       If_100n error limit ( %d ) reached at %7.4r  %M", maxEv, $abstime );
        $fwrite(outfile,"dfwdphf       If_100n error limit ( %d ) reached at %7.4r  %M\n", maxEv, $abstime );
        If_100n_cnt=If_100n_cnt-1;
        $fclose(outfile);
      end
   end

//      If_DC
   If_DC = I_A /  ( m_soa * area / 9.16e-06 ) ;
   if((If_DC_cnt>0) || ( maxEv_flg==0 ))   begin
      if( (If_DC < -1000) && (If_DC_retc!=-1))
      begin
        outfile=$fopen(errFileName,"a");
        $strobe("dfwdphf       If_DC   leaving   OCA (  .. -1.000 mA/um ) at %7.4r  %M", $abstime );
        $fwrite(outfile,"dfwdphf       If_DC   leaving   OCA (  .. -1.000 mA/um ) at %7.4r  %M\n", $abstime );
        If_DC_retc=-1;
        If_DC_cnt=If_DC_cnt-1;
        $fclose(outfile);
      end
      if((If_DC >= -1000) &&  (If_DC <= 100) && (If_DC_retc!=0))
      begin
        outfile=$fopen(errFileName,"a");
        $strobe("dfwdphf       If_DC   entering SOCA ( -1.000 mA/um .. 100.000 uA/um ) at %7.4r  %M", $abstime );
        $fwrite(outfile,"dfwdphf       If_DC   entering SOCA ( -1.000 mA/um .. 100.000 uA/um ) at %7.4r  %M\n", $abstime );
        If_DC_retc=0;
        If_DC_cnt=If_DC_cnt-1;
        $fclose(outfile);
      end
      if((If_DC > 100) &&  (If_DC_retc!=1))
      begin
        outfile=$fopen(errFileName,"a");
        $strobe("dfwdphf       If_DC   leaving   OCA ( 100.000 uA/um ..  ) at %7.4r  %M", $abstime );
        $fwrite(outfile,"dfwdphf       If_DC   leaving   OCA ( 100.000 uA/um ..  ) at %7.4r  %M\n", $abstime );
        If_DC_retc=1;
        If_DC_cnt=If_DC_cnt-1;
        $fclose(outfile);
      end
   end
   else
   begin
      if(If_DC_cnt==0)
      begin
        outfile=$fopen(errFileName,"a");
        $strobe("dfwdphf       If_DC   error limit ( %d ) reached at %7.4r  %M", maxEv, $abstime );
        $fwrite(outfile,"dfwdphf       If_DC   error limit ( %d ) reached at %7.4r  %M\n", maxEv, $abstime );
        If_DC_cnt=If_DC_cnt-1;
        $fclose(outfile);
      end
   end

end // analog
endmodule // dfwdphf

// Verilog-A OC Watch for device dfwnsj1_7 Parameters  VAC
module dfwnsj1_7_ahdl(A,C);
parameter tstep_occ=100n;
parameter errFileName="./occ.err";
parameter maxEv = 25;
parameter maxEv_flg = 0;
inout A,C;
electrical A,C;

integer outfile;
real V_A_C;
real VAC;
integer VAC_retc;
integer VAC_cnt;

analog begin
   $bound_step( tstep_occ );
   @(initial_step) begin
      VAC_retc=0;
      VAC_cnt = maxEv;
   end
   V_A_C = V(A,C);

//      VAC
   VAC = V_A_C;
   if((VAC_cnt>0) || ( maxEv_flg==0 ))   begin
      if( (VAC < -100) && (VAC_retc!=-1))
      begin
        outfile=$fopen(errFileName,"a");
        $strobe("dfwnsj1_7     VAC     leaving   OCA (  .. -100.000 V ) at %7.4r  %M", $abstime );
        $fwrite(outfile,"dfwnsj1_7     VAC     leaving   OCA (  .. -100.000 V ) at %7.4r  %M\n", $abstime );
        VAC_retc=-1;
        VAC_cnt=VAC_cnt-1;
        $fclose(outfile);
      end
      if((VAC >= -100) &&  (VAC <= 1.5) && (VAC_retc!=0))
      begin
        outfile=$fopen(errFileName,"a");
        $strobe("dfwnsj1_7     VAC     entering SOCA ( -100.000 V .. 1.500 V ) at %7.4r  %M", $abstime );
        $fwrite(outfile,"dfwnsj1_7     VAC     entering SOCA ( -100.000 V .. 1.500 V ) at %7.4r  %M\n", $abstime );
        VAC_retc=0;
        VAC_cnt=VAC_cnt-1;
        $fclose(outfile);
      end
      if((VAC > 1.5) &&  (VAC_retc!=1))
      begin
        outfile=$fopen(errFileName,"a");
        $strobe("dfwnsj1_7     VAC     leaving   OCA ( 1.500 V ..  ) at %7.4r  %M", $abstime );
        $fwrite(outfile,"dfwnsj1_7     VAC     leaving   OCA ( 1.500 V ..  ) at %7.4r  %M\n", $abstime );
        VAC_retc=1;
        VAC_cnt=VAC_cnt-1;
        $fclose(outfile);
      end
   end
   else
   begin
      if(VAC_cnt==0)
      begin
        outfile=$fopen(errFileName,"a");
        $strobe("dfwnsj1_7     VAC     error limit ( %d ) reached at %7.4r  %M", maxEv, $abstime );
        $fwrite(outfile,"dfwnsj1_7     VAC     error limit ( %d ) reached at %7.4r  %M\n", maxEv, $abstime );
        VAC_cnt=VAC_cnt-1;
        $fclose(outfile);
      end
   end

end // analog
endmodule // dfwnsj1_7

// Verilog-A OC Watch for device dfwpsj1_7 Parameters  VAC
module dfwpsj1_7_ahdl(A,C);
parameter tstep_occ=100n;
parameter errFileName="./occ.err";
parameter maxEv = 25;
parameter maxEv_flg = 0;
inout A,C;
electrical A,C;

integer outfile;
real V_A_C;
real VAC;
integer VAC_retc;
integer VAC_cnt;

analog begin
   $bound_step( tstep_occ );
   @(initial_step) begin
      VAC_retc=0;
      VAC_cnt = maxEv;
   end
   V_A_C = V(A,C);

//      VAC
   VAC = V_A_C;
   if((VAC_cnt>0) || ( maxEv_flg==0 ))   begin
      if( (VAC < -100) && (VAC_retc!=-1))
      begin
        outfile=$fopen(errFileName,"a");
        $strobe("dfwpsj1_7     VAC     leaving   OCA (  .. -100.000 V ) at %7.4r  %M", $abstime );
        $fwrite(outfile,"dfwpsj1_7     VAC     leaving   OCA (  .. -100.000 V ) at %7.4r  %M\n", $abstime );
        VAC_retc=-1;
        VAC_cnt=VAC_cnt-1;
        $fclose(outfile);
      end
      if((VAC >= -100) &&  (VAC <= 1.5) && (VAC_retc!=0))
      begin
        outfile=$fopen(errFileName,"a");
        $strobe("dfwpsj1_7     VAC     entering SOCA ( -100.000 V .. 1.500 V ) at %7.4r  %M", $abstime );
        $fwrite(outfile,"dfwpsj1_7     VAC     entering SOCA ( -100.000 V .. 1.500 V ) at %7.4r  %M\n", $abstime );
        VAC_retc=0;
        VAC_cnt=VAC_cnt-1;
        $fclose(outfile);
      end
      if((VAC > 1.5) &&  (VAC_retc!=1))
      begin
        outfile=$fopen(errFileName,"a");
        $strobe("dfwpsj1_7     VAC     leaving   OCA ( 1.500 V ..  ) at %7.4r  %M", $abstime );
        $fwrite(outfile,"dfwpsj1_7     VAC     leaving   OCA ( 1.500 V ..  ) at %7.4r  %M\n", $abstime );
        VAC_retc=1;
        VAC_cnt=VAC_cnt-1;
        $fclose(outfile);
      end
   end
   else
   begin
      if(VAC_cnt==0)
      begin
        outfile=$fopen(errFileName,"a");
        $strobe("dfwpsj1_7     VAC     error limit ( %d ) reached at %7.4r  %M", maxEv, $abstime );
        $fwrite(outfile,"dfwpsj1_7     VAC     error limit ( %d ) reached at %7.4r  %M\n", maxEv, $abstime );
        VAC_cnt=VAC_cnt-1;
        $fclose(outfile);
      end
   end

end // analog
endmodule // dfwpsj1_7

// Verilog-A OC Watch for device dfwnsj1_10 Parameters  VAC
module dfwnsj1_10_ahdl(A,C);
parameter tstep_occ=100n;
parameter errFileName="./occ.err";
parameter maxEv = 25;
parameter maxEv_flg = 0;
inout A,C;
electrical A,C;

integer outfile;
real V_A_C;
real VAC;
integer VAC_retc;
integer VAC_cnt;

analog begin
   $bound_step( tstep_occ );
   @(initial_step) begin
      VAC_retc=0;
      VAC_cnt = maxEv;
   end
   V_A_C = V(A,C);

//      VAC
   VAC = V_A_C;
   if((VAC_cnt>0) || ( maxEv_flg==0 ))   begin
      if( (VAC < -140) && (VAC_retc!=-1))
      begin
        outfile=$fopen(errFileName,"a");
        $strobe("dfwnsj1_10    VAC     leaving   OCA (  .. -140.000 V ) at %7.4r  %M", $abstime );
        $fwrite(outfile,"dfwnsj1_10    VAC     leaving   OCA (  .. -140.000 V ) at %7.4r  %M\n", $abstime );
        VAC_retc=-1;
        VAC_cnt=VAC_cnt-1;
        $fclose(outfile);
      end
      if((VAC >= -140) &&  (VAC <= 1.5) && (VAC_retc!=0))
      begin
        outfile=$fopen(errFileName,"a");
        $strobe("dfwnsj1_10    VAC     entering SOCA ( -140.000 V .. 1.500 V ) at %7.4r  %M", $abstime );
        $fwrite(outfile,"dfwnsj1_10    VAC     entering SOCA ( -140.000 V .. 1.500 V ) at %7.4r  %M\n", $abstime );
        VAC_retc=0;
        VAC_cnt=VAC_cnt-1;
        $fclose(outfile);
      end
      if((VAC > 1.5) &&  (VAC_retc!=1))
      begin
        outfile=$fopen(errFileName,"a");
        $strobe("dfwnsj1_10    VAC     leaving   OCA ( 1.500 V ..  ) at %7.4r  %M", $abstime );
        $fwrite(outfile,"dfwnsj1_10    VAC     leaving   OCA ( 1.500 V ..  ) at %7.4r  %M\n", $abstime );
        VAC_retc=1;
        VAC_cnt=VAC_cnt-1;
        $fclose(outfile);
      end
   end
   else
   begin
      if(VAC_cnt==0)
      begin
        outfile=$fopen(errFileName,"a");
        $strobe("dfwnsj1_10    VAC     error limit ( %d ) reached at %7.4r  %M", maxEv, $abstime );
        $fwrite(outfile,"dfwnsj1_10    VAC     error limit ( %d ) reached at %7.4r  %M\n", maxEv, $abstime );
        VAC_cnt=VAC_cnt-1;
        $fclose(outfile);
      end
   end

end // analog
endmodule // dfwnsj1_10

// Verilog-A OC Watch for device dfwpsj1_10 Parameters  VAC
module dfwpsj1_10_ahdl(A,C);
parameter tstep_occ=100n;
parameter errFileName="./occ.err";
parameter maxEv = 25;
parameter maxEv_flg = 0;
inout A,C;
electrical A,C;

integer outfile;
real V_A_C;
real VAC;
integer VAC_retc;
integer VAC_cnt;

analog begin
   $bound_step( tstep_occ );
   @(initial_step) begin
      VAC_retc=0;
      VAC_cnt = maxEv;
   end
   V_A_C = V(A,C);

//      VAC
   VAC = V_A_C;
   if((VAC_cnt>0) || ( maxEv_flg==0 ))   begin
      if( (VAC < -140) && (VAC_retc!=-1))
      begin
        outfile=$fopen(errFileName,"a");
        $strobe("dfwpsj1_10    VAC     leaving   OCA (  .. -140.000 V ) at %7.4r  %M", $abstime );
        $fwrite(outfile,"dfwpsj1_10    VAC     leaving   OCA (  .. -140.000 V ) at %7.4r  %M\n", $abstime );
        VAC_retc=-1;
        VAC_cnt=VAC_cnt-1;
        $fclose(outfile);
      end
      if((VAC >= -140) &&  (VAC <= 1.5) && (VAC_retc!=0))
      begin
        outfile=$fopen(errFileName,"a");
        $strobe("dfwpsj1_10    VAC     entering SOCA ( -140.000 V .. 1.500 V ) at %7.4r  %M", $abstime );
        $fwrite(outfile,"dfwpsj1_10    VAC     entering SOCA ( -140.000 V .. 1.500 V ) at %7.4r  %M\n", $abstime );
        VAC_retc=0;
        VAC_cnt=VAC_cnt-1;
        $fclose(outfile);
      end
      if((VAC > 1.5) &&  (VAC_retc!=1))
      begin
        outfile=$fopen(errFileName,"a");
        $strobe("dfwpsj1_10    VAC     leaving   OCA ( 1.500 V ..  ) at %7.4r  %M", $abstime );
        $fwrite(outfile,"dfwpsj1_10    VAC     leaving   OCA ( 1.500 V ..  ) at %7.4r  %M\n", $abstime );
        VAC_retc=1;
        VAC_cnt=VAC_cnt-1;
        $fclose(outfile);
      end
   end
   else
   begin
      if(VAC_cnt==0)
      begin
        outfile=$fopen(errFileName,"a");
        $strobe("dfwpsj1_10    VAC     error limit ( %d ) reached at %7.4r  %M", maxEv, $abstime );
        $fwrite(outfile,"dfwpsj1_10    VAC     error limit ( %d ) reached at %7.4r  %M\n", maxEv, $abstime );
        VAC_cnt=VAC_cnt-1;
        $fclose(outfile);
      end
   end

end // analog
endmodule // dfwpsj1_10

// Verilog-A OC Watch for device dfwnsj1_16c Parameters  VAC
module dfwnsj1_16c_ahdl(A,C);
parameter tstep_occ=100n;
parameter errFileName="./occ.err";
parameter maxEv = 25;
parameter maxEv_flg = 0;
inout A,C;
electrical A,C;

integer outfile;
real V_A_C;
real VAC;
integer VAC_retc;
integer VAC_cnt;

analog begin
   $bound_step( tstep_occ );
   @(initial_step) begin
      VAC_retc=0;
      VAC_cnt = maxEv;
   end
   V_A_C = V(A,C);

//      VAC
   VAC = V_A_C;
   if((VAC_cnt>0) || ( maxEv_flg==0 ))   begin
      if( (VAC < -200) && (VAC_retc!=-1))
      begin
        outfile=$fopen(errFileName,"a");
        $strobe("dfwnsj1_16c   VAC     leaving   OCA (  .. -200.000 V ) at %7.4r  %M", $abstime );
        $fwrite(outfile,"dfwnsj1_16c   VAC     leaving   OCA (  .. -200.000 V ) at %7.4r  %M\n", $abstime );
        VAC_retc=-1;
        VAC_cnt=VAC_cnt-1;
        $fclose(outfile);
      end
      if((VAC >= -200) &&  (VAC <= 1.5) && (VAC_retc!=0))
      begin
        outfile=$fopen(errFileName,"a");
        $strobe("dfwnsj1_16c   VAC     entering SOCA ( -200.000 V .. 1.500 V ) at %7.4r  %M", $abstime );
        $fwrite(outfile,"dfwnsj1_16c   VAC     entering SOCA ( -200.000 V .. 1.500 V ) at %7.4r  %M\n", $abstime );
        VAC_retc=0;
        VAC_cnt=VAC_cnt-1;
        $fclose(outfile);
      end
      if((VAC > 1.5) &&  (VAC_retc!=1))
      begin
        outfile=$fopen(errFileName,"a");
        $strobe("dfwnsj1_16c   VAC     leaving   OCA ( 1.500 V ..  ) at %7.4r  %M", $abstime );
        $fwrite(outfile,"dfwnsj1_16c   VAC     leaving   OCA ( 1.500 V ..  ) at %7.4r  %M\n", $abstime );
        VAC_retc=1;
        VAC_cnt=VAC_cnt-1;
        $fclose(outfile);
      end
   end
   else
   begin
      if(VAC_cnt==0)
      begin
        outfile=$fopen(errFileName,"a");
        $strobe("dfwnsj1_16c   VAC     error limit ( %d ) reached at %7.4r  %M", maxEv, $abstime );
        $fwrite(outfile,"dfwnsj1_16c   VAC     error limit ( %d ) reached at %7.4r  %M\n", maxEv, $abstime );
        VAC_cnt=VAC_cnt-1;
        $fclose(outfile);
      end
   end

end // analog
endmodule // dfwnsj1_16c

// Verilog-A OC Watch for device dfwpsj1_16c Parameters  VAC
module dfwpsj1_16c_ahdl(A,C);
parameter tstep_occ=100n;
parameter errFileName="./occ.err";
parameter maxEv = 25;
parameter maxEv_flg = 0;
inout A,C;
electrical A,C;

integer outfile;
real V_A_C;
real VAC;
integer VAC_retc;
integer VAC_cnt;

analog begin
   $bound_step( tstep_occ );
   @(initial_step) begin
      VAC_retc=0;
      VAC_cnt = maxEv;
   end
   V_A_C = V(A,C);

//      VAC
   VAC = V_A_C;
   if((VAC_cnt>0) || ( maxEv_flg==0 ))   begin
      if( (VAC < -200) && (VAC_retc!=-1))
      begin
        outfile=$fopen(errFileName,"a");
        $strobe("dfwpsj1_16c   VAC     leaving   OCA (  .. -200.000 V ) at %7.4r  %M", $abstime );
        $fwrite(outfile,"dfwpsj1_16c   VAC     leaving   OCA (  .. -200.000 V ) at %7.4r  %M\n", $abstime );
        VAC_retc=-1;
        VAC_cnt=VAC_cnt-1;
        $fclose(outfile);
      end
      if((VAC >= -200) &&  (VAC <= 1.5) && (VAC_retc!=0))
      begin
        outfile=$fopen(errFileName,"a");
        $strobe("dfwpsj1_16c   VAC     entering SOCA ( -200.000 V .. 1.500 V ) at %7.4r  %M", $abstime );
        $fwrite(outfile,"dfwpsj1_16c   VAC     entering SOCA ( -200.000 V .. 1.500 V ) at %7.4r  %M\n", $abstime );
        VAC_retc=0;
        VAC_cnt=VAC_cnt-1;
        $fclose(outfile);
      end
      if((VAC > 1.5) &&  (VAC_retc!=1))
      begin
        outfile=$fopen(errFileName,"a");
        $strobe("dfwpsj1_16c   VAC     leaving   OCA ( 1.500 V ..  ) at %7.4r  %M", $abstime );
        $fwrite(outfile,"dfwpsj1_16c   VAC     leaving   OCA ( 1.500 V ..  ) at %7.4r  %M\n", $abstime );
        VAC_retc=1;
        VAC_cnt=VAC_cnt-1;
        $fclose(outfile);
      end
   end
   else
   begin
      if(VAC_cnt==0)
      begin
        outfile=$fopen(errFileName,"a");
        $strobe("dfwpsj1_16c   VAC     error limit ( %d ) reached at %7.4r  %M", maxEv, $abstime );
        $fwrite(outfile,"dfwpsj1_16c   VAC     error limit ( %d ) reached at %7.4r  %M\n", maxEv, $abstime );
        VAC_cnt=VAC_cnt-1;
        $fclose(outfile);
      end
   end

end // analog
endmodule // dfwpsj1_16c

// Verilog-A OC Watch for device dhw2 Parameters  VAC
module dhw2_ahdl(A,C);
parameter tstep_occ=100n;
parameter errFileName="./occ.err";
parameter maxEv = 25;
parameter maxEv_flg = 0;
inout A,C;
electrical A,C;

integer outfile;
real V_A_C;
real VAC;
integer VAC_retc;
integer VAC_cnt;

analog begin
   $bound_step( tstep_occ );
   @(initial_step) begin
      VAC_retc=0;
      VAC_cnt = maxEv;
   end
   V_A_C = V(A,C);

//      VAC
   VAC = V_A_C;
   if((VAC_cnt>0) || ( maxEv_flg==0 ))   begin
      if( (VAC < -140) && (VAC_retc!=-1))
      begin
        outfile=$fopen(errFileName,"a");
        $strobe("dhw2          VAC     leaving   OCA (  .. -140.000 V ) at %7.4r  %M", $abstime );
        $fwrite(outfile,"dhw2          VAC     leaving   OCA (  .. -140.000 V ) at %7.4r  %M\n", $abstime );
        VAC_retc=-1;
        VAC_cnt=VAC_cnt-1;
        $fclose(outfile);
      end
      if((VAC >= -140) &&  (VAC <= 0.1) && (VAC_retc!=0))
      begin
        outfile=$fopen(errFileName,"a");
        $strobe("dhw2          VAC     entering SOCA ( -140.000 V .. 0.100 V ) at %7.4r  %M", $abstime );
        $fwrite(outfile,"dhw2          VAC     entering SOCA ( -140.000 V .. 0.100 V ) at %7.4r  %M\n", $abstime );
        VAC_retc=0;
        VAC_cnt=VAC_cnt-1;
        $fclose(outfile);
      end
      if((VAC > 0.1) &&  (VAC_retc!=1))
      begin
        outfile=$fopen(errFileName,"a");
        $strobe("dhw2          VAC     leaving   OCA ( 0.100 V ..  ) at %7.4r  %M", $abstime );
        $fwrite(outfile,"dhw2          VAC     leaving   OCA ( 0.100 V ..  ) at %7.4r  %M\n", $abstime );
        VAC_retc=1;
        VAC_cnt=VAC_cnt-1;
        $fclose(outfile);
      end
   end
   else
   begin
      if(VAC_cnt==0)
      begin
        outfile=$fopen(errFileName,"a");
        $strobe("dhw2          VAC     error limit ( %d ) reached at %7.4r  %M", maxEv, $abstime );
        $fwrite(outfile,"dhw2          VAC     error limit ( %d ) reached at %7.4r  %M\n", maxEv, $abstime );
        VAC_cnt=VAC_cnt-1;
        $fclose(outfile);
      end
   end

end // analog
endmodule // dhw2

// Verilog-A OC Watch for device dhw2a Parameters  VAC
module dhw2a_ahdl(A,C);
parameter tstep_occ=100n;
parameter errFileName="./occ.err";
parameter maxEv = 25;
parameter maxEv_flg = 0;
inout A,C;
electrical A,C;

integer outfile;
real V_A_C;
real VAC;
integer VAC_retc;
integer VAC_cnt;

analog begin
   $bound_step( tstep_occ );
   @(initial_step) begin
      VAC_retc=0;
      VAC_cnt = maxEv;
   end
   V_A_C = V(A,C);

//      VAC
   VAC = V_A_C;
   if((VAC_cnt>0) || ( maxEv_flg==0 ))   begin
      if( (VAC < -100) && (VAC_retc!=-1))
      begin
        outfile=$fopen(errFileName,"a");
        $strobe("dhw2a         VAC     leaving   OCA (  .. -100.000 V ) at %7.4r  %M", $abstime );
        $fwrite(outfile,"dhw2a         VAC     leaving   OCA (  .. -100.000 V ) at %7.4r  %M\n", $abstime );
        VAC_retc=-1;
        VAC_cnt=VAC_cnt-1;
        $fclose(outfile);
      end
      if((VAC >= -100) &&  (VAC <= 0.1) && (VAC_retc!=0))
      begin
        outfile=$fopen(errFileName,"a");
        $strobe("dhw2a         VAC     entering SOCA ( -100.000 V .. 0.100 V ) at %7.4r  %M", $abstime );
        $fwrite(outfile,"dhw2a         VAC     entering SOCA ( -100.000 V .. 0.100 V ) at %7.4r  %M\n", $abstime );
        VAC_retc=0;
        VAC_cnt=VAC_cnt-1;
        $fclose(outfile);
      end
      if((VAC > 0.1) &&  (VAC_retc!=1))
      begin
        outfile=$fopen(errFileName,"a");
        $strobe("dhw2a         VAC     leaving   OCA ( 0.100 V ..  ) at %7.4r  %M", $abstime );
        $fwrite(outfile,"dhw2a         VAC     leaving   OCA ( 0.100 V ..  ) at %7.4r  %M\n", $abstime );
        VAC_retc=1;
        VAC_cnt=VAC_cnt-1;
        $fclose(outfile);
      end
   end
   else
   begin
      if(VAC_cnt==0)
      begin
        outfile=$fopen(errFileName,"a");
        $strobe("dhw2a         VAC     error limit ( %d ) reached at %7.4r  %M", maxEv, $abstime );
        $fwrite(outfile,"dhw2a         VAC     error limit ( %d ) reached at %7.4r  %M\n", maxEv, $abstime );
        VAC_cnt=VAC_cnt-1;
        $fclose(outfile);
      end
   end

end // analog
endmodule // dhw2a

// Verilog-A OC Watch for device dhw2b Parameters  VAC
module dhw2b_ahdl(A,C);
parameter tstep_occ=100n;
parameter errFileName="./occ.err";
parameter maxEv = 25;
parameter maxEv_flg = 0;
inout A,C;
electrical A,C;

integer outfile;
real V_A_C;
real VAC;
integer VAC_retc;
integer VAC_cnt;

analog begin
   $bound_step( tstep_occ );
   @(initial_step) begin
      VAC_retc=0;
      VAC_cnt = maxEv;
   end
   V_A_C = V(A,C);

//      VAC
   VAC = V_A_C;
   if((VAC_cnt>0) || ( maxEv_flg==0 ))   begin
      if( (VAC < -115) && (VAC_retc!=-1))
      begin
        outfile=$fopen(errFileName,"a");
        $strobe("dhw2b         VAC     leaving   OCA (  .. -115.000 V ) at %7.4r  %M", $abstime );
        $fwrite(outfile,"dhw2b         VAC     leaving   OCA (  .. -115.000 V ) at %7.4r  %M\n", $abstime );
        VAC_retc=-1;
        VAC_cnt=VAC_cnt-1;
        $fclose(outfile);
      end
      if((VAC >= -115) &&  (VAC <= 0.1) && (VAC_retc!=0))
      begin
        outfile=$fopen(errFileName,"a");
        $strobe("dhw2b         VAC     entering SOCA ( -115.000 V .. 0.100 V ) at %7.4r  %M", $abstime );
        $fwrite(outfile,"dhw2b         VAC     entering SOCA ( -115.000 V .. 0.100 V ) at %7.4r  %M\n", $abstime );
        VAC_retc=0;
        VAC_cnt=VAC_cnt-1;
        $fclose(outfile);
      end
      if((VAC > 0.1) &&  (VAC_retc!=1))
      begin
        outfile=$fopen(errFileName,"a");
        $strobe("dhw2b         VAC     leaving   OCA ( 0.100 V ..  ) at %7.4r  %M", $abstime );
        $fwrite(outfile,"dhw2b         VAC     leaving   OCA ( 0.100 V ..  ) at %7.4r  %M\n", $abstime );
        VAC_retc=1;
        VAC_cnt=VAC_cnt-1;
        $fclose(outfile);
      end
   end
   else
   begin
      if(VAC_cnt==0)
      begin
        outfile=$fopen(errFileName,"a");
        $strobe("dhw2b         VAC     error limit ( %d ) reached at %7.4r  %M", maxEv, $abstime );
        $fwrite(outfile,"dhw2b         VAC     error limit ( %d ) reached at %7.4r  %M\n", maxEv, $abstime );
        VAC_cnt=VAC_cnt-1;
        $fclose(outfile);
      end
   end

end // analog
endmodule // dhw2b

// Verilog-A OC Watch for device dhw2c Parameters  VAC
module dhw2c_ahdl(A,C);
parameter tstep_occ=100n;
parameter errFileName="./occ.err";
parameter maxEv = 25;
parameter maxEv_flg = 0;
inout A,C;
electrical A,C;

integer outfile;
real V_A_C;
real VAC;
integer VAC_retc;
integer VAC_cnt;

analog begin
   $bound_step( tstep_occ );
   @(initial_step) begin
      VAC_retc=0;
      VAC_cnt = maxEv;
   end
   V_A_C = V(A,C);

//      VAC
   VAC = V_A_C;
   if((VAC_cnt>0) || ( maxEv_flg==0 ))   begin
      if( (VAC < -160) && (VAC_retc!=-1))
      begin
        outfile=$fopen(errFileName,"a");
        $strobe("dhw2c         VAC     leaving   OCA (  .. -160.000 V ) at %7.4r  %M", $abstime );
        $fwrite(outfile,"dhw2c         VAC     leaving   OCA (  .. -160.000 V ) at %7.4r  %M\n", $abstime );
        VAC_retc=-1;
        VAC_cnt=VAC_cnt-1;
        $fclose(outfile);
      end
      if((VAC >= -160) &&  (VAC <= 0.1) && (VAC_retc!=0))
      begin
        outfile=$fopen(errFileName,"a");
        $strobe("dhw2c         VAC     entering SOCA ( -160.000 V .. 0.100 V ) at %7.4r  %M", $abstime );
        $fwrite(outfile,"dhw2c         VAC     entering SOCA ( -160.000 V .. 0.100 V ) at %7.4r  %M\n", $abstime );
        VAC_retc=0;
        VAC_cnt=VAC_cnt-1;
        $fclose(outfile);
      end
      if((VAC > 0.1) &&  (VAC_retc!=1))
      begin
        outfile=$fopen(errFileName,"a");
        $strobe("dhw2c         VAC     leaving   OCA ( 0.100 V ..  ) at %7.4r  %M", $abstime );
        $fwrite(outfile,"dhw2c         VAC     leaving   OCA ( 0.100 V ..  ) at %7.4r  %M\n", $abstime );
        VAC_retc=1;
        VAC_cnt=VAC_cnt-1;
        $fclose(outfile);
      end
   end
   else
   begin
      if(VAC_cnt==0)
      begin
        outfile=$fopen(errFileName,"a");
        $strobe("dhw2c         VAC     error limit ( %d ) reached at %7.4r  %M", maxEv, $abstime );
        $fwrite(outfile,"dhw2c         VAC     error limit ( %d ) reached at %7.4r  %M\n", maxEv, $abstime );
        VAC_cnt=VAC_cnt-1;
        $fclose(outfile);
      end
   end

end // analog
endmodule // dhw2c

// Verilog-A OC Watch for device dhw3 Parameters  VAC
module dhw3_ahdl(A,C);
parameter tstep_occ=100n;
parameter errFileName="./occ.err";
parameter maxEv = 25;
parameter maxEv_flg = 0;
inout A,C;
electrical A,C;

integer outfile;
real V_A_C;
real VAC;
integer VAC_retc;
integer VAC_cnt;

analog begin
   $bound_step( tstep_occ );
   @(initial_step) begin
      VAC_retc=0;
      VAC_cnt = maxEv;
   end
   V_A_C = V(A,C);

//      VAC
   VAC = V_A_C;
   if((VAC_cnt>0) || ( maxEv_flg==0 ))   begin
      if( (VAC < -200) && (VAC_retc!=-1))
      begin
        outfile=$fopen(errFileName,"a");
        $strobe("dhw3          VAC     leaving   OCA (  .. -200.000 V ) at %7.4r  %M", $abstime );
        $fwrite(outfile,"dhw3          VAC     leaving   OCA (  .. -200.000 V ) at %7.4r  %M\n", $abstime );
        VAC_retc=-1;
        VAC_cnt=VAC_cnt-1;
        $fclose(outfile);
      end
      if((VAC >= -200) &&  (VAC <= 0.1) && (VAC_retc!=0))
      begin
        outfile=$fopen(errFileName,"a");
        $strobe("dhw3          VAC     entering SOCA ( -200.000 V .. 0.100 V ) at %7.4r  %M", $abstime );
        $fwrite(outfile,"dhw3          VAC     entering SOCA ( -200.000 V .. 0.100 V ) at %7.4r  %M\n", $abstime );
        VAC_retc=0;
        VAC_cnt=VAC_cnt-1;
        $fclose(outfile);
      end
      if((VAC > 0.1) &&  (VAC_retc!=1))
      begin
        outfile=$fopen(errFileName,"a");
        $strobe("dhw3          VAC     leaving   OCA ( 0.100 V ..  ) at %7.4r  %M", $abstime );
        $fwrite(outfile,"dhw3          VAC     leaving   OCA ( 0.100 V ..  ) at %7.4r  %M\n", $abstime );
        VAC_retc=1;
        VAC_cnt=VAC_cnt-1;
        $fclose(outfile);
      end
   end
   else
   begin
      if(VAC_cnt==0)
      begin
        outfile=$fopen(errFileName,"a");
        $strobe("dhw3          VAC     error limit ( %d ) reached at %7.4r  %M", maxEv, $abstime );
        $fwrite(outfile,"dhw3          VAC     error limit ( %d ) reached at %7.4r  %M\n", maxEv, $abstime );
        VAC_cnt=VAC_cnt-1;
        $fclose(outfile);
      end
   end

end // analog
endmodule // dhw3

// Verilog-A OC Watch for device dhw3c Parameters  VAC
module dhw3c_ahdl(A,C);
parameter tstep_occ=100n;
parameter errFileName="./occ.err";
parameter maxEv = 25;
parameter maxEv_flg = 0;
inout A,C;
electrical A,C;

integer outfile;
real V_A_C;
real VAC;
integer VAC_retc;
integer VAC_cnt;

analog begin
   $bound_step( tstep_occ );
   @(initial_step) begin
      VAC_retc=0;
      VAC_cnt = maxEv;
   end
   V_A_C = V(A,C);

//      VAC
   VAC = V_A_C;
   if((VAC_cnt>0) || ( maxEv_flg==0 ))   begin
      if( (VAC < -235) && (VAC_retc!=-1))
      begin
        outfile=$fopen(errFileName,"a");
        $strobe("dhw3c         VAC     leaving   OCA (  .. -235.000 V ) at %7.4r  %M", $abstime );
        $fwrite(outfile,"dhw3c         VAC     leaving   OCA (  .. -235.000 V ) at %7.4r  %M\n", $abstime );
        VAC_retc=-1;
        VAC_cnt=VAC_cnt-1;
        $fclose(outfile);
      end
      if((VAC >= -235) &&  (VAC <= 0.1) && (VAC_retc!=0))
      begin
        outfile=$fopen(errFileName,"a");
        $strobe("dhw3c         VAC     entering SOCA ( -235.000 V .. 0.100 V ) at %7.4r  %M", $abstime );
        $fwrite(outfile,"dhw3c         VAC     entering SOCA ( -235.000 V .. 0.100 V ) at %7.4r  %M\n", $abstime );
        VAC_retc=0;
        VAC_cnt=VAC_cnt-1;
        $fclose(outfile);
      end
      if((VAC > 0.1) &&  (VAC_retc!=1))
      begin
        outfile=$fopen(errFileName,"a");
        $strobe("dhw3c         VAC     leaving   OCA ( 0.100 V ..  ) at %7.4r  %M", $abstime );
        $fwrite(outfile,"dhw3c         VAC     leaving   OCA ( 0.100 V ..  ) at %7.4r  %M\n", $abstime );
        VAC_retc=1;
        VAC_cnt=VAC_cnt-1;
        $fclose(outfile);
      end
   end
   else
   begin
      if(VAC_cnt==0)
      begin
        outfile=$fopen(errFileName,"a");
        $strobe("dhw3c         VAC     error limit ( %d ) reached at %7.4r  %M", maxEv, $abstime );
        $fwrite(outfile,"dhw3c         VAC     error limit ( %d ) reached at %7.4r  %M\n", maxEv, $abstime );
        VAC_cnt=VAC_cnt-1;
        $fclose(outfile);
      end
   end

end // analog
endmodule // dhw3c

// Verilog-A OC Watch for device dhw4c Parameters  VAC
module dhw4c_ahdl(A,C);
parameter tstep_occ=100n;
parameter errFileName="./occ.err";
parameter maxEv = 25;
parameter maxEv_flg = 0;
inout A,C;
electrical A,C;

integer outfile;
real V_A_C;
real VAC;
integer VAC_retc;
integer VAC_cnt;

analog begin
   $bound_step( tstep_occ );
   @(initial_step) begin
      VAC_retc=0;
      VAC_cnt = maxEv;
   end
   V_A_C = V(A,C);

//      VAC
   VAC = V_A_C;
   if((VAC_cnt>0) || ( maxEv_flg==0 ))   begin
      if( (VAC < -280) && (VAC_retc!=-1))
      begin
        outfile=$fopen(errFileName,"a");
        $strobe("dhw4c         VAC     leaving   OCA (  .. -280.000 V ) at %7.4r  %M", $abstime );
        $fwrite(outfile,"dhw4c         VAC     leaving   OCA (  .. -280.000 V ) at %7.4r  %M\n", $abstime );
        VAC_retc=-1;
        VAC_cnt=VAC_cnt-1;
        $fclose(outfile);
      end
      if((VAC >= -280) &&  (VAC <= 0.1) && (VAC_retc!=0))
      begin
        outfile=$fopen(errFileName,"a");
        $strobe("dhw4c         VAC     entering SOCA ( -280.000 V .. 0.100 V ) at %7.4r  %M", $abstime );
        $fwrite(outfile,"dhw4c         VAC     entering SOCA ( -280.000 V .. 0.100 V ) at %7.4r  %M\n", $abstime );
        VAC_retc=0;
        VAC_cnt=VAC_cnt-1;
        $fclose(outfile);
      end
      if((VAC > 0.1) &&  (VAC_retc!=1))
      begin
        outfile=$fopen(errFileName,"a");
        $strobe("dhw4c         VAC     leaving   OCA ( 0.100 V ..  ) at %7.4r  %M", $abstime );
        $fwrite(outfile,"dhw4c         VAC     leaving   OCA ( 0.100 V ..  ) at %7.4r  %M\n", $abstime );
        VAC_retc=1;
        VAC_cnt=VAC_cnt-1;
        $fclose(outfile);
      end
   end
   else
   begin
      if(VAC_cnt==0)
      begin
        outfile=$fopen(errFileName,"a");
        $strobe("dhw4c         VAC     error limit ( %d ) reached at %7.4r  %M", maxEv, $abstime );
        $fwrite(outfile,"dhw4c         VAC     error limit ( %d ) reached at %7.4r  %M\n", maxEv, $abstime );
        VAC_cnt=VAC_cnt-1;
        $fclose(outfile);
      end
   end

end // analog
endmodule // dhw4c

// Verilog-A OC Watch for device dhw4d Parameters  VAC
module dhw4d_ahdl(A,C);
parameter tstep_occ=100n;
parameter errFileName="./occ.err";
parameter maxEv = 25;
parameter maxEv_flg = 0;
inout A,C;
electrical A,C;

integer outfile;
real V_A_C;
real VAC;
integer VAC_retc;
integer VAC_cnt;

analog begin
   $bound_step( tstep_occ );
   @(initial_step) begin
      VAC_retc=0;
      VAC_cnt = maxEv;
   end
   V_A_C = V(A,C);

//      VAC
   VAC = V_A_C;
   if((VAC_cnt>0) || ( maxEv_flg==0 ))   begin
      if( (VAC < -360) && (VAC_retc!=-1))
      begin
        outfile=$fopen(errFileName,"a");
        $strobe("dhw4d         VAC     leaving   OCA (  .. -360.000 V ) at %7.4r  %M", $abstime );
        $fwrite(outfile,"dhw4d         VAC     leaving   OCA (  .. -360.000 V ) at %7.4r  %M\n", $abstime );
        VAC_retc=-1;
        VAC_cnt=VAC_cnt-1;
        $fclose(outfile);
      end
      if((VAC >= -360) &&  (VAC <= 0.1) && (VAC_retc!=0))
      begin
        outfile=$fopen(errFileName,"a");
        $strobe("dhw4d         VAC     entering SOCA ( -360.000 V .. 0.100 V ) at %7.4r  %M", $abstime );
        $fwrite(outfile,"dhw4d         VAC     entering SOCA ( -360.000 V .. 0.100 V ) at %7.4r  %M\n", $abstime );
        VAC_retc=0;
        VAC_cnt=VAC_cnt-1;
        $fclose(outfile);
      end
      if((VAC > 0.1) &&  (VAC_retc!=1))
      begin
        outfile=$fopen(errFileName,"a");
        $strobe("dhw4d         VAC     leaving   OCA ( 0.100 V ..  ) at %7.4r  %M", $abstime );
        $fwrite(outfile,"dhw4d         VAC     leaving   OCA ( 0.100 V ..  ) at %7.4r  %M\n", $abstime );
        VAC_retc=1;
        VAC_cnt=VAC_cnt-1;
        $fclose(outfile);
      end
   end
   else
   begin
      if(VAC_cnt==0)
      begin
        outfile=$fopen(errFileName,"a");
        $strobe("dhw4d         VAC     error limit ( %d ) reached at %7.4r  %M", maxEv, $abstime );
        $fwrite(outfile,"dhw4d         VAC     error limit ( %d ) reached at %7.4r  %M\n", maxEv, $abstime );
        VAC_cnt=VAC_cnt-1;
        $fclose(outfile);
      end
   end

end // analog
endmodule // dhw4d

// Verilog-A OC Watch for device dhw5d Parameters  VAC
module dhw5d_ahdl(A,C);
parameter tstep_occ=100n;
parameter errFileName="./occ.err";
parameter maxEv = 25;
parameter maxEv_flg = 0;
inout A,C;
electrical A,C;

integer outfile;
real V_A_C;
real VAC;
integer VAC_retc;
integer VAC_cnt;

analog begin
   $bound_step( tstep_occ );
   @(initial_step) begin
      VAC_retc=0;
      VAC_cnt = maxEv;
   end
   V_A_C = V(A,C);

//      VAC
   VAC = V_A_C;
   if((VAC_cnt>0) || ( maxEv_flg==0 ))   begin
      if( (VAC < -420) && (VAC_retc!=-1))
      begin
        outfile=$fopen(errFileName,"a");
        $strobe("dhw5d         VAC     leaving   OCA (  .. -420.000 V ) at %7.4r  %M", $abstime );
        $fwrite(outfile,"dhw5d         VAC     leaving   OCA (  .. -420.000 V ) at %7.4r  %M\n", $abstime );
        VAC_retc=-1;
        VAC_cnt=VAC_cnt-1;
        $fclose(outfile);
      end
      if((VAC >= -420) &&  (VAC <= 0.1) && (VAC_retc!=0))
      begin
        outfile=$fopen(errFileName,"a");
        $strobe("dhw5d         VAC     entering SOCA ( -420.000 V .. 0.100 V ) at %7.4r  %M", $abstime );
        $fwrite(outfile,"dhw5d         VAC     entering SOCA ( -420.000 V .. 0.100 V ) at %7.4r  %M\n", $abstime );
        VAC_retc=0;
        VAC_cnt=VAC_cnt-1;
        $fclose(outfile);
      end
      if((VAC > 0.1) &&  (VAC_retc!=1))
      begin
        outfile=$fopen(errFileName,"a");
        $strobe("dhw5d         VAC     leaving   OCA ( 0.100 V ..  ) at %7.4r  %M", $abstime );
        $fwrite(outfile,"dhw5d         VAC     leaving   OCA ( 0.100 V ..  ) at %7.4r  %M\n", $abstime );
        VAC_retc=1;
        VAC_cnt=VAC_cnt-1;
        $fclose(outfile);
      end
   end
   else
   begin
      if(VAC_cnt==0)
      begin
        outfile=$fopen(errFileName,"a");
        $strobe("dhw5d         VAC     error limit ( %d ) reached at %7.4r  %M", maxEv, $abstime );
        $fwrite(outfile,"dhw5d         VAC     error limit ( %d ) reached at %7.4r  %M\n", maxEv, $abstime );
        VAC_cnt=VAC_cnt-1;
        $fclose(outfile);
      end
   end

end // analog
endmodule // dhw5d

// Verilog-A OC Watch for device dpp6 Parameters  VAC Ibr Ibr1000
module dpp6_ahdl(A1,C1,A,C);
parameter tstep_occ=100n;
parameter errFileName="./occ.err";
parameter area = 1u;
parameter m_soa = 1;
parameter maxEv = 25;
parameter maxEv_flg = 0;
inout A1,C1,A,C;
electrical A1,C1,A,C;

integer outfile;
real V_A_C;
real I_C;
real I_A;
real VAC;
integer VAC_retc;
integer VAC_cnt;
real Ibr;
integer Ibr_retc;
integer Ibr_cnt;
real Ibr1000;
integer Ibr1000_retc;
integer Ibr1000_cnt;

analog begin
   $bound_step( tstep_occ );
   @(initial_step) begin
      VAC_retc=0;
      VAC_cnt = maxEv;
      Ibr_retc=0;
      Ibr_cnt = maxEv;
      Ibr1000_retc=0;
      Ibr1000_cnt = maxEv;
   end
   V_A_C = V(A,C);
   I_C = I(C1,C);
   I_A = I(A1,A);

//      VAC
   VAC = V_A_C;
   if((VAC_cnt>0) || ( maxEv_flg==0 ))   begin
      if( (VAC < -7) && (VAC_retc!=-1))
      begin
        outfile=$fopen(errFileName,"a");
        $strobe("dpp6          VAC     leaving   OCA (  .. -7.000 V ) at %7.4r  %M", $abstime );
        $fwrite(outfile,"dpp6          VAC     leaving   OCA (  .. -7.000 V ) at %7.4r  %M\n", $abstime );
        VAC_retc=-1;
        VAC_cnt=VAC_cnt-1;
        $fclose(outfile);
      end
      if((VAC >= -7) &&  (VAC <= 0.1) && (VAC_retc!=0))
      begin
        outfile=$fopen(errFileName,"a");
        $strobe("dpp6          VAC     entering SOCA ( -7.000 V .. 0.100 V ) at %7.4r  %M", $abstime );
        $fwrite(outfile,"dpp6          VAC     entering SOCA ( -7.000 V .. 0.100 V ) at %7.4r  %M\n", $abstime );
        VAC_retc=0;
        VAC_cnt=VAC_cnt-1;
        $fclose(outfile);
      end
      if((VAC > 0.1) &&  (VAC_retc!=1))
      begin
        outfile=$fopen(errFileName,"a");
        $strobe("dpp6          VAC     leaving   OCA ( 0.100 V ..  ) at %7.4r  %M", $abstime );
        $fwrite(outfile,"dpp6          VAC     leaving   OCA ( 0.100 V ..  ) at %7.4r  %M\n", $abstime );
        VAC_retc=1;
        VAC_cnt=VAC_cnt-1;
        $fclose(outfile);
      end
   end
   else
   begin
      if(VAC_cnt==0)
      begin
        outfile=$fopen(errFileName,"a");
        $strobe("dpp6          VAC     error limit ( %d ) reached at %7.4r  %M", maxEv, $abstime );
        $fwrite(outfile,"dpp6          VAC     error limit ( %d ) reached at %7.4r  %M\n", maxEv, $abstime );
        VAC_cnt=VAC_cnt-1;
        $fclose(outfile);
      end
   end

//      Ibr
   Ibr = I_C /  ( m_soa * area / 8.2e-07 ) ;
   if((Ibr_cnt>0) || ( maxEv_flg==0 ))   begin
      if( (Ibr < -0.5) && (Ibr_retc!=-1))
      begin
        outfile=$fopen(errFileName,"a");
        $strobe("dpp6          Ibr     leaving   OCA (  .. -0.500 uA/um ) at %7.4r  %M", $abstime );
        $fwrite(outfile,"dpp6          Ibr     leaving   OCA (  .. -0.500 uA/um ) at %7.4r  %M\n", $abstime );
        Ibr_retc=-1;
        Ibr_cnt=Ibr_cnt-1;
        $fclose(outfile);
      end
      if((Ibr >= -0.5) &&  (Ibr <= 0.5) && (Ibr_retc!=0))
      begin
        outfile=$fopen(errFileName,"a");
        $strobe("dpp6          Ibr     entering SOCA ( -0.500 uA/um .. 0.500 uA/um ) at %7.4r  %M", $abstime );
        $fwrite(outfile,"dpp6          Ibr     entering SOCA ( -0.500 uA/um .. 0.500 uA/um ) at %7.4r  %M\n", $abstime );
        Ibr_retc=0;
        Ibr_cnt=Ibr_cnt-1;
        $fclose(outfile);
      end
      if((Ibr > 0.5) &&  (Ibr_retc!=1))
      begin
        outfile=$fopen(errFileName,"a");
        $strobe("dpp6          Ibr     leaving   OCA ( 0.500 uA/um ..  ) at %7.4r  %M", $abstime );
        $fwrite(outfile,"dpp6          Ibr     leaving   OCA ( 0.500 uA/um ..  ) at %7.4r  %M\n", $abstime );
        Ibr_retc=1;
        Ibr_cnt=Ibr_cnt-1;
        $fclose(outfile);
      end
   end
   else
   begin
      if(Ibr_cnt==0)
      begin
        outfile=$fopen(errFileName,"a");
        $strobe("dpp6          Ibr     error limit ( %d ) reached at %7.4r  %M", maxEv, $abstime );
        $fwrite(outfile,"dpp6          Ibr     error limit ( %d ) reached at %7.4r  %M\n", maxEv, $abstime );
        Ibr_cnt=Ibr_cnt-1;
        $fclose(outfile);
      end
   end

//      Ibr1000
   Ibr1000 = I_C /  ( m_soa * area / 8.2e-07 ) ;
   if((Ibr1000_cnt>0) || ( maxEv_flg==0 ))   begin
      if( (Ibr1000 < -5) && (Ibr1000_retc!=-1))
      begin
        outfile=$fopen(errFileName,"a");
        $strobe("dpp6          Ibr1000 leaving   OCA (  .. -5.000 uA/um ) at %7.4r  %M", $abstime );
        $fwrite(outfile,"dpp6          Ibr1000 leaving   OCA (  .. -5.000 uA/um ) at %7.4r  %M\n", $abstime );
        Ibr1000_retc=-1;
        Ibr1000_cnt=Ibr1000_cnt-1;
        $fclose(outfile);
      end
      if((Ibr1000 >= -5) &&  (Ibr1000 <= 5) && (Ibr1000_retc!=0))
      begin
        outfile=$fopen(errFileName,"a");
        $strobe("dpp6          Ibr1000 entering SOCA ( -5.000 uA/um .. 5.000 uA/um ) at %7.4r  %M", $abstime );
        $fwrite(outfile,"dpp6          Ibr1000 entering SOCA ( -5.000 uA/um .. 5.000 uA/um ) at %7.4r  %M\n", $abstime );
        Ibr1000_retc=0;
        Ibr1000_cnt=Ibr1000_cnt-1;
        $fclose(outfile);
      end
      if((Ibr1000 > 5) &&  (Ibr1000_retc!=1))
      begin
        outfile=$fopen(errFileName,"a");
        $strobe("dpp6          Ibr1000 leaving   OCA ( 5.000 uA/um ..  ) at %7.4r  %M", $abstime );
        $fwrite(outfile,"dpp6          Ibr1000 leaving   OCA ( 5.000 uA/um ..  ) at %7.4r  %M\n", $abstime );
        Ibr1000_retc=1;
        Ibr1000_cnt=Ibr1000_cnt-1;
        $fclose(outfile);
      end
   end
   else
   begin
      if(Ibr1000_cnt==0)
      begin
        outfile=$fopen(errFileName,"a");
        $strobe("dpp6          Ibr1000 error limit ( %d ) reached at %7.4r  %M", maxEv, $abstime );
        $fwrite(outfile,"dpp6          Ibr1000 error limit ( %d ) reached at %7.4r  %M\n", maxEv, $abstime );
        Ibr1000_cnt=Ibr1000_cnt-1;
        $fclose(outfile);
      end
   end

end // analog
endmodule // dpp6

// Verilog-A OC Watch for device dnp7 Parameters  VAC Ibr Ibr1000
module dnp7_ahdl(A1,C1,A,C);
parameter tstep_occ=100n;
parameter errFileName="./occ.err";
parameter area = 1u;
parameter m_soa = 1;
parameter maxEv = 25;
parameter maxEv_flg = 0;
inout A1,C1,A,C;
electrical A1,C1,A,C;

integer outfile;
real V_A_C;
real I_C;
real I_A;
real VAC;
integer VAC_retc;
integer VAC_cnt;
real Ibr;
integer Ibr_retc;
integer Ibr_cnt;
real Ibr1000;
integer Ibr1000_retc;
integer Ibr1000_cnt;

analog begin
   $bound_step( tstep_occ );
   @(initial_step) begin
      VAC_retc=0;
      VAC_cnt = maxEv;
      Ibr_retc=0;
      Ibr_cnt = maxEv;
      Ibr1000_retc=0;
      Ibr1000_cnt = maxEv;
   end
   V_A_C = V(A,C);
   I_C = I(C1,C);
   I_A = I(A1,A);

//      VAC
   VAC = V_A_C;
   if((VAC_cnt>0) || ( maxEv_flg==0 ))   begin
      if( (VAC < -9.6) && (VAC_retc!=-1))
      begin
        outfile=$fopen(errFileName,"a");
        $strobe("dnp7          VAC     leaving   OCA (  .. -9.600 V ) at %7.4r  %M", $abstime );
        $fwrite(outfile,"dnp7          VAC     leaving   OCA (  .. -9.600 V ) at %7.4r  %M\n", $abstime );
        VAC_retc=-1;
        VAC_cnt=VAC_cnt-1;
        $fclose(outfile);
      end
      if((VAC >= -9.6) &&  (VAC <= 0.1) && (VAC_retc!=0))
      begin
        outfile=$fopen(errFileName,"a");
        $strobe("dnp7          VAC     entering SOCA ( -9.600 V .. 0.100 V ) at %7.4r  %M", $abstime );
        $fwrite(outfile,"dnp7          VAC     entering SOCA ( -9.600 V .. 0.100 V ) at %7.4r  %M\n", $abstime );
        VAC_retc=0;
        VAC_cnt=VAC_cnt-1;
        $fclose(outfile);
      end
      if((VAC > 0.1) &&  (VAC_retc!=1))
      begin
        outfile=$fopen(errFileName,"a");
        $strobe("dnp7          VAC     leaving   OCA ( 0.100 V ..  ) at %7.4r  %M", $abstime );
        $fwrite(outfile,"dnp7          VAC     leaving   OCA ( 0.100 V ..  ) at %7.4r  %M\n", $abstime );
        VAC_retc=1;
        VAC_cnt=VAC_cnt-1;
        $fclose(outfile);
      end
   end
   else
   begin
      if(VAC_cnt==0)
      begin
        outfile=$fopen(errFileName,"a");
        $strobe("dnp7          VAC     error limit ( %d ) reached at %7.4r  %M", maxEv, $abstime );
        $fwrite(outfile,"dnp7          VAC     error limit ( %d ) reached at %7.4r  %M\n", maxEv, $abstime );
        VAC_cnt=VAC_cnt-1;
        $fclose(outfile);
      end
   end

//      Ibr
   Ibr = I_C /  ( m_soa * area / 1e-06 ) ;
   if((Ibr_cnt>0) || ( maxEv_flg==0 ))   begin
      if( (Ibr < -0.5) && (Ibr_retc!=-1))
      begin
        outfile=$fopen(errFileName,"a");
        $strobe("dnp7          Ibr     leaving   OCA (  .. -0.500 uA/um ) at %7.4r  %M", $abstime );
        $fwrite(outfile,"dnp7          Ibr     leaving   OCA (  .. -0.500 uA/um ) at %7.4r  %M\n", $abstime );
        Ibr_retc=-1;
        Ibr_cnt=Ibr_cnt-1;
        $fclose(outfile);
      end
      if((Ibr >= -0.5) &&  (Ibr <= 0.5) && (Ibr_retc!=0))
      begin
        outfile=$fopen(errFileName,"a");
        $strobe("dnp7          Ibr     entering SOCA ( -0.500 uA/um .. 0.500 uA/um ) at %7.4r  %M", $abstime );
        $fwrite(outfile,"dnp7          Ibr     entering SOCA ( -0.500 uA/um .. 0.500 uA/um ) at %7.4r  %M\n", $abstime );
        Ibr_retc=0;
        Ibr_cnt=Ibr_cnt-1;
        $fclose(outfile);
      end
      if((Ibr > 0.5) &&  (Ibr_retc!=1))
      begin
        outfile=$fopen(errFileName,"a");
        $strobe("dnp7          Ibr     leaving   OCA ( 0.500 uA/um ..  ) at %7.4r  %M", $abstime );
        $fwrite(outfile,"dnp7          Ibr     leaving   OCA ( 0.500 uA/um ..  ) at %7.4r  %M\n", $abstime );
        Ibr_retc=1;
        Ibr_cnt=Ibr_cnt-1;
        $fclose(outfile);
      end
   end
   else
   begin
      if(Ibr_cnt==0)
      begin
        outfile=$fopen(errFileName,"a");
        $strobe("dnp7          Ibr     error limit ( %d ) reached at %7.4r  %M", maxEv, $abstime );
        $fwrite(outfile,"dnp7          Ibr     error limit ( %d ) reached at %7.4r  %M\n", maxEv, $abstime );
        Ibr_cnt=Ibr_cnt-1;
        $fclose(outfile);
      end
   end

//      Ibr1000
   Ibr1000 = I_C /  ( m_soa * area / 1e-06 ) ;
   if((Ibr1000_cnt>0) || ( maxEv_flg==0 ))   begin
      if( (Ibr1000 < -5) && (Ibr1000_retc!=-1))
      begin
        outfile=$fopen(errFileName,"a");
        $strobe("dnp7          Ibr1000 leaving   OCA (  .. -5.000 uA/um ) at %7.4r  %M", $abstime );
        $fwrite(outfile,"dnp7          Ibr1000 leaving   OCA (  .. -5.000 uA/um ) at %7.4r  %M\n", $abstime );
        Ibr1000_retc=-1;
        Ibr1000_cnt=Ibr1000_cnt-1;
        $fclose(outfile);
      end
      if((Ibr1000 >= -5) &&  (Ibr1000 <= 5) && (Ibr1000_retc!=0))
      begin
        outfile=$fopen(errFileName,"a");
        $strobe("dnp7          Ibr1000 entering SOCA ( -5.000 uA/um .. 5.000 uA/um ) at %7.4r  %M", $abstime );
        $fwrite(outfile,"dnp7          Ibr1000 entering SOCA ( -5.000 uA/um .. 5.000 uA/um ) at %7.4r  %M\n", $abstime );
        Ibr1000_retc=0;
        Ibr1000_cnt=Ibr1000_cnt-1;
        $fclose(outfile);
      end
      if((Ibr1000 > 5) &&  (Ibr1000_retc!=1))
      begin
        outfile=$fopen(errFileName,"a");
        $strobe("dnp7          Ibr1000 leaving   OCA ( 5.000 uA/um ..  ) at %7.4r  %M", $abstime );
        $fwrite(outfile,"dnp7          Ibr1000 leaving   OCA ( 5.000 uA/um ..  ) at %7.4r  %M\n", $abstime );
        Ibr1000_retc=1;
        Ibr1000_cnt=Ibr1000_cnt-1;
        $fclose(outfile);
      end
   end
   else
   begin
      if(Ibr1000_cnt==0)
      begin
        outfile=$fopen(errFileName,"a");
        $strobe("dnp7          Ibr1000 error limit ( %d ) reached at %7.4r  %M", maxEv, $abstime );
        $fwrite(outfile,"dnp7          Ibr1000 error limit ( %d ) reached at %7.4r  %M\n", maxEv, $abstime );
        Ibr1000_cnt=Ibr1000_cnt-1;
        $fclose(outfile);
      end
   end

end // analog
endmodule // dnp7

// Verilog-A OC Watch for device dpp7 Parameters  VAC Ibr Ibr1000
module dpp7_ahdl(A1,C1,A,C);
parameter tstep_occ=100n;
parameter errFileName="./occ.err";
parameter area = 1u;
parameter m_soa = 1;
parameter maxEv = 25;
parameter maxEv_flg = 0;
inout A1,C1,A,C;
electrical A1,C1,A,C;

integer outfile;
real V_A_C;
real I_C;
real I_A;
real VAC;
integer VAC_retc;
integer VAC_cnt;
real Ibr;
integer Ibr_retc;
integer Ibr_cnt;
real Ibr1000;
integer Ibr1000_retc;
integer Ibr1000_cnt;

analog begin
   $bound_step( tstep_occ );
   @(initial_step) begin
      VAC_retc=0;
      VAC_cnt = maxEv;
      Ibr_retc=0;
      Ibr_cnt = maxEv;
      Ibr1000_retc=0;
      Ibr1000_cnt = maxEv;
   end
   V_A_C = V(A,C);
   I_C = I(C1,C);
   I_A = I(A1,A);

//      VAC
   VAC = V_A_C;
   if((VAC_cnt>0) || ( maxEv_flg==0 ))   begin
      if( (VAC < -9.4) && (VAC_retc!=-1))
      begin
        outfile=$fopen(errFileName,"a");
        $strobe("dpp7          VAC     leaving   OCA (  .. -9.400 V ) at %7.4r  %M", $abstime );
        $fwrite(outfile,"dpp7          VAC     leaving   OCA (  .. -9.400 V ) at %7.4r  %M\n", $abstime );
        VAC_retc=-1;
        VAC_cnt=VAC_cnt-1;
        $fclose(outfile);
      end
      if((VAC >= -9.4) &&  (VAC <= 0.1) && (VAC_retc!=0))
      begin
        outfile=$fopen(errFileName,"a");
        $strobe("dpp7          VAC     entering SOCA ( -9.400 V .. 0.100 V ) at %7.4r  %M", $abstime );
        $fwrite(outfile,"dpp7          VAC     entering SOCA ( -9.400 V .. 0.100 V ) at %7.4r  %M\n", $abstime );
        VAC_retc=0;
        VAC_cnt=VAC_cnt-1;
        $fclose(outfile);
      end
      if((VAC > 0.1) &&  (VAC_retc!=1))
      begin
        outfile=$fopen(errFileName,"a");
        $strobe("dpp7          VAC     leaving   OCA ( 0.100 V ..  ) at %7.4r  %M", $abstime );
        $fwrite(outfile,"dpp7          VAC     leaving   OCA ( 0.100 V ..  ) at %7.4r  %M\n", $abstime );
        VAC_retc=1;
        VAC_cnt=VAC_cnt-1;
        $fclose(outfile);
      end
   end
   else
   begin
      if(VAC_cnt==0)
      begin
        outfile=$fopen(errFileName,"a");
        $strobe("dpp7          VAC     error limit ( %d ) reached at %7.4r  %M", maxEv, $abstime );
        $fwrite(outfile,"dpp7          VAC     error limit ( %d ) reached at %7.4r  %M\n", maxEv, $abstime );
        VAC_cnt=VAC_cnt-1;
        $fclose(outfile);
      end
   end

//      Ibr
   Ibr = I_C /  ( m_soa * area / 1e-06 ) ;
   if((Ibr_cnt>0) || ( maxEv_flg==0 ))   begin
      if( (Ibr < -0.5) && (Ibr_retc!=-1))
      begin
        outfile=$fopen(errFileName,"a");
        $strobe("dpp7          Ibr     leaving   OCA (  .. -0.500 uA/um ) at %7.4r  %M", $abstime );
        $fwrite(outfile,"dpp7          Ibr     leaving   OCA (  .. -0.500 uA/um ) at %7.4r  %M\n", $abstime );
        Ibr_retc=-1;
        Ibr_cnt=Ibr_cnt-1;
        $fclose(outfile);
      end
      if((Ibr >= -0.5) &&  (Ibr <= 0.5) && (Ibr_retc!=0))
      begin
        outfile=$fopen(errFileName,"a");
        $strobe("dpp7          Ibr     entering SOCA ( -0.500 uA/um .. 0.500 uA/um ) at %7.4r  %M", $abstime );
        $fwrite(outfile,"dpp7          Ibr     entering SOCA ( -0.500 uA/um .. 0.500 uA/um ) at %7.4r  %M\n", $abstime );
        Ibr_retc=0;
        Ibr_cnt=Ibr_cnt-1;
        $fclose(outfile);
      end
      if((Ibr > 0.5) &&  (Ibr_retc!=1))
      begin
        outfile=$fopen(errFileName,"a");
        $strobe("dpp7          Ibr     leaving   OCA ( 0.500 uA/um ..  ) at %7.4r  %M", $abstime );
        $fwrite(outfile,"dpp7          Ibr     leaving   OCA ( 0.500 uA/um ..  ) at %7.4r  %M\n", $abstime );
        Ibr_retc=1;
        Ibr_cnt=Ibr_cnt-1;
        $fclose(outfile);
      end
   end
   else
   begin
      if(Ibr_cnt==0)
      begin
        outfile=$fopen(errFileName,"a");
        $strobe("dpp7          Ibr     error limit ( %d ) reached at %7.4r  %M", maxEv, $abstime );
        $fwrite(outfile,"dpp7          Ibr     error limit ( %d ) reached at %7.4r  %M\n", maxEv, $abstime );
        Ibr_cnt=Ibr_cnt-1;
        $fclose(outfile);
      end
   end

//      Ibr1000
   Ibr1000 = I_C /  ( m_soa * area / 1e-06 ) ;
   if((Ibr1000_cnt>0) || ( maxEv_flg==0 ))   begin
      if( (Ibr1000 < -5) && (Ibr1000_retc!=-1))
      begin
        outfile=$fopen(errFileName,"a");
        $strobe("dpp7          Ibr1000 leaving   OCA (  .. -5.000 uA/um ) at %7.4r  %M", $abstime );
        $fwrite(outfile,"dpp7          Ibr1000 leaving   OCA (  .. -5.000 uA/um ) at %7.4r  %M\n", $abstime );
        Ibr1000_retc=-1;
        Ibr1000_cnt=Ibr1000_cnt-1;
        $fclose(outfile);
      end
      if((Ibr1000 >= -5) &&  (Ibr1000 <= 5) && (Ibr1000_retc!=0))
      begin
        outfile=$fopen(errFileName,"a");
        $strobe("dpp7          Ibr1000 entering SOCA ( -5.000 uA/um .. 5.000 uA/um ) at %7.4r  %M", $abstime );
        $fwrite(outfile,"dpp7          Ibr1000 entering SOCA ( -5.000 uA/um .. 5.000 uA/um ) at %7.4r  %M\n", $abstime );
        Ibr1000_retc=0;
        Ibr1000_cnt=Ibr1000_cnt-1;
        $fclose(outfile);
      end
      if((Ibr1000 > 5) &&  (Ibr1000_retc!=1))
      begin
        outfile=$fopen(errFileName,"a");
        $strobe("dpp7          Ibr1000 leaving   OCA ( 5.000 uA/um ..  ) at %7.4r  %M", $abstime );
        $fwrite(outfile,"dpp7          Ibr1000 leaving   OCA ( 5.000 uA/um ..  ) at %7.4r  %M\n", $abstime );
        Ibr1000_retc=1;
        Ibr1000_cnt=Ibr1000_cnt-1;
        $fclose(outfile);
      end
   end
   else
   begin
      if(Ibr1000_cnt==0)
      begin
        outfile=$fopen(errFileName,"a");
        $strobe("dpp7          Ibr1000 error limit ( %d ) reached at %7.4r  %M", maxEv, $abstime );
        $fwrite(outfile,"dpp7          Ibr1000 error limit ( %d ) reached at %7.4r  %M\n", maxEv, $abstime );
        Ibr1000_cnt=Ibr1000_cnt-1;
        $fclose(outfile);
      end
   end

end // analog
endmodule // dpp7

// Verilog-A OC Watch for device dnpati Parameters  VAC Ibr Ibr1000
module dnpati_ahdl(A1,C1,A,C);
parameter tstep_occ=100n;
parameter errFileName="./occ.err";
parameter area = 1u;
parameter m_soa = 1;
parameter maxEv = 25;
parameter maxEv_flg = 0;
inout A1,C1,A,C;
electrical A1,C1,A,C;

integer outfile;
real V_A_C;
real I_C;
real I_A;
real VAC;
integer VAC_retc;
integer VAC_cnt;
real Ibr;
integer Ibr_retc;
integer Ibr_cnt;
real Ibr1000;
integer Ibr1000_retc;
integer Ibr1000_cnt;

analog begin
   $bound_step( tstep_occ );
   @(initial_step) begin
      VAC_retc=0;
      VAC_cnt = maxEv;
      Ibr_retc=0;
      Ibr_cnt = maxEv;
      Ibr1000_retc=0;
      Ibr1000_cnt = maxEv;
   end
   V_A_C = V(A,C);
   I_C = I(C1,C);
   I_A = I(A1,A);

//      VAC
   VAC = V_A_C;
   if((VAC_cnt>0) || ( maxEv_flg==0 ))   begin
      if( (VAC < -9) && (VAC_retc!=-1))
      begin
        outfile=$fopen(errFileName,"a");
        $strobe("dnpati        VAC     leaving   OCA (  .. -9.000 V ) at %7.4r  %M", $abstime );
        $fwrite(outfile,"dnpati        VAC     leaving   OCA (  .. -9.000 V ) at %7.4r  %M\n", $abstime );
        VAC_retc=-1;
        VAC_cnt=VAC_cnt-1;
        $fclose(outfile);
      end
      if((VAC >= -9) &&  (VAC <= 0.1) && (VAC_retc!=0))
      begin
        outfile=$fopen(errFileName,"a");
        $strobe("dnpati        VAC     entering SOCA ( -9.000 V .. 0.100 V ) at %7.4r  %M", $abstime );
        $fwrite(outfile,"dnpati        VAC     entering SOCA ( -9.000 V .. 0.100 V ) at %7.4r  %M\n", $abstime );
        VAC_retc=0;
        VAC_cnt=VAC_cnt-1;
        $fclose(outfile);
      end
      if((VAC > 0.1) &&  (VAC_retc!=1))
      begin
        outfile=$fopen(errFileName,"a");
        $strobe("dnpati        VAC     leaving   OCA ( 0.100 V ..  ) at %7.4r  %M", $abstime );
        $fwrite(outfile,"dnpati        VAC     leaving   OCA ( 0.100 V ..  ) at %7.4r  %M\n", $abstime );
        VAC_retc=1;
        VAC_cnt=VAC_cnt-1;
        $fclose(outfile);
      end
   end
   else
   begin
      if(VAC_cnt==0)
      begin
        outfile=$fopen(errFileName,"a");
        $strobe("dnpati        VAC     error limit ( %d ) reached at %7.4r  %M", maxEv, $abstime );
        $fwrite(outfile,"dnpati        VAC     error limit ( %d ) reached at %7.4r  %M\n", maxEv, $abstime );
        VAC_cnt=VAC_cnt-1;
        $fclose(outfile);
      end
   end

//      Ibr
   Ibr = I_C /  ( m_soa * area / 1e-06 ) ;
   if((Ibr_cnt>0) || ( maxEv_flg==0 ))   begin
      if( (Ibr < -0.5) && (Ibr_retc!=-1))
      begin
        outfile=$fopen(errFileName,"a");
        $strobe("dnpati        Ibr     leaving   OCA (  .. -0.500 uA/um ) at %7.4r  %M", $abstime );
        $fwrite(outfile,"dnpati        Ibr     leaving   OCA (  .. -0.500 uA/um ) at %7.4r  %M\n", $abstime );
        Ibr_retc=-1;
        Ibr_cnt=Ibr_cnt-1;
        $fclose(outfile);
      end
      if((Ibr >= -0.5) &&  (Ibr <= 0.5) && (Ibr_retc!=0))
      begin
        outfile=$fopen(errFileName,"a");
        $strobe("dnpati        Ibr     entering SOCA ( -0.500 uA/um .. 0.500 uA/um ) at %7.4r  %M", $abstime );
        $fwrite(outfile,"dnpati        Ibr     entering SOCA ( -0.500 uA/um .. 0.500 uA/um ) at %7.4r  %M\n", $abstime );
        Ibr_retc=0;
        Ibr_cnt=Ibr_cnt-1;
        $fclose(outfile);
      end
      if((Ibr > 0.5) &&  (Ibr_retc!=1))
      begin
        outfile=$fopen(errFileName,"a");
        $strobe("dnpati        Ibr     leaving   OCA ( 0.500 uA/um ..  ) at %7.4r  %M", $abstime );
        $fwrite(outfile,"dnpati        Ibr     leaving   OCA ( 0.500 uA/um ..  ) at %7.4r  %M\n", $abstime );
        Ibr_retc=1;
        Ibr_cnt=Ibr_cnt-1;
        $fclose(outfile);
      end
   end
   else
   begin
      if(Ibr_cnt==0)
      begin
        outfile=$fopen(errFileName,"a");
        $strobe("dnpati        Ibr     error limit ( %d ) reached at %7.4r  %M", maxEv, $abstime );
        $fwrite(outfile,"dnpati        Ibr     error limit ( %d ) reached at %7.4r  %M\n", maxEv, $abstime );
        Ibr_cnt=Ibr_cnt-1;
        $fclose(outfile);
      end
   end

//      Ibr1000
   Ibr1000 = I_C /  ( m_soa * area / 1e-06 ) ;
   if((Ibr1000_cnt>0) || ( maxEv_flg==0 ))   begin
      if( (Ibr1000 < -5) && (Ibr1000_retc!=-1))
      begin
        outfile=$fopen(errFileName,"a");
        $strobe("dnpati        Ibr1000 leaving   OCA (  .. -5.000 uA/um ) at %7.4r  %M", $abstime );
        $fwrite(outfile,"dnpati        Ibr1000 leaving   OCA (  .. -5.000 uA/um ) at %7.4r  %M\n", $abstime );
        Ibr1000_retc=-1;
        Ibr1000_cnt=Ibr1000_cnt-1;
        $fclose(outfile);
      end
      if((Ibr1000 >= -5) &&  (Ibr1000 <= 5) && (Ibr1000_retc!=0))
      begin
        outfile=$fopen(errFileName,"a");
        $strobe("dnpati        Ibr1000 entering SOCA ( -5.000 uA/um .. 5.000 uA/um ) at %7.4r  %M", $abstime );
        $fwrite(outfile,"dnpati        Ibr1000 entering SOCA ( -5.000 uA/um .. 5.000 uA/um ) at %7.4r  %M\n", $abstime );
        Ibr1000_retc=0;
        Ibr1000_cnt=Ibr1000_cnt-1;
        $fclose(outfile);
      end
      if((Ibr1000 > 5) &&  (Ibr1000_retc!=1))
      begin
        outfile=$fopen(errFileName,"a");
        $strobe("dnpati        Ibr1000 leaving   OCA ( 5.000 uA/um ..  ) at %7.4r  %M", $abstime );
        $fwrite(outfile,"dnpati        Ibr1000 leaving   OCA ( 5.000 uA/um ..  ) at %7.4r  %M\n", $abstime );
        Ibr1000_retc=1;
        Ibr1000_cnt=Ibr1000_cnt-1;
        $fclose(outfile);
      end
   end
   else
   begin
      if(Ibr1000_cnt==0)
      begin
        outfile=$fopen(errFileName,"a");
        $strobe("dnpati        Ibr1000 error limit ( %d ) reached at %7.4r  %M", maxEv, $abstime );
        $fwrite(outfile,"dnpati        Ibr1000 error limit ( %d ) reached at %7.4r  %M\n", maxEv, $abstime );
        Ibr1000_cnt=Ibr1000_cnt-1;
        $fclose(outfile);
      end
   end

end // analog
endmodule // dnpati

// Verilog-A OC Watch for device dza Parameters  VAC Ibr Ibr1000
module dza_ahdl(A1,C1,A,C);
parameter tstep_occ=100n;
parameter errFileName="./occ.err";
parameter area = 1u;
parameter m_soa = 1;
parameter maxEv = 25;
parameter maxEv_flg = 0;
inout A1,C1,A,C;
electrical A1,C1,A,C;

integer outfile;
real V_A_C;
real I_C;
real I_A;
real VAC;
integer VAC_retc;
integer VAC_cnt;
real Ibr;
integer Ibr_retc;
integer Ibr_cnt;
real Ibr1000;
integer Ibr1000_retc;
integer Ibr1000_cnt;

analog begin
   $bound_step( tstep_occ );
   @(initial_step) begin
      VAC_retc=0;
      VAC_cnt = maxEv;
      Ibr_retc=0;
      Ibr_cnt = maxEv;
      Ibr1000_retc=0;
      Ibr1000_cnt = maxEv;
   end
   V_A_C = V(A,C);
   I_C = I(C1,C);
   I_A = I(A1,A);

//      VAC
   VAC = V_A_C;
   if((VAC_cnt>0) || ( maxEv_flg==0 ))   begin
      if( (VAC < -6.3) && (VAC_retc!=-1))
      begin
        outfile=$fopen(errFileName,"a");
        $strobe("dza           VAC     leaving   OCA (  .. -6.300 V ) at %7.4r  %M", $abstime );
        $fwrite(outfile,"dza           VAC     leaving   OCA (  .. -6.300 V ) at %7.4r  %M\n", $abstime );
        VAC_retc=-1;
        VAC_cnt=VAC_cnt-1;
        $fclose(outfile);
      end
      if((VAC >= -6.3) &&  (VAC <= 0.1) && (VAC_retc!=0))
      begin
        outfile=$fopen(errFileName,"a");
        $strobe("dza           VAC     entering SOCA ( -6.300 V .. 0.100 V ) at %7.4r  %M", $abstime );
        $fwrite(outfile,"dza           VAC     entering SOCA ( -6.300 V .. 0.100 V ) at %7.4r  %M\n", $abstime );
        VAC_retc=0;
        VAC_cnt=VAC_cnt-1;
        $fclose(outfile);
      end
      if((VAC > 0.1) &&  (VAC_retc!=1))
      begin
        outfile=$fopen(errFileName,"a");
        $strobe("dza           VAC     leaving   OCA ( 0.100 V ..  ) at %7.4r  %M", $abstime );
        $fwrite(outfile,"dza           VAC     leaving   OCA ( 0.100 V ..  ) at %7.4r  %M\n", $abstime );
        VAC_retc=1;
        VAC_cnt=VAC_cnt-1;
        $fclose(outfile);
      end
   end
   else
   begin
      if(VAC_cnt==0)
      begin
        outfile=$fopen(errFileName,"a");
        $strobe("dza           VAC     error limit ( %d ) reached at %7.4r  %M", maxEv, $abstime );
        $fwrite(outfile,"dza           VAC     error limit ( %d ) reached at %7.4r  %M\n", maxEv, $abstime );
        VAC_cnt=VAC_cnt-1;
        $fclose(outfile);
      end
   end

//      Ibr
   Ibr = I_C /  ( m_soa * area / 1e-06 ) ;
   if((Ibr_cnt>0) || ( maxEv_flg==0 ))   begin
      if( (Ibr < -10) && (Ibr_retc!=-1))
      begin
        outfile=$fopen(errFileName,"a");
        $strobe("dza           Ibr     leaving   OCA (  .. -10.000 uA/um ) at %7.4r  %M", $abstime );
        $fwrite(outfile,"dza           Ibr     leaving   OCA (  .. -10.000 uA/um ) at %7.4r  %M\n", $abstime );
        Ibr_retc=-1;
        Ibr_cnt=Ibr_cnt-1;
        $fclose(outfile);
      end
      if((Ibr >= -10) &&  (Ibr <= 10) && (Ibr_retc!=0))
      begin
        outfile=$fopen(errFileName,"a");
        $strobe("dza           Ibr     entering SOCA ( -10.000 uA/um .. 10.000 uA/um ) at %7.4r  %M", $abstime );
        $fwrite(outfile,"dza           Ibr     entering SOCA ( -10.000 uA/um .. 10.000 uA/um ) at %7.4r  %M\n", $abstime );
        Ibr_retc=0;
        Ibr_cnt=Ibr_cnt-1;
        $fclose(outfile);
      end
      if((Ibr > 10) &&  (Ibr_retc!=1))
      begin
        outfile=$fopen(errFileName,"a");
        $strobe("dza           Ibr     leaving   OCA ( 10.000 uA/um ..  ) at %7.4r  %M", $abstime );
        $fwrite(outfile,"dza           Ibr     leaving   OCA ( 10.000 uA/um ..  ) at %7.4r  %M\n", $abstime );
        Ibr_retc=1;
        Ibr_cnt=Ibr_cnt-1;
        $fclose(outfile);
      end
   end
   else
   begin
      if(Ibr_cnt==0)
      begin
        outfile=$fopen(errFileName,"a");
        $strobe("dza           Ibr     error limit ( %d ) reached at %7.4r  %M", maxEv, $abstime );
        $fwrite(outfile,"dza           Ibr     error limit ( %d ) reached at %7.4r  %M\n", maxEv, $abstime );
        Ibr_cnt=Ibr_cnt-1;
        $fclose(outfile);
      end
   end

//      Ibr1000
   Ibr1000 = I_C /  ( m_soa * area / 1e-06 ) ;
   if((Ibr1000_cnt>0) || ( maxEv_flg==0 ))   begin
      if( (Ibr1000 < -100) && (Ibr1000_retc!=-1))
      begin
        outfile=$fopen(errFileName,"a");
        $strobe("dza           Ibr1000 leaving   OCA (  .. -100.000 uA/um ) at %7.4r  %M", $abstime );
        $fwrite(outfile,"dza           Ibr1000 leaving   OCA (  .. -100.000 uA/um ) at %7.4r  %M\n", $abstime );
        Ibr1000_retc=-1;
        Ibr1000_cnt=Ibr1000_cnt-1;
        $fclose(outfile);
      end
      if((Ibr1000 >= -100) &&  (Ibr1000 <= 100) && (Ibr1000_retc!=0))
      begin
        outfile=$fopen(errFileName,"a");
        $strobe("dza           Ibr1000 entering SOCA ( -100.000 uA/um .. 100.000 uA/um ) at %7.4r  %M", $abstime );
        $fwrite(outfile,"dza           Ibr1000 entering SOCA ( -100.000 uA/um .. 100.000 uA/um ) at %7.4r  %M\n", $abstime );
        Ibr1000_retc=0;
        Ibr1000_cnt=Ibr1000_cnt-1;
        $fclose(outfile);
      end
      if((Ibr1000 > 100) &&  (Ibr1000_retc!=1))
      begin
        outfile=$fopen(errFileName,"a");
        $strobe("dza           Ibr1000 leaving   OCA ( 100.000 uA/um ..  ) at %7.4r  %M", $abstime );
        $fwrite(outfile,"dza           Ibr1000 leaving   OCA ( 100.000 uA/um ..  ) at %7.4r  %M\n", $abstime );
        Ibr1000_retc=1;
        Ibr1000_cnt=Ibr1000_cnt-1;
        $fclose(outfile);
      end
   end
   else
   begin
      if(Ibr1000_cnt==0)
      begin
        outfile=$fopen(errFileName,"a");
        $strobe("dza           Ibr1000 error limit ( %d ) reached at %7.4r  %M", maxEv, $abstime );
        $fwrite(outfile,"dza           Ibr1000 error limit ( %d ) reached at %7.4r  %M\n", maxEv, $abstime );
        Ibr1000_cnt=Ibr1000_cnt-1;
        $fclose(outfile);
      end
   end

end // analog
endmodule // dza

// Verilog-A OC Watch for device dzati Parameters  VAC Ibr Ibr1000
module dzati_ahdl(A1,C1,A,C);
parameter tstep_occ=100n;
parameter errFileName="./occ.err";
parameter area = 1u;
parameter m_soa = 1;
parameter maxEv = 25;
parameter maxEv_flg = 0;
inout A1,C1,A,C;
electrical A1,C1,A,C;

integer outfile;
real V_A_C;
real I_C;
real I_A;
real VAC;
integer VAC_retc;
integer VAC_cnt;
real Ibr;
integer Ibr_retc;
integer Ibr_cnt;
real Ibr1000;
integer Ibr1000_retc;
integer Ibr1000_cnt;

analog begin
   $bound_step( tstep_occ );
   @(initial_step) begin
      VAC_retc=0;
      VAC_cnt = maxEv;
      Ibr_retc=0;
      Ibr_cnt = maxEv;
      Ibr1000_retc=0;
      Ibr1000_cnt = maxEv;
   end
   V_A_C = V(A,C);
   I_C = I(C1,C);
   I_A = I(A1,A);

//      VAC
   VAC = V_A_C;
   if((VAC_cnt>0) || ( maxEv_flg==0 ))   begin
      if( (VAC < -6) && (VAC_retc!=-1))
      begin
        outfile=$fopen(errFileName,"a");
        $strobe("dzati         VAC     leaving   OCA (  .. -6.000 V ) at %7.4r  %M", $abstime );
        $fwrite(outfile,"dzati         VAC     leaving   OCA (  .. -6.000 V ) at %7.4r  %M\n", $abstime );
        VAC_retc=-1;
        VAC_cnt=VAC_cnt-1;
        $fclose(outfile);
      end
      if((VAC >= -6) &&  (VAC <= 1.5) && (VAC_retc!=0))
      begin
        outfile=$fopen(errFileName,"a");
        $strobe("dzati         VAC     entering SOCA ( -6.000 V .. 1.500 V ) at %7.4r  %M", $abstime );
        $fwrite(outfile,"dzati         VAC     entering SOCA ( -6.000 V .. 1.500 V ) at %7.4r  %M\n", $abstime );
        VAC_retc=0;
        VAC_cnt=VAC_cnt-1;
        $fclose(outfile);
      end
      if((VAC > 1.5) &&  (VAC_retc!=1))
      begin
        outfile=$fopen(errFileName,"a");
        $strobe("dzati         VAC     leaving   OCA ( 1.500 V ..  ) at %7.4r  %M", $abstime );
        $fwrite(outfile,"dzati         VAC     leaving   OCA ( 1.500 V ..  ) at %7.4r  %M\n", $abstime );
        VAC_retc=1;
        VAC_cnt=VAC_cnt-1;
        $fclose(outfile);
      end
   end
   else
   begin
      if(VAC_cnt==0)
      begin
        outfile=$fopen(errFileName,"a");
        $strobe("dzati         VAC     error limit ( %d ) reached at %7.4r  %M", maxEv, $abstime );
        $fwrite(outfile,"dzati         VAC     error limit ( %d ) reached at %7.4r  %M\n", maxEv, $abstime );
        VAC_cnt=VAC_cnt-1;
        $fclose(outfile);
      end
   end

//      Ibr
   Ibr = I_C /  ( m_soa * area / 1e-06 ) ;
   if((Ibr_cnt>0) || ( maxEv_flg==0 ))   begin
      if( (Ibr < -10) && (Ibr_retc!=-1))
      begin
        outfile=$fopen(errFileName,"a");
        $strobe("dzati         Ibr     leaving   OCA (  .. -10.000 uA/um ) at %7.4r  %M", $abstime );
        $fwrite(outfile,"dzati         Ibr     leaving   OCA (  .. -10.000 uA/um ) at %7.4r  %M\n", $abstime );
        Ibr_retc=-1;
        Ibr_cnt=Ibr_cnt-1;
        $fclose(outfile);
      end
      if((Ibr >= -10) &&  (Ibr <= 10) && (Ibr_retc!=0))
      begin
        outfile=$fopen(errFileName,"a");
        $strobe("dzati         Ibr     entering SOCA ( -10.000 uA/um .. 10.000 uA/um ) at %7.4r  %M", $abstime );
        $fwrite(outfile,"dzati         Ibr     entering SOCA ( -10.000 uA/um .. 10.000 uA/um ) at %7.4r  %M\n", $abstime );
        Ibr_retc=0;
        Ibr_cnt=Ibr_cnt-1;
        $fclose(outfile);
      end
      if((Ibr > 10) &&  (Ibr_retc!=1))
      begin
        outfile=$fopen(errFileName,"a");
        $strobe("dzati         Ibr     leaving   OCA ( 10.000 uA/um ..  ) at %7.4r  %M", $abstime );
        $fwrite(outfile,"dzati         Ibr     leaving   OCA ( 10.000 uA/um ..  ) at %7.4r  %M\n", $abstime );
        Ibr_retc=1;
        Ibr_cnt=Ibr_cnt-1;
        $fclose(outfile);
      end
   end
   else
   begin
      if(Ibr_cnt==0)
      begin
        outfile=$fopen(errFileName,"a");
        $strobe("dzati         Ibr     error limit ( %d ) reached at %7.4r  %M", maxEv, $abstime );
        $fwrite(outfile,"dzati         Ibr     error limit ( %d ) reached at %7.4r  %M\n", maxEv, $abstime );
        Ibr_cnt=Ibr_cnt-1;
        $fclose(outfile);
      end
   end

//      Ibr1000
   Ibr1000 = I_C /  ( m_soa * area / 1e-06 ) ;
   if((Ibr1000_cnt>0) || ( maxEv_flg==0 ))   begin
      if( (Ibr1000 < -100) && (Ibr1000_retc!=-1))
      begin
        outfile=$fopen(errFileName,"a");
        $strobe("dzati         Ibr1000 leaving   OCA (  .. -100.000 uA/um ) at %7.4r  %M", $abstime );
        $fwrite(outfile,"dzati         Ibr1000 leaving   OCA (  .. -100.000 uA/um ) at %7.4r  %M\n", $abstime );
        Ibr1000_retc=-1;
        Ibr1000_cnt=Ibr1000_cnt-1;
        $fclose(outfile);
      end
      if((Ibr1000 >= -100) &&  (Ibr1000 <= 100) && (Ibr1000_retc!=0))
      begin
        outfile=$fopen(errFileName,"a");
        $strobe("dzati         Ibr1000 entering SOCA ( -100.000 uA/um .. 100.000 uA/um ) at %7.4r  %M", $abstime );
        $fwrite(outfile,"dzati         Ibr1000 entering SOCA ( -100.000 uA/um .. 100.000 uA/um ) at %7.4r  %M\n", $abstime );
        Ibr1000_retc=0;
        Ibr1000_cnt=Ibr1000_cnt-1;
        $fclose(outfile);
      end
      if((Ibr1000 > 100) &&  (Ibr1000_retc!=1))
      begin
        outfile=$fopen(errFileName,"a");
        $strobe("dzati         Ibr1000 leaving   OCA ( 100.000 uA/um ..  ) at %7.4r  %M", $abstime );
        $fwrite(outfile,"dzati         Ibr1000 leaving   OCA ( 100.000 uA/um ..  ) at %7.4r  %M\n", $abstime );
        Ibr1000_retc=1;
        Ibr1000_cnt=Ibr1000_cnt-1;
        $fclose(outfile);
      end
   end
   else
   begin
      if(Ibr1000_cnt==0)
      begin
        outfile=$fopen(errFileName,"a");
        $strobe("dzati         Ibr1000 error limit ( %d ) reached at %7.4r  %M", maxEv, $abstime );
        $fwrite(outfile,"dzati         Ibr1000 error limit ( %d ) reached at %7.4r  %M\n", maxEv, $abstime );
        Ibr1000_cnt=Ibr1000_cnt-1;
        $fclose(outfile);
      end
   end

end // analog
endmodule // dzati

// Verilog-A OC Watch for device dzcti Parameters  VAC Ibr Ibr1000
module dzcti_ahdl(A1,C1,A,C);
parameter tstep_occ=100n;
parameter errFileName="./occ.err";
parameter area = 1u;
parameter m_soa = 1;
parameter maxEv = 25;
parameter maxEv_flg = 0;
inout A1,C1,A,C;
electrical A1,C1,A,C;

integer outfile;
real V_A_C;
real I_C;
real I_A;
real VAC;
integer VAC_retc;
integer VAC_cnt;
real Ibr;
integer Ibr_retc;
integer Ibr_cnt;
real Ibr1000;
integer Ibr1000_retc;
integer Ibr1000_cnt;

analog begin
   $bound_step( tstep_occ );
   @(initial_step) begin
      VAC_retc=0;
      VAC_cnt = maxEv;
      Ibr_retc=0;
      Ibr_cnt = maxEv;
      Ibr1000_retc=0;
      Ibr1000_cnt = maxEv;
   end
   V_A_C = V(A,C);
   I_C = I(C1,C);
   I_A = I(A1,A);

//      VAC
   VAC = V_A_C;
   if((VAC_cnt>0) || ( maxEv_flg==0 ))   begin
      if( (VAC < -6) && (VAC_retc!=-1))
      begin
        outfile=$fopen(errFileName,"a");
        $strobe("dzcti         VAC     leaving   OCA (  .. -6.000 V ) at %7.4r  %M", $abstime );
        $fwrite(outfile,"dzcti         VAC     leaving   OCA (  .. -6.000 V ) at %7.4r  %M\n", $abstime );
        VAC_retc=-1;
        VAC_cnt=VAC_cnt-1;
        $fclose(outfile);
      end
      if((VAC >= -6) &&  (VAC <= 1.5) && (VAC_retc!=0))
      begin
        outfile=$fopen(errFileName,"a");
        $strobe("dzcti         VAC     entering SOCA ( -6.000 V .. 1.500 V ) at %7.4r  %M", $abstime );
        $fwrite(outfile,"dzcti         VAC     entering SOCA ( -6.000 V .. 1.500 V ) at %7.4r  %M\n", $abstime );
        VAC_retc=0;
        VAC_cnt=VAC_cnt-1;
        $fclose(outfile);
      end
      if((VAC > 1.5) &&  (VAC_retc!=1))
      begin
        outfile=$fopen(errFileName,"a");
        $strobe("dzcti         VAC     leaving   OCA ( 1.500 V ..  ) at %7.4r  %M", $abstime );
        $fwrite(outfile,"dzcti         VAC     leaving   OCA ( 1.500 V ..  ) at %7.4r  %M\n", $abstime );
        VAC_retc=1;
        VAC_cnt=VAC_cnt-1;
        $fclose(outfile);
      end
   end
   else
   begin
      if(VAC_cnt==0)
      begin
        outfile=$fopen(errFileName,"a");
        $strobe("dzcti         VAC     error limit ( %d ) reached at %7.4r  %M", maxEv, $abstime );
        $fwrite(outfile,"dzcti         VAC     error limit ( %d ) reached at %7.4r  %M\n", maxEv, $abstime );
        VAC_cnt=VAC_cnt-1;
        $fclose(outfile);
      end
   end

//      Ibr
   Ibr = I_C /  ( m_soa * area / 1e-06 ) ;
   if((Ibr_cnt>0) || ( maxEv_flg==0 ))   begin
      if( (Ibr < -10) && (Ibr_retc!=-1))
      begin
        outfile=$fopen(errFileName,"a");
        $strobe("dzcti         Ibr     leaving   OCA (  .. -10.000 uA/um ) at %7.4r  %M", $abstime );
        $fwrite(outfile,"dzcti         Ibr     leaving   OCA (  .. -10.000 uA/um ) at %7.4r  %M\n", $abstime );
        Ibr_retc=-1;
        Ibr_cnt=Ibr_cnt-1;
        $fclose(outfile);
      end
      if((Ibr >= -10) &&  (Ibr <= 10) && (Ibr_retc!=0))
      begin
        outfile=$fopen(errFileName,"a");
        $strobe("dzcti         Ibr     entering SOCA ( -10.000 uA/um .. 10.000 uA/um ) at %7.4r  %M", $abstime );
        $fwrite(outfile,"dzcti         Ibr     entering SOCA ( -10.000 uA/um .. 10.000 uA/um ) at %7.4r  %M\n", $abstime );
        Ibr_retc=0;
        Ibr_cnt=Ibr_cnt-1;
        $fclose(outfile);
      end
      if((Ibr > 10) &&  (Ibr_retc!=1))
      begin
        outfile=$fopen(errFileName,"a");
        $strobe("dzcti         Ibr     leaving   OCA ( 10.000 uA/um ..  ) at %7.4r  %M", $abstime );
        $fwrite(outfile,"dzcti         Ibr     leaving   OCA ( 10.000 uA/um ..  ) at %7.4r  %M\n", $abstime );
        Ibr_retc=1;
        Ibr_cnt=Ibr_cnt-1;
        $fclose(outfile);
      end
   end
   else
   begin
      if(Ibr_cnt==0)
      begin
        outfile=$fopen(errFileName,"a");
        $strobe("dzcti         Ibr     error limit ( %d ) reached at %7.4r  %M", maxEv, $abstime );
        $fwrite(outfile,"dzcti         Ibr     error limit ( %d ) reached at %7.4r  %M\n", maxEv, $abstime );
        Ibr_cnt=Ibr_cnt-1;
        $fclose(outfile);
      end
   end

//      Ibr1000
   Ibr1000 = I_C /  ( m_soa * area / 1e-06 ) ;
   if((Ibr1000_cnt>0) || ( maxEv_flg==0 ))   begin
      if( (Ibr1000 < -100) && (Ibr1000_retc!=-1))
      begin
        outfile=$fopen(errFileName,"a");
        $strobe("dzcti         Ibr1000 leaving   OCA (  .. -100.000 uA/um ) at %7.4r  %M", $abstime );
        $fwrite(outfile,"dzcti         Ibr1000 leaving   OCA (  .. -100.000 uA/um ) at %7.4r  %M\n", $abstime );
        Ibr1000_retc=-1;
        Ibr1000_cnt=Ibr1000_cnt-1;
        $fclose(outfile);
      end
      if((Ibr1000 >= -100) &&  (Ibr1000 <= 100) && (Ibr1000_retc!=0))
      begin
        outfile=$fopen(errFileName,"a");
        $strobe("dzcti         Ibr1000 entering SOCA ( -100.000 uA/um .. 100.000 uA/um ) at %7.4r  %M", $abstime );
        $fwrite(outfile,"dzcti         Ibr1000 entering SOCA ( -100.000 uA/um .. 100.000 uA/um ) at %7.4r  %M\n", $abstime );
        Ibr1000_retc=0;
        Ibr1000_cnt=Ibr1000_cnt-1;
        $fclose(outfile);
      end
      if((Ibr1000 > 100) &&  (Ibr1000_retc!=1))
      begin
        outfile=$fopen(errFileName,"a");
        $strobe("dzcti         Ibr1000 leaving   OCA ( 100.000 uA/um ..  ) at %7.4r  %M", $abstime );
        $fwrite(outfile,"dzcti         Ibr1000 leaving   OCA ( 100.000 uA/um ..  ) at %7.4r  %M\n", $abstime );
        Ibr1000_retc=1;
        Ibr1000_cnt=Ibr1000_cnt-1;
        $fclose(outfile);
      end
   end
   else
   begin
      if(Ibr1000_cnt==0)
      begin
        outfile=$fopen(errFileName,"a");
        $strobe("dzcti         Ibr1000 error limit ( %d ) reached at %7.4r  %M", maxEv, $abstime );
        $fwrite(outfile,"dzcti         Ibr1000 error limit ( %d ) reached at %7.4r  %M\n", maxEv, $abstime );
        Ibr1000_cnt=Ibr1000_cnt-1;
        $fclose(outfile);
      end
   end

end // analog
endmodule // dzcti

// Verilog-A OC Watch for device dzbti Parameters  VAC VCS Ibr Ibr1000
module dzbti_ahdl(A1,C1,SUB1,A,C,SUB);
parameter tstep_occ=100n;
parameter errFileName="./occ.err";
parameter area = 1u;
parameter m_soa = 1;
parameter maxEv = 25;
parameter maxEv_flg = 0;
inout A1,C1,SUB1,A,C,SUB;
electrical A1,C1,SUB1,A,C,SUB;

integer outfile;
real V_C_SUB;
real V_A_C;
real I_SUB;
real I_C;
real I_A;
real VAC;
integer VAC_retc;
integer VAC_cnt;
real VCS;
integer VCS_retc;
integer VCS_cnt;
real Ibr;
integer Ibr_retc;
integer Ibr_cnt;
real Ibr1000;
integer Ibr1000_retc;
integer Ibr1000_cnt;

analog begin
   $bound_step( tstep_occ );
   @(initial_step) begin
      VAC_retc=0;
      VAC_cnt = maxEv;
      VCS_retc=0;
      VCS_cnt = maxEv;
      Ibr_retc=0;
      Ibr_cnt = maxEv;
      Ibr1000_retc=0;
      Ibr1000_cnt = maxEv;
   end
   V_C_SUB = V(C,SUB);
   V_A_C = V(A,C);
   I_SUB = I(SUB1,SUB);
   I_C = I(C1,C);
   I_A = I(A1,A);

//      VAC
   VAC = V_A_C;
   if((VAC_cnt>0) || ( maxEv_flg==0 ))   begin
      if( (VAC < -6.3) && (VAC_retc!=-1))
      begin
        outfile=$fopen(errFileName,"a");
        $strobe("dzbti         VAC     leaving   OCA (  .. -6.300 V ) at %7.4r  %M", $abstime );
        $fwrite(outfile,"dzbti         VAC     leaving   OCA (  .. -6.300 V ) at %7.4r  %M\n", $abstime );
        VAC_retc=-1;
        VAC_cnt=VAC_cnt-1;
        $fclose(outfile);
      end
      if((VAC >= -6.3) &&  (VAC <= 0.1) && (VAC_retc!=0))
      begin
        outfile=$fopen(errFileName,"a");
        $strobe("dzbti         VAC     entering SOCA ( -6.300 V .. 0.100 V ) at %7.4r  %M", $abstime );
        $fwrite(outfile,"dzbti         VAC     entering SOCA ( -6.300 V .. 0.100 V ) at %7.4r  %M\n", $abstime );
        VAC_retc=0;
        VAC_cnt=VAC_cnt-1;
        $fclose(outfile);
      end
      if((VAC > 0.1) &&  (VAC_retc!=1))
      begin
        outfile=$fopen(errFileName,"a");
        $strobe("dzbti         VAC     leaving   OCA ( 0.100 V ..  ) at %7.4r  %M", $abstime );
        $fwrite(outfile,"dzbti         VAC     leaving   OCA ( 0.100 V ..  ) at %7.4r  %M\n", $abstime );
        VAC_retc=1;
        VAC_cnt=VAC_cnt-1;
        $fclose(outfile);
      end
   end
   else
   begin
      if(VAC_cnt==0)
      begin
        outfile=$fopen(errFileName,"a");
        $strobe("dzbti         VAC     error limit ( %d ) reached at %7.4r  %M", maxEv, $abstime );
        $fwrite(outfile,"dzbti         VAC     error limit ( %d ) reached at %7.4r  %M\n", maxEv, $abstime );
        VAC_cnt=VAC_cnt-1;
        $fclose(outfile);
      end
   end

//      VCS
   VCS = V_C_SUB;
   if((VCS_cnt>0) || ( maxEv_flg==0 ))   begin
      if( (VCS < -0.1) && (VCS_retc!=-1))
      begin
        outfile=$fopen(errFileName,"a");
        $strobe("dzbti         VCS     leaving   OCA (  .. -0.100 V ) at %7.4r  %M", $abstime );
        $fwrite(outfile,"dzbti         VCS     leaving   OCA (  .. -0.100 V ) at %7.4r  %M\n", $abstime );
        VCS_retc=-1;
        VCS_cnt=VCS_cnt-1;
        $fclose(outfile);
      end
      if((VCS >= -0.1) &&  (VCS <= 5.5) && (VCS_retc!=0))
      begin
        outfile=$fopen(errFileName,"a");
        $strobe("dzbti         VCS     entering SOCA ( -0.100 V .. 5.500 V ) at %7.4r  %M", $abstime );
        $fwrite(outfile,"dzbti         VCS     entering SOCA ( -0.100 V .. 5.500 V ) at %7.4r  %M\n", $abstime );
        VCS_retc=0;
        VCS_cnt=VCS_cnt-1;
        $fclose(outfile);
      end
      if((VCS > 5.5) &&  (VCS_retc!=1))
      begin
        outfile=$fopen(errFileName,"a");
        $strobe("dzbti         VCS     leaving   OCA ( 5.500 V ..  ) at %7.4r  %M", $abstime );
        $fwrite(outfile,"dzbti         VCS     leaving   OCA ( 5.500 V ..  ) at %7.4r  %M\n", $abstime );
        VCS_retc=1;
        VCS_cnt=VCS_cnt-1;
        $fclose(outfile);
      end
   end
   else
   begin
      if(VCS_cnt==0)
      begin
        outfile=$fopen(errFileName,"a");
        $strobe("dzbti         VCS     error limit ( %d ) reached at %7.4r  %M", maxEv, $abstime );
        $fwrite(outfile,"dzbti         VCS     error limit ( %d ) reached at %7.4r  %M\n", maxEv, $abstime );
        VCS_cnt=VCS_cnt-1;
        $fclose(outfile);
      end
   end

//      Ibr
   Ibr = I_C /  ( m_soa * area / 1.16e-06 ) ;
   if((Ibr_cnt>0) || ( maxEv_flg==0 ))   begin
      if( (Ibr < -10) && (Ibr_retc!=-1))
      begin
        outfile=$fopen(errFileName,"a");
        $strobe("dzbti         Ibr     leaving   OCA (  .. -10.000 uA/um ) at %7.4r  %M", $abstime );
        $fwrite(outfile,"dzbti         Ibr     leaving   OCA (  .. -10.000 uA/um ) at %7.4r  %M\n", $abstime );
        Ibr_retc=-1;
        Ibr_cnt=Ibr_cnt-1;
        $fclose(outfile);
      end
      if((Ibr >= -10) &&  (Ibr <= 10) && (Ibr_retc!=0))
      begin
        outfile=$fopen(errFileName,"a");
        $strobe("dzbti         Ibr     entering SOCA ( -10.000 uA/um .. 10.000 uA/um ) at %7.4r  %M", $abstime );
        $fwrite(outfile,"dzbti         Ibr     entering SOCA ( -10.000 uA/um .. 10.000 uA/um ) at %7.4r  %M\n", $abstime );
        Ibr_retc=0;
        Ibr_cnt=Ibr_cnt-1;
        $fclose(outfile);
      end
      if((Ibr > 10) &&  (Ibr_retc!=1))
      begin
        outfile=$fopen(errFileName,"a");
        $strobe("dzbti         Ibr     leaving   OCA ( 10.000 uA/um ..  ) at %7.4r  %M", $abstime );
        $fwrite(outfile,"dzbti         Ibr     leaving   OCA ( 10.000 uA/um ..  ) at %7.4r  %M\n", $abstime );
        Ibr_retc=1;
        Ibr_cnt=Ibr_cnt-1;
        $fclose(outfile);
      end
   end
   else
   begin
      if(Ibr_cnt==0)
      begin
        outfile=$fopen(errFileName,"a");
        $strobe("dzbti         Ibr     error limit ( %d ) reached at %7.4r  %M", maxEv, $abstime );
        $fwrite(outfile,"dzbti         Ibr     error limit ( %d ) reached at %7.4r  %M\n", maxEv, $abstime );
        Ibr_cnt=Ibr_cnt-1;
        $fclose(outfile);
      end
   end

//      Ibr1000
   Ibr1000 = I_C /  ( m_soa * area / 1.16e-06 ) ;
   if((Ibr1000_cnt>0) || ( maxEv_flg==0 ))   begin
      if( (Ibr1000 < -100) && (Ibr1000_retc!=-1))
      begin
        outfile=$fopen(errFileName,"a");
        $strobe("dzbti         Ibr1000 leaving   OCA (  .. -100.000 uA/um ) at %7.4r  %M", $abstime );
        $fwrite(outfile,"dzbti         Ibr1000 leaving   OCA (  .. -100.000 uA/um ) at %7.4r  %M\n", $abstime );
        Ibr1000_retc=-1;
        Ibr1000_cnt=Ibr1000_cnt-1;
        $fclose(outfile);
      end
      if((Ibr1000 >= -100) &&  (Ibr1000 <= 100) && (Ibr1000_retc!=0))
      begin
        outfile=$fopen(errFileName,"a");
        $strobe("dzbti         Ibr1000 entering SOCA ( -100.000 uA/um .. 100.000 uA/um ) at %7.4r  %M", $abstime );
        $fwrite(outfile,"dzbti         Ibr1000 entering SOCA ( -100.000 uA/um .. 100.000 uA/um ) at %7.4r  %M\n", $abstime );
        Ibr1000_retc=0;
        Ibr1000_cnt=Ibr1000_cnt-1;
        $fclose(outfile);
      end
      if((Ibr1000 > 100) &&  (Ibr1000_retc!=1))
      begin
        outfile=$fopen(errFileName,"a");
        $strobe("dzbti         Ibr1000 leaving   OCA ( 100.000 uA/um ..  ) at %7.4r  %M", $abstime );
        $fwrite(outfile,"dzbti         Ibr1000 leaving   OCA ( 100.000 uA/um ..  ) at %7.4r  %M\n", $abstime );
        Ibr1000_retc=1;
        Ibr1000_cnt=Ibr1000_cnt-1;
        $fclose(outfile);
      end
   end
   else
   begin
      if(Ibr1000_cnt==0)
      begin
        outfile=$fopen(errFileName,"a");
        $strobe("dzbti         Ibr1000 error limit ( %d ) reached at %7.4r  %M", maxEv, $abstime );
        $fwrite(outfile,"dzbti         Ibr1000 error limit ( %d ) reached at %7.4r  %M\n", maxEv, $abstime );
        Ibr1000_cnt=Ibr1000_cnt-1;
        $fclose(outfile);
      end
   end

end // analog
endmodule // dzbti

// Verilog-A OC Watch for device pfuse Parameters  VAB
module pfuse_ahdl(A,B);
parameter tstep_occ=100n;
parameter errFileName="./occ.err";
parameter prog = 1u;
parameter maxEv = 25;
parameter maxEv_flg = 0;
inout A,B;
electrical A,B;

integer outfile;
real V_A_B;
real VAB;
integer VAB_retc;
integer VAB_cnt;

analog begin
   $bound_step( tstep_occ );
   @(initial_step) begin
      VAB_retc=0;
      VAB_cnt = maxEv;
   end
   V_A_B = V(A,B);

//      VAB
   if(prog == 0)
   begin
      VAB = V_A_B;
      if((VAB_cnt>0) || ( maxEv_flg==0 ))      begin
         if( (VAB < -0.1) && (VAB_retc!=-1))
         begin
           outfile=$fopen(errFileName,"a");
           $strobe("pfuse         VAB     leaving   OCA (  .. -0.100 V ) at %7.4r  %M", $abstime );
           $fwrite(outfile,"pfuse         VAB     leaving   OCA (  .. -0.100 V ) at %7.4r  %M\n", $abstime );
           VAB_retc=-1;
           VAB_cnt=VAB_cnt-1;
           $fclose(outfile);
         end
         if((VAB >= -0.1) &&  (VAB <= 0.1) && (VAB_retc!=0))
         begin
           outfile=$fopen(errFileName,"a");
           $strobe("pfuse         VAB     entering SOCA ( -0.100 V .. 0.100 V ) at %7.4r  %M", $abstime );
           $fwrite(outfile,"pfuse         VAB     entering SOCA ( -0.100 V .. 0.100 V ) at %7.4r  %M\n", $abstime );
           VAB_retc=0;
           VAB_cnt=VAB_cnt-1;
           $fclose(outfile);
         end
         if((VAB > 0.1) &&  (VAB_retc!=1))
         begin
           outfile=$fopen(errFileName,"a");
           $strobe("pfuse         VAB     leaving   OCA ( 0.100 V ..  ) at %7.4r  %M", $abstime );
           $fwrite(outfile,"pfuse         VAB     leaving   OCA ( 0.100 V ..  ) at %7.4r  %M\n", $abstime );
           VAB_retc=1;
           VAB_cnt=VAB_cnt-1;
           $fclose(outfile);
         end
      end
      else
      begin
         if(VAB_cnt==0)
         begin
           outfile=$fopen(errFileName,"a");
           $strobe("pfuse         VAB     error limit ( %d ) reached at %7.4r  %M", maxEv, $abstime );
           $fwrite(outfile,"pfuse         VAB     error limit ( %d ) reached at %7.4r  %M\n", maxEv, $abstime );
           VAB_cnt=VAB_cnt-1;
           $fclose(outfile);
         end
      end
   end
   else
   begin
      VAB = V_A_B;
      if((VAB_cnt>0) || ( maxEv_flg==0 ))      begin
         if( (VAB < -3.6) && (VAB_retc!=-1))
         begin
           outfile=$fopen(errFileName,"a");
           $strobe("pfuse         VAB     leaving   OCA (  .. -3.600 V ) at %7.4r  %M", $abstime );
           $fwrite(outfile,"pfuse         VAB     leaving   OCA (  .. -3.600 V ) at %7.4r  %M\n", $abstime );
           VAB_retc=-1;
           VAB_cnt=VAB_cnt-1;
           $fclose(outfile);
         end
         if((VAB >= -3.6) &&  (VAB <= 3.6) && (VAB_retc!=0))
         begin
           outfile=$fopen(errFileName,"a");
           $strobe("pfuse         VAB     entering SOCA ( -3.600 V .. 3.600 V ) at %7.4r  %M", $abstime );
           $fwrite(outfile,"pfuse         VAB     entering SOCA ( -3.600 V .. 3.600 V ) at %7.4r  %M\n", $abstime );
           VAB_retc=0;
           VAB_cnt=VAB_cnt-1;
           $fclose(outfile);
         end
         if((VAB > 3.6) &&  (VAB_retc!=1))
         begin
           outfile=$fopen(errFileName,"a");
           $strobe("pfuse         VAB     leaving   OCA ( 3.600 V ..  ) at %7.4r  %M", $abstime );
           $fwrite(outfile,"pfuse         VAB     leaving   OCA ( 3.600 V ..  ) at %7.4r  %M\n", $abstime );
           VAB_retc=1;
           VAB_cnt=VAB_cnt-1;
           $fclose(outfile);
         end
      end
      else
      begin
         if(VAB_cnt==0)
         begin
           outfile=$fopen(errFileName,"a");
           $strobe("pfuse         VAB     error limit ( %d ) reached at %7.4r  %M", maxEv, $abstime );
           $fwrite(outfile,"pfuse         VAB     error limit ( %d ) reached at %7.4r  %M\n", maxEv, $abstime );
           VAB_cnt=VAB_cnt-1;
           $fclose(outfile);
         end
      end
   end

end // analog
endmodule // pfuse

// Verilog-A OC Watch for device nhsj1b_2 Parameters  VGS VGD VDS VDB VDHW
module nhsj1b_2_ahdl(D,G,S,B,HW);
parameter tstep_occ=100n;
parameter errFileName="./occ.err";
parameter maxEv = 25;
parameter maxEv_flg = 0;
inout D,G,S,B,HW;
electrical D,G,S,B,HW;

integer outfile;
real V_D_HW;
real V_D_B;
real V_D_S;
real V_G_D;
real V_G_S;
real VGS;
integer VGS_retc;
integer VGS_cnt;
real VGD;
integer VGD_retc;
integer VGD_cnt;
real VDS;
integer VDS_retc;
integer VDS_cnt;
real VDB;
integer VDB_retc;
integer VDB_cnt;
real VDHW;
integer VDHW_retc;
integer VDHW_cnt;

analog begin
   $bound_step( tstep_occ );
   @(initial_step) begin
      VGS_retc=0;
      VGS_cnt = maxEv;
      VGD_retc=0;
      VGD_cnt = maxEv;
      VDS_retc=0;
      VDS_cnt = maxEv;
      VDB_retc=0;
      VDB_cnt = maxEv;
      VDHW_retc=0;
      VDHW_cnt = maxEv;
   end
   V_D_HW = V(D,HW);
   V_D_B = V(D,B);
   V_D_S = V(D,S);
   V_G_D = V(G,D);
   V_G_S = V(G,S);

//      VGS
   VGS = V_G_S;
   if((VGS_cnt>0) || ( maxEv_flg==0 ))   begin
      if( (VGS < -5.5) && (VGS_retc!=-1))
      begin
        outfile=$fopen(errFileName,"a");
        $strobe("nhsj1b_2      VGS     leaving   OCA (  .. -5.500 V ) at %7.4r  %M", $abstime );
        $fwrite(outfile,"nhsj1b_2      VGS     leaving   OCA (  .. -5.500 V ) at %7.4r  %M\n", $abstime );
        VGS_retc=-1;
        VGS_cnt=VGS_cnt-1;
        $fclose(outfile);
      end
      if((VGS >= -5.5) &&  (VGS <= 5.5) && (VGS_retc!=0))
      begin
        outfile=$fopen(errFileName,"a");
        $strobe("nhsj1b_2      VGS     entering SOCA ( -5.500 V .. 5.500 V ) at %7.4r  %M", $abstime );
        $fwrite(outfile,"nhsj1b_2      VGS     entering SOCA ( -5.500 V .. 5.500 V ) at %7.4r  %M\n", $abstime );
        VGS_retc=0;
        VGS_cnt=VGS_cnt-1;
        $fclose(outfile);
      end
      if((VGS > 5.5) &&  (VGS_retc!=1))
      begin
        outfile=$fopen(errFileName,"a");
        $strobe("nhsj1b_2      VGS     leaving   OCA ( 5.500 V ..  ) at %7.4r  %M", $abstime );
        $fwrite(outfile,"nhsj1b_2      VGS     leaving   OCA ( 5.500 V ..  ) at %7.4r  %M\n", $abstime );
        VGS_retc=1;
        VGS_cnt=VGS_cnt-1;
        $fclose(outfile);
      end
   end
   else
   begin
      if(VGS_cnt==0)
      begin
        outfile=$fopen(errFileName,"a");
        $strobe("nhsj1b_2      VGS     error limit ( %d ) reached at %7.4r  %M", maxEv, $abstime );
        $fwrite(outfile,"nhsj1b_2      VGS     error limit ( %d ) reached at %7.4r  %M\n", maxEv, $abstime );
        VGS_cnt=VGS_cnt-1;
        $fclose(outfile);
      end
   end

//      VGD
   VGD = V_G_D;
   if((VGD_cnt>0) || ( maxEv_flg==0 ))   begin
      if( (VGD < -45) && (VGD_retc!=-1))
      begin
        outfile=$fopen(errFileName,"a");
        $strobe("nhsj1b_2      VGD     leaving   OCA (  .. -45.000 V ) at %7.4r  %M", $abstime );
        $fwrite(outfile,"nhsj1b_2      VGD     leaving   OCA (  .. -45.000 V ) at %7.4r  %M\n", $abstime );
        VGD_retc=-1;
        VGD_cnt=VGD_cnt-1;
        $fclose(outfile);
      end
      if((VGD >= -45) &&  (VGD <= 5.5) && (VGD_retc!=0))
      begin
        outfile=$fopen(errFileName,"a");
        $strobe("nhsj1b_2      VGD     entering SOCA ( -45.000 V .. 5.500 V ) at %7.4r  %M", $abstime );
        $fwrite(outfile,"nhsj1b_2      VGD     entering SOCA ( -45.000 V .. 5.500 V ) at %7.4r  %M\n", $abstime );
        VGD_retc=0;
        VGD_cnt=VGD_cnt-1;
        $fclose(outfile);
      end
      if((VGD > 5.5) &&  (VGD_retc!=1))
      begin
        outfile=$fopen(errFileName,"a");
        $strobe("nhsj1b_2      VGD     leaving   OCA ( 5.500 V ..  ) at %7.4r  %M", $abstime );
        $fwrite(outfile,"nhsj1b_2      VGD     leaving   OCA ( 5.500 V ..  ) at %7.4r  %M\n", $abstime );
        VGD_retc=1;
        VGD_cnt=VGD_cnt-1;
        $fclose(outfile);
      end
   end
   else
   begin
      if(VGD_cnt==0)
      begin
        outfile=$fopen(errFileName,"a");
        $strobe("nhsj1b_2      VGD     error limit ( %d ) reached at %7.4r  %M", maxEv, $abstime );
        $fwrite(outfile,"nhsj1b_2      VGD     error limit ( %d ) reached at %7.4r  %M\n", maxEv, $abstime );
        VGD_cnt=VGD_cnt-1;
        $fclose(outfile);
      end
   end

//      VDS
   VDS = V_D_S;
   if((VDS_cnt>0) || ( maxEv_flg==0 ))   begin
      if( (VDS < -1.5) && (VDS_retc!=-1))
      begin
        outfile=$fopen(errFileName,"a");
        $strobe("nhsj1b_2      VDS     leaving   OCA (  .. -1.500 V ) at %7.4r  %M", $abstime );
        $fwrite(outfile,"nhsj1b_2      VDS     leaving   OCA (  .. -1.500 V ) at %7.4r  %M\n", $abstime );
        VDS_retc=-1;
        VDS_cnt=VDS_cnt-1;
        $fclose(outfile);
      end
      if((VDS >= -1.5) &&  (VDS <= 45) && (VDS_retc!=0))
      begin
        outfile=$fopen(errFileName,"a");
        $strobe("nhsj1b_2      VDS     entering SOCA ( -1.500 V .. 45.000 V ) at %7.4r  %M", $abstime );
        $fwrite(outfile,"nhsj1b_2      VDS     entering SOCA ( -1.500 V .. 45.000 V ) at %7.4r  %M\n", $abstime );
        VDS_retc=0;
        VDS_cnt=VDS_cnt-1;
        $fclose(outfile);
      end
      if((VDS > 45) &&  (VDS_retc!=1))
      begin
        outfile=$fopen(errFileName,"a");
        $strobe("nhsj1b_2      VDS     leaving   OCA ( 45.000 V ..  ) at %7.4r  %M", $abstime );
        $fwrite(outfile,"nhsj1b_2      VDS     leaving   OCA ( 45.000 V ..  ) at %7.4r  %M\n", $abstime );
        VDS_retc=1;
        VDS_cnt=VDS_cnt-1;
        $fclose(outfile);
      end
   end
   else
   begin
      if(VDS_cnt==0)
      begin
        outfile=$fopen(errFileName,"a");
        $strobe("nhsj1b_2      VDS     error limit ( %d ) reached at %7.4r  %M", maxEv, $abstime );
        $fwrite(outfile,"nhsj1b_2      VDS     error limit ( %d ) reached at %7.4r  %M\n", maxEv, $abstime );
        VDS_cnt=VDS_cnt-1;
        $fclose(outfile);
      end
   end

//      VDB
   VDB = V_D_B;
   if((VDB_cnt>0) || ( maxEv_flg==0 ))   begin
      if( (VDB < -1.5) && (VDB_retc!=-1))
      begin
        outfile=$fopen(errFileName,"a");
        $strobe("nhsj1b_2      VDB     leaving   OCA (  .. -1.500 V ) at %7.4r  %M", $abstime );
        $fwrite(outfile,"nhsj1b_2      VDB     leaving   OCA (  .. -1.500 V ) at %7.4r  %M\n", $abstime );
        VDB_retc=-1;
        VDB_cnt=VDB_cnt-1;
        $fclose(outfile);
      end
      if((VDB >= -1.5) &&  (VDB <= 45) && (VDB_retc!=0))
      begin
        outfile=$fopen(errFileName,"a");
        $strobe("nhsj1b_2      VDB     entering SOCA ( -1.500 V .. 45.000 V ) at %7.4r  %M", $abstime );
        $fwrite(outfile,"nhsj1b_2      VDB     entering SOCA ( -1.500 V .. 45.000 V ) at %7.4r  %M\n", $abstime );
        VDB_retc=0;
        VDB_cnt=VDB_cnt-1;
        $fclose(outfile);
      end
      if((VDB > 45) &&  (VDB_retc!=1))
      begin
        outfile=$fopen(errFileName,"a");
        $strobe("nhsj1b_2      VDB     leaving   OCA ( 45.000 V ..  ) at %7.4r  %M", $abstime );
        $fwrite(outfile,"nhsj1b_2      VDB     leaving   OCA ( 45.000 V ..  ) at %7.4r  %M\n", $abstime );
        VDB_retc=1;
        VDB_cnt=VDB_cnt-1;
        $fclose(outfile);
      end
   end
   else
   begin
      if(VDB_cnt==0)
      begin
        outfile=$fopen(errFileName,"a");
        $strobe("nhsj1b_2      VDB     error limit ( %d ) reached at %7.4r  %M", maxEv, $abstime );
        $fwrite(outfile,"nhsj1b_2      VDB     error limit ( %d ) reached at %7.4r  %M\n", maxEv, $abstime );
        VDB_cnt=VDB_cnt-1;
        $fclose(outfile);
      end
   end

//      VDHW
   VDHW = V_D_HW;
   if((VDHW_cnt>0) || ( maxEv_flg==0 ))   begin
      if( (VDHW < -1.5) && (VDHW_retc!=-1))
      begin
        outfile=$fopen(errFileName,"a");
        $strobe("nhsj1b_2      VDHW    leaving   OCA (  .. -1.500 V ) at %7.4r  %M", $abstime );
        $fwrite(outfile,"nhsj1b_2      VDHW    leaving   OCA (  .. -1.500 V ) at %7.4r  %M\n", $abstime );
        VDHW_retc=-1;
        VDHW_cnt=VDHW_cnt-1;
        $fclose(outfile);
      end
      if((VDHW >= -1.5) &&  (VDHW <= 400) && (VDHW_retc!=0))
      begin
        outfile=$fopen(errFileName,"a");
        $strobe("nhsj1b_2      VDHW    entering SOCA ( -1.500 V .. 400.000 V ) at %7.4r  %M", $abstime );
        $fwrite(outfile,"nhsj1b_2      VDHW    entering SOCA ( -1.500 V .. 400.000 V ) at %7.4r  %M\n", $abstime );
        VDHW_retc=0;
        VDHW_cnt=VDHW_cnt-1;
        $fclose(outfile);
      end
      if((VDHW > 400) &&  (VDHW_retc!=1))
      begin
        outfile=$fopen(errFileName,"a");
        $strobe("nhsj1b_2      VDHW    leaving   OCA ( 400.000 V ..  ) at %7.4r  %M", $abstime );
        $fwrite(outfile,"nhsj1b_2      VDHW    leaving   OCA ( 400.000 V ..  ) at %7.4r  %M\n", $abstime );
        VDHW_retc=1;
        VDHW_cnt=VDHW_cnt-1;
        $fclose(outfile);
      end
   end
   else
   begin
      if(VDHW_cnt==0)
      begin
        outfile=$fopen(errFileName,"a");
        $strobe("nhsj1b_2      VDHW    error limit ( %d ) reached at %7.4r  %M", maxEv, $abstime );
        $fwrite(outfile,"nhsj1b_2      VDHW    error limit ( %d ) reached at %7.4r  %M\n", maxEv, $abstime );
        VDHW_cnt=VDHW_cnt-1;
        $fclose(outfile);
      end
   end

end // analog
endmodule // nhsj1b_2

// Verilog-A OC Watch for device nhsj1b_4 Parameters  VGS VGD VDS VDB VDHW
module nhsj1b_4_ahdl(D,G,S,B,HW);
parameter tstep_occ=100n;
parameter errFileName="./occ.err";
parameter maxEv = 25;
parameter maxEv_flg = 0;
inout D,G,S,B,HW;
electrical D,G,S,B,HW;

integer outfile;
real V_D_HW;
real V_D_B;
real V_D_S;
real V_G_D;
real V_G_S;
real VGS;
integer VGS_retc;
integer VGS_cnt;
real VGD;
integer VGD_retc;
integer VGD_cnt;
real VDS;
integer VDS_retc;
integer VDS_cnt;
real VDB;
integer VDB_retc;
integer VDB_cnt;
real VDHW;
integer VDHW_retc;
integer VDHW_cnt;

analog begin
   $bound_step( tstep_occ );
   @(initial_step) begin
      VGS_retc=0;
      VGS_cnt = maxEv;
      VGD_retc=0;
      VGD_cnt = maxEv;
      VDS_retc=0;
      VDS_cnt = maxEv;
      VDB_retc=0;
      VDB_cnt = maxEv;
      VDHW_retc=0;
      VDHW_cnt = maxEv;
   end
   V_D_HW = V(D,HW);
   V_D_B = V(D,B);
   V_D_S = V(D,S);
   V_G_D = V(G,D);
   V_G_S = V(G,S);

//      VGS
   VGS = V_G_S;
   if((VGS_cnt>0) || ( maxEv_flg==0 ))   begin
      if( (VGS < -5.5) && (VGS_retc!=-1))
      begin
        outfile=$fopen(errFileName,"a");
        $strobe("nhsj1b_4      VGS     leaving   OCA (  .. -5.500 V ) at %7.4r  %M", $abstime );
        $fwrite(outfile,"nhsj1b_4      VGS     leaving   OCA (  .. -5.500 V ) at %7.4r  %M\n", $abstime );
        VGS_retc=-1;
        VGS_cnt=VGS_cnt-1;
        $fclose(outfile);
      end
      if((VGS >= -5.5) &&  (VGS <= 5.5) && (VGS_retc!=0))
      begin
        outfile=$fopen(errFileName,"a");
        $strobe("nhsj1b_4      VGS     entering SOCA ( -5.500 V .. 5.500 V ) at %7.4r  %M", $abstime );
        $fwrite(outfile,"nhsj1b_4      VGS     entering SOCA ( -5.500 V .. 5.500 V ) at %7.4r  %M\n", $abstime );
        VGS_retc=0;
        VGS_cnt=VGS_cnt-1;
        $fclose(outfile);
      end
      if((VGS > 5.5) &&  (VGS_retc!=1))
      begin
        outfile=$fopen(errFileName,"a");
        $strobe("nhsj1b_4      VGS     leaving   OCA ( 5.500 V ..  ) at %7.4r  %M", $abstime );
        $fwrite(outfile,"nhsj1b_4      VGS     leaving   OCA ( 5.500 V ..  ) at %7.4r  %M\n", $abstime );
        VGS_retc=1;
        VGS_cnt=VGS_cnt-1;
        $fclose(outfile);
      end
   end
   else
   begin
      if(VGS_cnt==0)
      begin
        outfile=$fopen(errFileName,"a");
        $strobe("nhsj1b_4      VGS     error limit ( %d ) reached at %7.4r  %M", maxEv, $abstime );
        $fwrite(outfile,"nhsj1b_4      VGS     error limit ( %d ) reached at %7.4r  %M\n", maxEv, $abstime );
        VGS_cnt=VGS_cnt-1;
        $fclose(outfile);
      end
   end

//      VGD
   VGD = V_G_D;
   if((VGD_cnt>0) || ( maxEv_flg==0 ))   begin
      if( (VGD < -72) && (VGD_retc!=-1))
      begin
        outfile=$fopen(errFileName,"a");
        $strobe("nhsj1b_4      VGD     leaving   OCA (  .. -72.000 V ) at %7.4r  %M", $abstime );
        $fwrite(outfile,"nhsj1b_4      VGD     leaving   OCA (  .. -72.000 V ) at %7.4r  %M\n", $abstime );
        VGD_retc=-1;
        VGD_cnt=VGD_cnt-1;
        $fclose(outfile);
      end
      if((VGD >= -72) &&  (VGD <= 5.5) && (VGD_retc!=0))
      begin
        outfile=$fopen(errFileName,"a");
        $strobe("nhsj1b_4      VGD     entering SOCA ( -72.000 V .. 5.500 V ) at %7.4r  %M", $abstime );
        $fwrite(outfile,"nhsj1b_4      VGD     entering SOCA ( -72.000 V .. 5.500 V ) at %7.4r  %M\n", $abstime );
        VGD_retc=0;
        VGD_cnt=VGD_cnt-1;
        $fclose(outfile);
      end
      if((VGD > 5.5) &&  (VGD_retc!=1))
      begin
        outfile=$fopen(errFileName,"a");
        $strobe("nhsj1b_4      VGD     leaving   OCA ( 5.500 V ..  ) at %7.4r  %M", $abstime );
        $fwrite(outfile,"nhsj1b_4      VGD     leaving   OCA ( 5.500 V ..  ) at %7.4r  %M\n", $abstime );
        VGD_retc=1;
        VGD_cnt=VGD_cnt-1;
        $fclose(outfile);
      end
   end
   else
   begin
      if(VGD_cnt==0)
      begin
        outfile=$fopen(errFileName,"a");
        $strobe("nhsj1b_4      VGD     error limit ( %d ) reached at %7.4r  %M", maxEv, $abstime );
        $fwrite(outfile,"nhsj1b_4      VGD     error limit ( %d ) reached at %7.4r  %M\n", maxEv, $abstime );
        VGD_cnt=VGD_cnt-1;
        $fclose(outfile);
      end
   end

//      VDS
   VDS = V_D_S;
   if((VDS_cnt>0) || ( maxEv_flg==0 ))   begin
      if( (VDS < -1.5) && (VDS_retc!=-1))
      begin
        outfile=$fopen(errFileName,"a");
        $strobe("nhsj1b_4      VDS     leaving   OCA (  .. -1.500 V ) at %7.4r  %M", $abstime );
        $fwrite(outfile,"nhsj1b_4      VDS     leaving   OCA (  .. -1.500 V ) at %7.4r  %M\n", $abstime );
        VDS_retc=-1;
        VDS_cnt=VDS_cnt-1;
        $fclose(outfile);
      end
      if((VDS >= -1.5) &&  (VDS <= 72) && (VDS_retc!=0))
      begin
        outfile=$fopen(errFileName,"a");
        $strobe("nhsj1b_4      VDS     entering SOCA ( -1.500 V .. 72.000 V ) at %7.4r  %M", $abstime );
        $fwrite(outfile,"nhsj1b_4      VDS     entering SOCA ( -1.500 V .. 72.000 V ) at %7.4r  %M\n", $abstime );
        VDS_retc=0;
        VDS_cnt=VDS_cnt-1;
        $fclose(outfile);
      end
      if((VDS > 72) &&  (VDS_retc!=1))
      begin
        outfile=$fopen(errFileName,"a");
        $strobe("nhsj1b_4      VDS     leaving   OCA ( 72.000 V ..  ) at %7.4r  %M", $abstime );
        $fwrite(outfile,"nhsj1b_4      VDS     leaving   OCA ( 72.000 V ..  ) at %7.4r  %M\n", $abstime );
        VDS_retc=1;
        VDS_cnt=VDS_cnt-1;
        $fclose(outfile);
      end
   end
   else
   begin
      if(VDS_cnt==0)
      begin
        outfile=$fopen(errFileName,"a");
        $strobe("nhsj1b_4      VDS     error limit ( %d ) reached at %7.4r  %M", maxEv, $abstime );
        $fwrite(outfile,"nhsj1b_4      VDS     error limit ( %d ) reached at %7.4r  %M\n", maxEv, $abstime );
        VDS_cnt=VDS_cnt-1;
        $fclose(outfile);
      end
   end

//      VDB
   VDB = V_D_B;
   if((VDB_cnt>0) || ( maxEv_flg==0 ))   begin
      if( (VDB < -1.5) && (VDB_retc!=-1))
      begin
        outfile=$fopen(errFileName,"a");
        $strobe("nhsj1b_4      VDB     leaving   OCA (  .. -1.500 V ) at %7.4r  %M", $abstime );
        $fwrite(outfile,"nhsj1b_4      VDB     leaving   OCA (  .. -1.500 V ) at %7.4r  %M\n", $abstime );
        VDB_retc=-1;
        VDB_cnt=VDB_cnt-1;
        $fclose(outfile);
      end
      if((VDB >= -1.5) &&  (VDB <= 72) && (VDB_retc!=0))
      begin
        outfile=$fopen(errFileName,"a");
        $strobe("nhsj1b_4      VDB     entering SOCA ( -1.500 V .. 72.000 V ) at %7.4r  %M", $abstime );
        $fwrite(outfile,"nhsj1b_4      VDB     entering SOCA ( -1.500 V .. 72.000 V ) at %7.4r  %M\n", $abstime );
        VDB_retc=0;
        VDB_cnt=VDB_cnt-1;
        $fclose(outfile);
      end
      if((VDB > 72) &&  (VDB_retc!=1))
      begin
        outfile=$fopen(errFileName,"a");
        $strobe("nhsj1b_4      VDB     leaving   OCA ( 72.000 V ..  ) at %7.4r  %M", $abstime );
        $fwrite(outfile,"nhsj1b_4      VDB     leaving   OCA ( 72.000 V ..  ) at %7.4r  %M\n", $abstime );
        VDB_retc=1;
        VDB_cnt=VDB_cnt-1;
        $fclose(outfile);
      end
   end
   else
   begin
      if(VDB_cnt==0)
      begin
        outfile=$fopen(errFileName,"a");
        $strobe("nhsj1b_4      VDB     error limit ( %d ) reached at %7.4r  %M", maxEv, $abstime );
        $fwrite(outfile,"nhsj1b_4      VDB     error limit ( %d ) reached at %7.4r  %M\n", maxEv, $abstime );
        VDB_cnt=VDB_cnt-1;
        $fclose(outfile);
      end
   end

//      VDHW
   VDHW = V_D_HW;
   if((VDHW_cnt>0) || ( maxEv_flg==0 ))   begin
      if( (VDHW < -1.5) && (VDHW_retc!=-1))
      begin
        outfile=$fopen(errFileName,"a");
        $strobe("nhsj1b_4      VDHW    leaving   OCA (  .. -1.500 V ) at %7.4r  %M", $abstime );
        $fwrite(outfile,"nhsj1b_4      VDHW    leaving   OCA (  .. -1.500 V ) at %7.4r  %M\n", $abstime );
        VDHW_retc=-1;
        VDHW_cnt=VDHW_cnt-1;
        $fclose(outfile);
      end
      if((VDHW >= -1.5) &&  (VDHW <= 400) && (VDHW_retc!=0))
      begin
        outfile=$fopen(errFileName,"a");
        $strobe("nhsj1b_4      VDHW    entering SOCA ( -1.500 V .. 400.000 V ) at %7.4r  %M", $abstime );
        $fwrite(outfile,"nhsj1b_4      VDHW    entering SOCA ( -1.500 V .. 400.000 V ) at %7.4r  %M\n", $abstime );
        VDHW_retc=0;
        VDHW_cnt=VDHW_cnt-1;
        $fclose(outfile);
      end
      if((VDHW > 400) &&  (VDHW_retc!=1))
      begin
        outfile=$fopen(errFileName,"a");
        $strobe("nhsj1b_4      VDHW    leaving   OCA ( 400.000 V ..  ) at %7.4r  %M", $abstime );
        $fwrite(outfile,"nhsj1b_4      VDHW    leaving   OCA ( 400.000 V ..  ) at %7.4r  %M\n", $abstime );
        VDHW_retc=1;
        VDHW_cnt=VDHW_cnt-1;
        $fclose(outfile);
      end
   end
   else
   begin
      if(VDHW_cnt==0)
      begin
        outfile=$fopen(errFileName,"a");
        $strobe("nhsj1b_4      VDHW    error limit ( %d ) reached at %7.4r  %M", maxEv, $abstime );
        $fwrite(outfile,"nhsj1b_4      VDHW    error limit ( %d ) reached at %7.4r  %M\n", maxEv, $abstime );
        VDHW_cnt=VDHW_cnt-1;
        $fclose(outfile);
      end
   end

end // analog
endmodule // nhsj1b_4

// Verilog-A OC Watch for device nhsj1b_5 Parameters  VGS VGD VDS VDB VDHW
module nhsj1b_5_ahdl(D,G,S,B,HW);
parameter tstep_occ=100n;
parameter errFileName="./occ.err";
parameter maxEv = 25;
parameter maxEv_flg = 0;
inout D,G,S,B,HW;
electrical D,G,S,B,HW;

integer outfile;
real V_D_HW;
real V_D_B;
real V_D_S;
real V_G_D;
real V_G_S;
real VGS;
integer VGS_retc;
integer VGS_cnt;
real VGD;
integer VGD_retc;
integer VGD_cnt;
real VDS;
integer VDS_retc;
integer VDS_cnt;
real VDB;
integer VDB_retc;
integer VDB_cnt;
real VDHW;
integer VDHW_retc;
integer VDHW_cnt;

analog begin
   $bound_step( tstep_occ );
   @(initial_step) begin
      VGS_retc=0;
      VGS_cnt = maxEv;
      VGD_retc=0;
      VGD_cnt = maxEv;
      VDS_retc=0;
      VDS_cnt = maxEv;
      VDB_retc=0;
      VDB_cnt = maxEv;
      VDHW_retc=0;
      VDHW_cnt = maxEv;
   end
   V_D_HW = V(D,HW);
   V_D_B = V(D,B);
   V_D_S = V(D,S);
   V_G_D = V(G,D);
   V_G_S = V(G,S);

//      VGS
   VGS = V_G_S;
   if((VGS_cnt>0) || ( maxEv_flg==0 ))   begin
      if( (VGS < -5.5) && (VGS_retc!=-1))
      begin
        outfile=$fopen(errFileName,"a");
        $strobe("nhsj1b_5      VGS     leaving   OCA (  .. -5.500 V ) at %7.4r  %M", $abstime );
        $fwrite(outfile,"nhsj1b_5      VGS     leaving   OCA (  .. -5.500 V ) at %7.4r  %M\n", $abstime );
        VGS_retc=-1;
        VGS_cnt=VGS_cnt-1;
        $fclose(outfile);
      end
      if((VGS >= -5.5) &&  (VGS <= 5.5) && (VGS_retc!=0))
      begin
        outfile=$fopen(errFileName,"a");
        $strobe("nhsj1b_5      VGS     entering SOCA ( -5.500 V .. 5.500 V ) at %7.4r  %M", $abstime );
        $fwrite(outfile,"nhsj1b_5      VGS     entering SOCA ( -5.500 V .. 5.500 V ) at %7.4r  %M\n", $abstime );
        VGS_retc=0;
        VGS_cnt=VGS_cnt-1;
        $fclose(outfile);
      end
      if((VGS > 5.5) &&  (VGS_retc!=1))
      begin
        outfile=$fopen(errFileName,"a");
        $strobe("nhsj1b_5      VGS     leaving   OCA ( 5.500 V ..  ) at %7.4r  %M", $abstime );
        $fwrite(outfile,"nhsj1b_5      VGS     leaving   OCA ( 5.500 V ..  ) at %7.4r  %M\n", $abstime );
        VGS_retc=1;
        VGS_cnt=VGS_cnt-1;
        $fclose(outfile);
      end
   end
   else
   begin
      if(VGS_cnt==0)
      begin
        outfile=$fopen(errFileName,"a");
        $strobe("nhsj1b_5      VGS     error limit ( %d ) reached at %7.4r  %M", maxEv, $abstime );
        $fwrite(outfile,"nhsj1b_5      VGS     error limit ( %d ) reached at %7.4r  %M\n", maxEv, $abstime );
        VGS_cnt=VGS_cnt-1;
        $fclose(outfile);
      end
   end

//      VGD
   VGD = V_G_D;
   if((VGD_cnt>0) || ( maxEv_flg==0 ))   begin
      if( (VGD < -95) && (VGD_retc!=-1))
      begin
        outfile=$fopen(errFileName,"a");
        $strobe("nhsj1b_5      VGD     leaving   OCA (  .. -95.000 V ) at %7.4r  %M", $abstime );
        $fwrite(outfile,"nhsj1b_5      VGD     leaving   OCA (  .. -95.000 V ) at %7.4r  %M\n", $abstime );
        VGD_retc=-1;
        VGD_cnt=VGD_cnt-1;
        $fclose(outfile);
      end
      if((VGD >= -95) &&  (VGD <= 5.5) && (VGD_retc!=0))
      begin
        outfile=$fopen(errFileName,"a");
        $strobe("nhsj1b_5      VGD     entering SOCA ( -95.000 V .. 5.500 V ) at %7.4r  %M", $abstime );
        $fwrite(outfile,"nhsj1b_5      VGD     entering SOCA ( -95.000 V .. 5.500 V ) at %7.4r  %M\n", $abstime );
        VGD_retc=0;
        VGD_cnt=VGD_cnt-1;
        $fclose(outfile);
      end
      if((VGD > 5.5) &&  (VGD_retc!=1))
      begin
        outfile=$fopen(errFileName,"a");
        $strobe("nhsj1b_5      VGD     leaving   OCA ( 5.500 V ..  ) at %7.4r  %M", $abstime );
        $fwrite(outfile,"nhsj1b_5      VGD     leaving   OCA ( 5.500 V ..  ) at %7.4r  %M\n", $abstime );
        VGD_retc=1;
        VGD_cnt=VGD_cnt-1;
        $fclose(outfile);
      end
   end
   else
   begin
      if(VGD_cnt==0)
      begin
        outfile=$fopen(errFileName,"a");
        $strobe("nhsj1b_5      VGD     error limit ( %d ) reached at %7.4r  %M", maxEv, $abstime );
        $fwrite(outfile,"nhsj1b_5      VGD     error limit ( %d ) reached at %7.4r  %M\n", maxEv, $abstime );
        VGD_cnt=VGD_cnt-1;
        $fclose(outfile);
      end
   end

//      VDS
   VDS = V_D_S;
   if((VDS_cnt>0) || ( maxEv_flg==0 ))   begin
      if( (VDS < -1.5) && (VDS_retc!=-1))
      begin
        outfile=$fopen(errFileName,"a");
        $strobe("nhsj1b_5      VDS     leaving   OCA (  .. -1.500 V ) at %7.4r  %M", $abstime );
        $fwrite(outfile,"nhsj1b_5      VDS     leaving   OCA (  .. -1.500 V ) at %7.4r  %M\n", $abstime );
        VDS_retc=-1;
        VDS_cnt=VDS_cnt-1;
        $fclose(outfile);
      end
      if((VDS >= -1.5) &&  (VDS <= 95) && (VDS_retc!=0))
      begin
        outfile=$fopen(errFileName,"a");
        $strobe("nhsj1b_5      VDS     entering SOCA ( -1.500 V .. 95.000 V ) at %7.4r  %M", $abstime );
        $fwrite(outfile,"nhsj1b_5      VDS     entering SOCA ( -1.500 V .. 95.000 V ) at %7.4r  %M\n", $abstime );
        VDS_retc=0;
        VDS_cnt=VDS_cnt-1;
        $fclose(outfile);
      end
      if((VDS > 95) &&  (VDS_retc!=1))
      begin
        outfile=$fopen(errFileName,"a");
        $strobe("nhsj1b_5      VDS     leaving   OCA ( 95.000 V ..  ) at %7.4r  %M", $abstime );
        $fwrite(outfile,"nhsj1b_5      VDS     leaving   OCA ( 95.000 V ..  ) at %7.4r  %M\n", $abstime );
        VDS_retc=1;
        VDS_cnt=VDS_cnt-1;
        $fclose(outfile);
      end
   end
   else
   begin
      if(VDS_cnt==0)
      begin
        outfile=$fopen(errFileName,"a");
        $strobe("nhsj1b_5      VDS     error limit ( %d ) reached at %7.4r  %M", maxEv, $abstime );
        $fwrite(outfile,"nhsj1b_5      VDS     error limit ( %d ) reached at %7.4r  %M\n", maxEv, $abstime );
        VDS_cnt=VDS_cnt-1;
        $fclose(outfile);
      end
   end

//      VDB
   VDB = V_D_B;
   if((VDB_cnt>0) || ( maxEv_flg==0 ))   begin
      if( (VDB < -1.5) && (VDB_retc!=-1))
      begin
        outfile=$fopen(errFileName,"a");
        $strobe("nhsj1b_5      VDB     leaving   OCA (  .. -1.500 V ) at %7.4r  %M", $abstime );
        $fwrite(outfile,"nhsj1b_5      VDB     leaving   OCA (  .. -1.500 V ) at %7.4r  %M\n", $abstime );
        VDB_retc=-1;
        VDB_cnt=VDB_cnt-1;
        $fclose(outfile);
      end
      if((VDB >= -1.5) &&  (VDB <= 95) && (VDB_retc!=0))
      begin
        outfile=$fopen(errFileName,"a");
        $strobe("nhsj1b_5      VDB     entering SOCA ( -1.500 V .. 95.000 V ) at %7.4r  %M", $abstime );
        $fwrite(outfile,"nhsj1b_5      VDB     entering SOCA ( -1.500 V .. 95.000 V ) at %7.4r  %M\n", $abstime );
        VDB_retc=0;
        VDB_cnt=VDB_cnt-1;
        $fclose(outfile);
      end
      if((VDB > 95) &&  (VDB_retc!=1))
      begin
        outfile=$fopen(errFileName,"a");
        $strobe("nhsj1b_5      VDB     leaving   OCA ( 95.000 V ..  ) at %7.4r  %M", $abstime );
        $fwrite(outfile,"nhsj1b_5      VDB     leaving   OCA ( 95.000 V ..  ) at %7.4r  %M\n", $abstime );
        VDB_retc=1;
        VDB_cnt=VDB_cnt-1;
        $fclose(outfile);
      end
   end
   else
   begin
      if(VDB_cnt==0)
      begin
        outfile=$fopen(errFileName,"a");
        $strobe("nhsj1b_5      VDB     error limit ( %d ) reached at %7.4r  %M", maxEv, $abstime );
        $fwrite(outfile,"nhsj1b_5      VDB     error limit ( %d ) reached at %7.4r  %M\n", maxEv, $abstime );
        VDB_cnt=VDB_cnt-1;
        $fclose(outfile);
      end
   end

//      VDHW
   VDHW = V_D_HW;
   if((VDHW_cnt>0) || ( maxEv_flg==0 ))   begin
      if( (VDHW < -1.5) && (VDHW_retc!=-1))
      begin
        outfile=$fopen(errFileName,"a");
        $strobe("nhsj1b_5      VDHW    leaving   OCA (  .. -1.500 V ) at %7.4r  %M", $abstime );
        $fwrite(outfile,"nhsj1b_5      VDHW    leaving   OCA (  .. -1.500 V ) at %7.4r  %M\n", $abstime );
        VDHW_retc=-1;
        VDHW_cnt=VDHW_cnt-1;
        $fclose(outfile);
      end
      if((VDHW >= -1.5) &&  (VDHW <= 400) && (VDHW_retc!=0))
      begin
        outfile=$fopen(errFileName,"a");
        $strobe("nhsj1b_5      VDHW    entering SOCA ( -1.500 V .. 400.000 V ) at %7.4r  %M", $abstime );
        $fwrite(outfile,"nhsj1b_5      VDHW    entering SOCA ( -1.500 V .. 400.000 V ) at %7.4r  %M\n", $abstime );
        VDHW_retc=0;
        VDHW_cnt=VDHW_cnt-1;
        $fclose(outfile);
      end
      if((VDHW > 400) &&  (VDHW_retc!=1))
      begin
        outfile=$fopen(errFileName,"a");
        $strobe("nhsj1b_5      VDHW    leaving   OCA ( 400.000 V ..  ) at %7.4r  %M", $abstime );
        $fwrite(outfile,"nhsj1b_5      VDHW    leaving   OCA ( 400.000 V ..  ) at %7.4r  %M\n", $abstime );
        VDHW_retc=1;
        VDHW_cnt=VDHW_cnt-1;
        $fclose(outfile);
      end
   end
   else
   begin
      if(VDHW_cnt==0)
      begin
        outfile=$fopen(errFileName,"a");
        $strobe("nhsj1b_5      VDHW    error limit ( %d ) reached at %7.4r  %M", maxEv, $abstime );
        $fwrite(outfile,"nhsj1b_5      VDHW    error limit ( %d ) reached at %7.4r  %M\n", maxEv, $abstime );
        VDHW_cnt=VDHW_cnt-1;
        $fclose(outfile);
      end
   end

end // analog
endmodule // nhsj1b_5

// Verilog-A OC Watch for device nhsj1b_7 Parameters  VGS VGD VDS VDB VDHW
module nhsj1b_7_ahdl(D,G,S,B,HW);
parameter tstep_occ=100n;
parameter errFileName="./occ.err";
parameter maxEv = 25;
parameter maxEv_flg = 0;
inout D,G,S,B,HW;
electrical D,G,S,B,HW;

integer outfile;
real V_D_HW;
real V_D_B;
real V_D_S;
real V_G_D;
real V_G_S;
real VGS;
integer VGS_retc;
integer VGS_cnt;
real VGD;
integer VGD_retc;
integer VGD_cnt;
real VDS;
integer VDS_retc;
integer VDS_cnt;
real VDB;
integer VDB_retc;
integer VDB_cnt;
real VDHW;
integer VDHW_retc;
integer VDHW_cnt;

analog begin
   $bound_step( tstep_occ );
   @(initial_step) begin
      VGS_retc=0;
      VGS_cnt = maxEv;
      VGD_retc=0;
      VGD_cnt = maxEv;
      VDS_retc=0;
      VDS_cnt = maxEv;
      VDB_retc=0;
      VDB_cnt = maxEv;
      VDHW_retc=0;
      VDHW_cnt = maxEv;
   end
   V_D_HW = V(D,HW);
   V_D_B = V(D,B);
   V_D_S = V(D,S);
   V_G_D = V(G,D);
   V_G_S = V(G,S);

//      VGS
   VGS = V_G_S;
   if((VGS_cnt>0) || ( maxEv_flg==0 ))   begin
      if( (VGS < -5.5) && (VGS_retc!=-1))
      begin
        outfile=$fopen(errFileName,"a");
        $strobe("nhsj1b_7      VGS     leaving   OCA (  .. -5.500 V ) at %7.4r  %M", $abstime );
        $fwrite(outfile,"nhsj1b_7      VGS     leaving   OCA (  .. -5.500 V ) at %7.4r  %M\n", $abstime );
        VGS_retc=-1;
        VGS_cnt=VGS_cnt-1;
        $fclose(outfile);
      end
      if((VGS >= -5.5) &&  (VGS <= 5.5) && (VGS_retc!=0))
      begin
        outfile=$fopen(errFileName,"a");
        $strobe("nhsj1b_7      VGS     entering SOCA ( -5.500 V .. 5.500 V ) at %7.4r  %M", $abstime );
        $fwrite(outfile,"nhsj1b_7      VGS     entering SOCA ( -5.500 V .. 5.500 V ) at %7.4r  %M\n", $abstime );
        VGS_retc=0;
        VGS_cnt=VGS_cnt-1;
        $fclose(outfile);
      end
      if((VGS > 5.5) &&  (VGS_retc!=1))
      begin
        outfile=$fopen(errFileName,"a");
        $strobe("nhsj1b_7      VGS     leaving   OCA ( 5.500 V ..  ) at %7.4r  %M", $abstime );
        $fwrite(outfile,"nhsj1b_7      VGS     leaving   OCA ( 5.500 V ..  ) at %7.4r  %M\n", $abstime );
        VGS_retc=1;
        VGS_cnt=VGS_cnt-1;
        $fclose(outfile);
      end
   end
   else
   begin
      if(VGS_cnt==0)
      begin
        outfile=$fopen(errFileName,"a");
        $strobe("nhsj1b_7      VGS     error limit ( %d ) reached at %7.4r  %M", maxEv, $abstime );
        $fwrite(outfile,"nhsj1b_7      VGS     error limit ( %d ) reached at %7.4r  %M\n", maxEv, $abstime );
        VGS_cnt=VGS_cnt-1;
        $fclose(outfile);
      end
   end

//      VGD
   VGD = V_G_D;
   if((VGD_cnt>0) || ( maxEv_flg==0 ))   begin
      if( (VGD < -115) && (VGD_retc!=-1))
      begin
        outfile=$fopen(errFileName,"a");
        $strobe("nhsj1b_7      VGD     leaving   OCA (  .. -115.000 V ) at %7.4r  %M", $abstime );
        $fwrite(outfile,"nhsj1b_7      VGD     leaving   OCA (  .. -115.000 V ) at %7.4r  %M\n", $abstime );
        VGD_retc=-1;
        VGD_cnt=VGD_cnt-1;
        $fclose(outfile);
      end
      if((VGD >= -115) &&  (VGD <= 5.5) && (VGD_retc!=0))
      begin
        outfile=$fopen(errFileName,"a");
        $strobe("nhsj1b_7      VGD     entering SOCA ( -115.000 V .. 5.500 V ) at %7.4r  %M", $abstime );
        $fwrite(outfile,"nhsj1b_7      VGD     entering SOCA ( -115.000 V .. 5.500 V ) at %7.4r  %M\n", $abstime );
        VGD_retc=0;
        VGD_cnt=VGD_cnt-1;
        $fclose(outfile);
      end
      if((VGD > 5.5) &&  (VGD_retc!=1))
      begin
        outfile=$fopen(errFileName,"a");
        $strobe("nhsj1b_7      VGD     leaving   OCA ( 5.500 V ..  ) at %7.4r  %M", $abstime );
        $fwrite(outfile,"nhsj1b_7      VGD     leaving   OCA ( 5.500 V ..  ) at %7.4r  %M\n", $abstime );
        VGD_retc=1;
        VGD_cnt=VGD_cnt-1;
        $fclose(outfile);
      end
   end
   else
   begin
      if(VGD_cnt==0)
      begin
        outfile=$fopen(errFileName,"a");
        $strobe("nhsj1b_7      VGD     error limit ( %d ) reached at %7.4r  %M", maxEv, $abstime );
        $fwrite(outfile,"nhsj1b_7      VGD     error limit ( %d ) reached at %7.4r  %M\n", maxEv, $abstime );
        VGD_cnt=VGD_cnt-1;
        $fclose(outfile);
      end
   end

//      VDS
   VDS = V_D_S;
   if((VDS_cnt>0) || ( maxEv_flg==0 ))   begin
      if( (VDS < -1.5) && (VDS_retc!=-1))
      begin
        outfile=$fopen(errFileName,"a");
        $strobe("nhsj1b_7      VDS     leaving   OCA (  .. -1.500 V ) at %7.4r  %M", $abstime );
        $fwrite(outfile,"nhsj1b_7      VDS     leaving   OCA (  .. -1.500 V ) at %7.4r  %M\n", $abstime );
        VDS_retc=-1;
        VDS_cnt=VDS_cnt-1;
        $fclose(outfile);
      end
      if((VDS >= -1.5) &&  (VDS <= 115) && (VDS_retc!=0))
      begin
        outfile=$fopen(errFileName,"a");
        $strobe("nhsj1b_7      VDS     entering SOCA ( -1.500 V .. 115.000 V ) at %7.4r  %M", $abstime );
        $fwrite(outfile,"nhsj1b_7      VDS     entering SOCA ( -1.500 V .. 115.000 V ) at %7.4r  %M\n", $abstime );
        VDS_retc=0;
        VDS_cnt=VDS_cnt-1;
        $fclose(outfile);
      end
      if((VDS > 115) &&  (VDS_retc!=1))
      begin
        outfile=$fopen(errFileName,"a");
        $strobe("nhsj1b_7      VDS     leaving   OCA ( 115.000 V ..  ) at %7.4r  %M", $abstime );
        $fwrite(outfile,"nhsj1b_7      VDS     leaving   OCA ( 115.000 V ..  ) at %7.4r  %M\n", $abstime );
        VDS_retc=1;
        VDS_cnt=VDS_cnt-1;
        $fclose(outfile);
      end
   end
   else
   begin
      if(VDS_cnt==0)
      begin
        outfile=$fopen(errFileName,"a");
        $strobe("nhsj1b_7      VDS     error limit ( %d ) reached at %7.4r  %M", maxEv, $abstime );
        $fwrite(outfile,"nhsj1b_7      VDS     error limit ( %d ) reached at %7.4r  %M\n", maxEv, $abstime );
        VDS_cnt=VDS_cnt-1;
        $fclose(outfile);
      end
   end

//      VDB
   VDB = V_D_B;
   if((VDB_cnt>0) || ( maxEv_flg==0 ))   begin
      if( (VDB < -1.5) && (VDB_retc!=-1))
      begin
        outfile=$fopen(errFileName,"a");
        $strobe("nhsj1b_7      VDB     leaving   OCA (  .. -1.500 V ) at %7.4r  %M", $abstime );
        $fwrite(outfile,"nhsj1b_7      VDB     leaving   OCA (  .. -1.500 V ) at %7.4r  %M\n", $abstime );
        VDB_retc=-1;
        VDB_cnt=VDB_cnt-1;
        $fclose(outfile);
      end
      if((VDB >= -1.5) &&  (VDB <= 115) && (VDB_retc!=0))
      begin
        outfile=$fopen(errFileName,"a");
        $strobe("nhsj1b_7      VDB     entering SOCA ( -1.500 V .. 115.000 V ) at %7.4r  %M", $abstime );
        $fwrite(outfile,"nhsj1b_7      VDB     entering SOCA ( -1.500 V .. 115.000 V ) at %7.4r  %M\n", $abstime );
        VDB_retc=0;
        VDB_cnt=VDB_cnt-1;
        $fclose(outfile);
      end
      if((VDB > 115) &&  (VDB_retc!=1))
      begin
        outfile=$fopen(errFileName,"a");
        $strobe("nhsj1b_7      VDB     leaving   OCA ( 115.000 V ..  ) at %7.4r  %M", $abstime );
        $fwrite(outfile,"nhsj1b_7      VDB     leaving   OCA ( 115.000 V ..  ) at %7.4r  %M\n", $abstime );
        VDB_retc=1;
        VDB_cnt=VDB_cnt-1;
        $fclose(outfile);
      end
   end
   else
   begin
      if(VDB_cnt==0)
      begin
        outfile=$fopen(errFileName,"a");
        $strobe("nhsj1b_7      VDB     error limit ( %d ) reached at %7.4r  %M", maxEv, $abstime );
        $fwrite(outfile,"nhsj1b_7      VDB     error limit ( %d ) reached at %7.4r  %M\n", maxEv, $abstime );
        VDB_cnt=VDB_cnt-1;
        $fclose(outfile);
      end
   end

//      VDHW
   VDHW = V_D_HW;
   if((VDHW_cnt>0) || ( maxEv_flg==0 ))   begin
      if( (VDHW < -1.5) && (VDHW_retc!=-1))
      begin
        outfile=$fopen(errFileName,"a");
        $strobe("nhsj1b_7      VDHW    leaving   OCA (  .. -1.500 V ) at %7.4r  %M", $abstime );
        $fwrite(outfile,"nhsj1b_7      VDHW    leaving   OCA (  .. -1.500 V ) at %7.4r  %M\n", $abstime );
        VDHW_retc=-1;
        VDHW_cnt=VDHW_cnt-1;
        $fclose(outfile);
      end
      if((VDHW >= -1.5) &&  (VDHW <= 400) && (VDHW_retc!=0))
      begin
        outfile=$fopen(errFileName,"a");
        $strobe("nhsj1b_7      VDHW    entering SOCA ( -1.500 V .. 400.000 V ) at %7.4r  %M", $abstime );
        $fwrite(outfile,"nhsj1b_7      VDHW    entering SOCA ( -1.500 V .. 400.000 V ) at %7.4r  %M\n", $abstime );
        VDHW_retc=0;
        VDHW_cnt=VDHW_cnt-1;
        $fclose(outfile);
      end
      if((VDHW > 400) &&  (VDHW_retc!=1))
      begin
        outfile=$fopen(errFileName,"a");
        $strobe("nhsj1b_7      VDHW    leaving   OCA ( 400.000 V ..  ) at %7.4r  %M", $abstime );
        $fwrite(outfile,"nhsj1b_7      VDHW    leaving   OCA ( 400.000 V ..  ) at %7.4r  %M\n", $abstime );
        VDHW_retc=1;
        VDHW_cnt=VDHW_cnt-1;
        $fclose(outfile);
      end
   end
   else
   begin
      if(VDHW_cnt==0)
      begin
        outfile=$fopen(errFileName,"a");
        $strobe("nhsj1b_7      VDHW    error limit ( %d ) reached at %7.4r  %M", maxEv, $abstime );
        $fwrite(outfile,"nhsj1b_7      VDHW    error limit ( %d ) reached at %7.4r  %M\n", maxEv, $abstime );
        VDHW_cnt=VDHW_cnt-1;
        $fclose(outfile);
      end
   end

end // analog
endmodule // nhsj1b_7

// Verilog-A OC Watch for device nhsj1b_8 Parameters  VGS VGD VDS VDB VDHW
module nhsj1b_8_ahdl(D,G,S,B,HW);
parameter tstep_occ=100n;
parameter errFileName="./occ.err";
parameter maxEv = 25;
parameter maxEv_flg = 0;
inout D,G,S,B,HW;
electrical D,G,S,B,HW;

integer outfile;
real V_D_HW;
real V_D_B;
real V_D_S;
real V_G_D;
real V_G_S;
real VGS;
integer VGS_retc;
integer VGS_cnt;
real VGD;
integer VGD_retc;
integer VGD_cnt;
real VDS;
integer VDS_retc;
integer VDS_cnt;
real VDB;
integer VDB_retc;
integer VDB_cnt;
real VDHW;
integer VDHW_retc;
integer VDHW_cnt;

analog begin
   $bound_step( tstep_occ );
   @(initial_step) begin
      VGS_retc=0;
      VGS_cnt = maxEv;
      VGD_retc=0;
      VGD_cnt = maxEv;
      VDS_retc=0;
      VDS_cnt = maxEv;
      VDB_retc=0;
      VDB_cnt = maxEv;
      VDHW_retc=0;
      VDHW_cnt = maxEv;
   end
   V_D_HW = V(D,HW);
   V_D_B = V(D,B);
   V_D_S = V(D,S);
   V_G_D = V(G,D);
   V_G_S = V(G,S);

//      VGS
   VGS = V_G_S;
   if((VGS_cnt>0) || ( maxEv_flg==0 ))   begin
      if( (VGS < -5.5) && (VGS_retc!=-1))
      begin
        outfile=$fopen(errFileName,"a");
        $strobe("nhsj1b_8      VGS     leaving   OCA (  .. -5.500 V ) at %7.4r  %M", $abstime );
        $fwrite(outfile,"nhsj1b_8      VGS     leaving   OCA (  .. -5.500 V ) at %7.4r  %M\n", $abstime );
        VGS_retc=-1;
        VGS_cnt=VGS_cnt-1;
        $fclose(outfile);
      end
      if((VGS >= -5.5) &&  (VGS <= 5.5) && (VGS_retc!=0))
      begin
        outfile=$fopen(errFileName,"a");
        $strobe("nhsj1b_8      VGS     entering SOCA ( -5.500 V .. 5.500 V ) at %7.4r  %M", $abstime );
        $fwrite(outfile,"nhsj1b_8      VGS     entering SOCA ( -5.500 V .. 5.500 V ) at %7.4r  %M\n", $abstime );
        VGS_retc=0;
        VGS_cnt=VGS_cnt-1;
        $fclose(outfile);
      end
      if((VGS > 5.5) &&  (VGS_retc!=1))
      begin
        outfile=$fopen(errFileName,"a");
        $strobe("nhsj1b_8      VGS     leaving   OCA ( 5.500 V ..  ) at %7.4r  %M", $abstime );
        $fwrite(outfile,"nhsj1b_8      VGS     leaving   OCA ( 5.500 V ..  ) at %7.4r  %M\n", $abstime );
        VGS_retc=1;
        VGS_cnt=VGS_cnt-1;
        $fclose(outfile);
      end
   end
   else
   begin
      if(VGS_cnt==0)
      begin
        outfile=$fopen(errFileName,"a");
        $strobe("nhsj1b_8      VGS     error limit ( %d ) reached at %7.4r  %M", maxEv, $abstime );
        $fwrite(outfile,"nhsj1b_8      VGS     error limit ( %d ) reached at %7.4r  %M\n", maxEv, $abstime );
        VGS_cnt=VGS_cnt-1;
        $fclose(outfile);
      end
   end

//      VGD
   VGD = V_G_D;
   if((VGD_cnt>0) || ( maxEv_flg==0 ))   begin
      if( (VGD < -140) && (VGD_retc!=-1))
      begin
        outfile=$fopen(errFileName,"a");
        $strobe("nhsj1b_8      VGD     leaving   OCA (  .. -140.000 V ) at %7.4r  %M", $abstime );
        $fwrite(outfile,"nhsj1b_8      VGD     leaving   OCA (  .. -140.000 V ) at %7.4r  %M\n", $abstime );
        VGD_retc=-1;
        VGD_cnt=VGD_cnt-1;
        $fclose(outfile);
      end
      if((VGD >= -140) &&  (VGD <= 5.5) && (VGD_retc!=0))
      begin
        outfile=$fopen(errFileName,"a");
        $strobe("nhsj1b_8      VGD     entering SOCA ( -140.000 V .. 5.500 V ) at %7.4r  %M", $abstime );
        $fwrite(outfile,"nhsj1b_8      VGD     entering SOCA ( -140.000 V .. 5.500 V ) at %7.4r  %M\n", $abstime );
        VGD_retc=0;
        VGD_cnt=VGD_cnt-1;
        $fclose(outfile);
      end
      if((VGD > 5.5) &&  (VGD_retc!=1))
      begin
        outfile=$fopen(errFileName,"a");
        $strobe("nhsj1b_8      VGD     leaving   OCA ( 5.500 V ..  ) at %7.4r  %M", $abstime );
        $fwrite(outfile,"nhsj1b_8      VGD     leaving   OCA ( 5.500 V ..  ) at %7.4r  %M\n", $abstime );
        VGD_retc=1;
        VGD_cnt=VGD_cnt-1;
        $fclose(outfile);
      end
   end
   else
   begin
      if(VGD_cnt==0)
      begin
        outfile=$fopen(errFileName,"a");
        $strobe("nhsj1b_8      VGD     error limit ( %d ) reached at %7.4r  %M", maxEv, $abstime );
        $fwrite(outfile,"nhsj1b_8      VGD     error limit ( %d ) reached at %7.4r  %M\n", maxEv, $abstime );
        VGD_cnt=VGD_cnt-1;
        $fclose(outfile);
      end
   end

//      VDS
   VDS = V_D_S;
   if((VDS_cnt>0) || ( maxEv_flg==0 ))   begin
      if( (VDS < -1.5) && (VDS_retc!=-1))
      begin
        outfile=$fopen(errFileName,"a");
        $strobe("nhsj1b_8      VDS     leaving   OCA (  .. -1.500 V ) at %7.4r  %M", $abstime );
        $fwrite(outfile,"nhsj1b_8      VDS     leaving   OCA (  .. -1.500 V ) at %7.4r  %M\n", $abstime );
        VDS_retc=-1;
        VDS_cnt=VDS_cnt-1;
        $fclose(outfile);
      end
      if((VDS >= -1.5) &&  (VDS <= 140) && (VDS_retc!=0))
      begin
        outfile=$fopen(errFileName,"a");
        $strobe("nhsj1b_8      VDS     entering SOCA ( -1.500 V .. 140.000 V ) at %7.4r  %M", $abstime );
        $fwrite(outfile,"nhsj1b_8      VDS     entering SOCA ( -1.500 V .. 140.000 V ) at %7.4r  %M\n", $abstime );
        VDS_retc=0;
        VDS_cnt=VDS_cnt-1;
        $fclose(outfile);
      end
      if((VDS > 140) &&  (VDS_retc!=1))
      begin
        outfile=$fopen(errFileName,"a");
        $strobe("nhsj1b_8      VDS     leaving   OCA ( 140.000 V ..  ) at %7.4r  %M", $abstime );
        $fwrite(outfile,"nhsj1b_8      VDS     leaving   OCA ( 140.000 V ..  ) at %7.4r  %M\n", $abstime );
        VDS_retc=1;
        VDS_cnt=VDS_cnt-1;
        $fclose(outfile);
      end
   end
   else
   begin
      if(VDS_cnt==0)
      begin
        outfile=$fopen(errFileName,"a");
        $strobe("nhsj1b_8      VDS     error limit ( %d ) reached at %7.4r  %M", maxEv, $abstime );
        $fwrite(outfile,"nhsj1b_8      VDS     error limit ( %d ) reached at %7.4r  %M\n", maxEv, $abstime );
        VDS_cnt=VDS_cnt-1;
        $fclose(outfile);
      end
   end

//      VDB
   VDB = V_D_B;
   if((VDB_cnt>0) || ( maxEv_flg==0 ))   begin
      if( (VDB < -1.5) && (VDB_retc!=-1))
      begin
        outfile=$fopen(errFileName,"a");
        $strobe("nhsj1b_8      VDB     leaving   OCA (  .. -1.500 V ) at %7.4r  %M", $abstime );
        $fwrite(outfile,"nhsj1b_8      VDB     leaving   OCA (  .. -1.500 V ) at %7.4r  %M\n", $abstime );
        VDB_retc=-1;
        VDB_cnt=VDB_cnt-1;
        $fclose(outfile);
      end
      if((VDB >= -1.5) &&  (VDB <= 140) && (VDB_retc!=0))
      begin
        outfile=$fopen(errFileName,"a");
        $strobe("nhsj1b_8      VDB     entering SOCA ( -1.500 V .. 140.000 V ) at %7.4r  %M", $abstime );
        $fwrite(outfile,"nhsj1b_8      VDB     entering SOCA ( -1.500 V .. 140.000 V ) at %7.4r  %M\n", $abstime );
        VDB_retc=0;
        VDB_cnt=VDB_cnt-1;
        $fclose(outfile);
      end
      if((VDB > 140) &&  (VDB_retc!=1))
      begin
        outfile=$fopen(errFileName,"a");
        $strobe("nhsj1b_8      VDB     leaving   OCA ( 140.000 V ..  ) at %7.4r  %M", $abstime );
        $fwrite(outfile,"nhsj1b_8      VDB     leaving   OCA ( 140.000 V ..  ) at %7.4r  %M\n", $abstime );
        VDB_retc=1;
        VDB_cnt=VDB_cnt-1;
        $fclose(outfile);
      end
   end
   else
   begin
      if(VDB_cnt==0)
      begin
        outfile=$fopen(errFileName,"a");
        $strobe("nhsj1b_8      VDB     error limit ( %d ) reached at %7.4r  %M", maxEv, $abstime );
        $fwrite(outfile,"nhsj1b_8      VDB     error limit ( %d ) reached at %7.4r  %M\n", maxEv, $abstime );
        VDB_cnt=VDB_cnt-1;
        $fclose(outfile);
      end
   end

//      VDHW
   VDHW = V_D_HW;
   if((VDHW_cnt>0) || ( maxEv_flg==0 ))   begin
      if( (VDHW < -1.5) && (VDHW_retc!=-1))
      begin
        outfile=$fopen(errFileName,"a");
        $strobe("nhsj1b_8      VDHW    leaving   OCA (  .. -1.500 V ) at %7.4r  %M", $abstime );
        $fwrite(outfile,"nhsj1b_8      VDHW    leaving   OCA (  .. -1.500 V ) at %7.4r  %M\n", $abstime );
        VDHW_retc=-1;
        VDHW_cnt=VDHW_cnt-1;
        $fclose(outfile);
      end
      if((VDHW >= -1.5) &&  (VDHW <= 400) && (VDHW_retc!=0))
      begin
        outfile=$fopen(errFileName,"a");
        $strobe("nhsj1b_8      VDHW    entering SOCA ( -1.500 V .. 400.000 V ) at %7.4r  %M", $abstime );
        $fwrite(outfile,"nhsj1b_8      VDHW    entering SOCA ( -1.500 V .. 400.000 V ) at %7.4r  %M\n", $abstime );
        VDHW_retc=0;
        VDHW_cnt=VDHW_cnt-1;
        $fclose(outfile);
      end
      if((VDHW > 400) &&  (VDHW_retc!=1))
      begin
        outfile=$fopen(errFileName,"a");
        $strobe("nhsj1b_8      VDHW    leaving   OCA ( 400.000 V ..  ) at %7.4r  %M", $abstime );
        $fwrite(outfile,"nhsj1b_8      VDHW    leaving   OCA ( 400.000 V ..  ) at %7.4r  %M\n", $abstime );
        VDHW_retc=1;
        VDHW_cnt=VDHW_cnt-1;
        $fclose(outfile);
      end
   end
   else
   begin
      if(VDHW_cnt==0)
      begin
        outfile=$fopen(errFileName,"a");
        $strobe("nhsj1b_8      VDHW    error limit ( %d ) reached at %7.4r  %M", maxEv, $abstime );
        $fwrite(outfile,"nhsj1b_8      VDHW    error limit ( %d ) reached at %7.4r  %M\n", maxEv, $abstime );
        VDHW_cnt=VDHW_cnt-1;
        $fclose(outfile);
      end
   end

end // analog
endmodule // nhsj1b_8

// Verilog-A OC Watch for device nhsj1b_10 Parameters  VGS VGD VDS VDB VDHW
module nhsj1b_10_ahdl(D,G,S,B,HW);
parameter tstep_occ=100n;
parameter errFileName="./occ.err";
parameter maxEv = 25;
parameter maxEv_flg = 0;
inout D,G,S,B,HW;
electrical D,G,S,B,HW;

integer outfile;
real V_D_HW;
real V_D_B;
real V_D_S;
real V_G_D;
real V_G_S;
real VGS;
integer VGS_retc;
integer VGS_cnt;
real VGD;
integer VGD_retc;
integer VGD_cnt;
real VDS;
integer VDS_retc;
integer VDS_cnt;
real VDB;
integer VDB_retc;
integer VDB_cnt;
real VDHW;
integer VDHW_retc;
integer VDHW_cnt;

analog begin
   $bound_step( tstep_occ );
   @(initial_step) begin
      VGS_retc=0;
      VGS_cnt = maxEv;
      VGD_retc=0;
      VGD_cnt = maxEv;
      VDS_retc=0;
      VDS_cnt = maxEv;
      VDB_retc=0;
      VDB_cnt = maxEv;
      VDHW_retc=0;
      VDHW_cnt = maxEv;
   end
   V_D_HW = V(D,HW);
   V_D_B = V(D,B);
   V_D_S = V(D,S);
   V_G_D = V(G,D);
   V_G_S = V(G,S);

//      VGS
   VGS = V_G_S;
   if((VGS_cnt>0) || ( maxEv_flg==0 ))   begin
      if( (VGS < -5.5) && (VGS_retc!=-1))
      begin
        outfile=$fopen(errFileName,"a");
        $strobe("nhsj1b_10     VGS     leaving   OCA (  .. -5.500 V ) at %7.4r  %M", $abstime );
        $fwrite(outfile,"nhsj1b_10     VGS     leaving   OCA (  .. -5.500 V ) at %7.4r  %M\n", $abstime );
        VGS_retc=-1;
        VGS_cnt=VGS_cnt-1;
        $fclose(outfile);
      end
      if((VGS >= -5.5) &&  (VGS <= 5.5) && (VGS_retc!=0))
      begin
        outfile=$fopen(errFileName,"a");
        $strobe("nhsj1b_10     VGS     entering SOCA ( -5.500 V .. 5.500 V ) at %7.4r  %M", $abstime );
        $fwrite(outfile,"nhsj1b_10     VGS     entering SOCA ( -5.500 V .. 5.500 V ) at %7.4r  %M\n", $abstime );
        VGS_retc=0;
        VGS_cnt=VGS_cnt-1;
        $fclose(outfile);
      end
      if((VGS > 5.5) &&  (VGS_retc!=1))
      begin
        outfile=$fopen(errFileName,"a");
        $strobe("nhsj1b_10     VGS     leaving   OCA ( 5.500 V ..  ) at %7.4r  %M", $abstime );
        $fwrite(outfile,"nhsj1b_10     VGS     leaving   OCA ( 5.500 V ..  ) at %7.4r  %M\n", $abstime );
        VGS_retc=1;
        VGS_cnt=VGS_cnt-1;
        $fclose(outfile);
      end
   end
   else
   begin
      if(VGS_cnt==0)
      begin
        outfile=$fopen(errFileName,"a");
        $strobe("nhsj1b_10     VGS     error limit ( %d ) reached at %7.4r  %M", maxEv, $abstime );
        $fwrite(outfile,"nhsj1b_10     VGS     error limit ( %d ) reached at %7.4r  %M\n", maxEv, $abstime );
        VGS_cnt=VGS_cnt-1;
        $fclose(outfile);
      end
   end

//      VGD
   VGD = V_G_D;
   if((VGD_cnt>0) || ( maxEv_flg==0 ))   begin
      if( (VGD < -155) && (VGD_retc!=-1))
      begin
        outfile=$fopen(errFileName,"a");
        $strobe("nhsj1b_10     VGD     leaving   OCA (  .. -155.000 V ) at %7.4r  %M", $abstime );
        $fwrite(outfile,"nhsj1b_10     VGD     leaving   OCA (  .. -155.000 V ) at %7.4r  %M\n", $abstime );
        VGD_retc=-1;
        VGD_cnt=VGD_cnt-1;
        $fclose(outfile);
      end
      if((VGD >= -155) &&  (VGD <= 5.5) && (VGD_retc!=0))
      begin
        outfile=$fopen(errFileName,"a");
        $strobe("nhsj1b_10     VGD     entering SOCA ( -155.000 V .. 5.500 V ) at %7.4r  %M", $abstime );
        $fwrite(outfile,"nhsj1b_10     VGD     entering SOCA ( -155.000 V .. 5.500 V ) at %7.4r  %M\n", $abstime );
        VGD_retc=0;
        VGD_cnt=VGD_cnt-1;
        $fclose(outfile);
      end
      if((VGD > 5.5) &&  (VGD_retc!=1))
      begin
        outfile=$fopen(errFileName,"a");
        $strobe("nhsj1b_10     VGD     leaving   OCA ( 5.500 V ..  ) at %7.4r  %M", $abstime );
        $fwrite(outfile,"nhsj1b_10     VGD     leaving   OCA ( 5.500 V ..  ) at %7.4r  %M\n", $abstime );
        VGD_retc=1;
        VGD_cnt=VGD_cnt-1;
        $fclose(outfile);
      end
   end
   else
   begin
      if(VGD_cnt==0)
      begin
        outfile=$fopen(errFileName,"a");
        $strobe("nhsj1b_10     VGD     error limit ( %d ) reached at %7.4r  %M", maxEv, $abstime );
        $fwrite(outfile,"nhsj1b_10     VGD     error limit ( %d ) reached at %7.4r  %M\n", maxEv, $abstime );
        VGD_cnt=VGD_cnt-1;
        $fclose(outfile);
      end
   end

//      VDS
   VDS = V_D_S;
   if((VDS_cnt>0) || ( maxEv_flg==0 ))   begin
      if( (VDS < -1.5) && (VDS_retc!=-1))
      begin
        outfile=$fopen(errFileName,"a");
        $strobe("nhsj1b_10     VDS     leaving   OCA (  .. -1.500 V ) at %7.4r  %M", $abstime );
        $fwrite(outfile,"nhsj1b_10     VDS     leaving   OCA (  .. -1.500 V ) at %7.4r  %M\n", $abstime );
        VDS_retc=-1;
        VDS_cnt=VDS_cnt-1;
        $fclose(outfile);
      end
      if((VDS >= -1.5) &&  (VDS <= 155) && (VDS_retc!=0))
      begin
        outfile=$fopen(errFileName,"a");
        $strobe("nhsj1b_10     VDS     entering SOCA ( -1.500 V .. 155.000 V ) at %7.4r  %M", $abstime );
        $fwrite(outfile,"nhsj1b_10     VDS     entering SOCA ( -1.500 V .. 155.000 V ) at %7.4r  %M\n", $abstime );
        VDS_retc=0;
        VDS_cnt=VDS_cnt-1;
        $fclose(outfile);
      end
      if((VDS > 155) &&  (VDS_retc!=1))
      begin
        outfile=$fopen(errFileName,"a");
        $strobe("nhsj1b_10     VDS     leaving   OCA ( 155.000 V ..  ) at %7.4r  %M", $abstime );
        $fwrite(outfile,"nhsj1b_10     VDS     leaving   OCA ( 155.000 V ..  ) at %7.4r  %M\n", $abstime );
        VDS_retc=1;
        VDS_cnt=VDS_cnt-1;
        $fclose(outfile);
      end
   end
   else
   begin
      if(VDS_cnt==0)
      begin
        outfile=$fopen(errFileName,"a");
        $strobe("nhsj1b_10     VDS     error limit ( %d ) reached at %7.4r  %M", maxEv, $abstime );
        $fwrite(outfile,"nhsj1b_10     VDS     error limit ( %d ) reached at %7.4r  %M\n", maxEv, $abstime );
        VDS_cnt=VDS_cnt-1;
        $fclose(outfile);
      end
   end

//      VDB
   VDB = V_D_B;
   if((VDB_cnt>0) || ( maxEv_flg==0 ))   begin
      if( (VDB < -1.5) && (VDB_retc!=-1))
      begin
        outfile=$fopen(errFileName,"a");
        $strobe("nhsj1b_10     VDB     leaving   OCA (  .. -1.500 V ) at %7.4r  %M", $abstime );
        $fwrite(outfile,"nhsj1b_10     VDB     leaving   OCA (  .. -1.500 V ) at %7.4r  %M\n", $abstime );
        VDB_retc=-1;
        VDB_cnt=VDB_cnt-1;
        $fclose(outfile);
      end
      if((VDB >= -1.5) &&  (VDB <= 155) && (VDB_retc!=0))
      begin
        outfile=$fopen(errFileName,"a");
        $strobe("nhsj1b_10     VDB     entering SOCA ( -1.500 V .. 155.000 V ) at %7.4r  %M", $abstime );
        $fwrite(outfile,"nhsj1b_10     VDB     entering SOCA ( -1.500 V .. 155.000 V ) at %7.4r  %M\n", $abstime );
        VDB_retc=0;
        VDB_cnt=VDB_cnt-1;
        $fclose(outfile);
      end
      if((VDB > 155) &&  (VDB_retc!=1))
      begin
        outfile=$fopen(errFileName,"a");
        $strobe("nhsj1b_10     VDB     leaving   OCA ( 155.000 V ..  ) at %7.4r  %M", $abstime );
        $fwrite(outfile,"nhsj1b_10     VDB     leaving   OCA ( 155.000 V ..  ) at %7.4r  %M\n", $abstime );
        VDB_retc=1;
        VDB_cnt=VDB_cnt-1;
        $fclose(outfile);
      end
   end
   else
   begin
      if(VDB_cnt==0)
      begin
        outfile=$fopen(errFileName,"a");
        $strobe("nhsj1b_10     VDB     error limit ( %d ) reached at %7.4r  %M", maxEv, $abstime );
        $fwrite(outfile,"nhsj1b_10     VDB     error limit ( %d ) reached at %7.4r  %M\n", maxEv, $abstime );
        VDB_cnt=VDB_cnt-1;
        $fclose(outfile);
      end
   end

//      VDHW
   VDHW = V_D_HW;
   if((VDHW_cnt>0) || ( maxEv_flg==0 ))   begin
      if( (VDHW < -1.5) && (VDHW_retc!=-1))
      begin
        outfile=$fopen(errFileName,"a");
        $strobe("nhsj1b_10     VDHW    leaving   OCA (  .. -1.500 V ) at %7.4r  %M", $abstime );
        $fwrite(outfile,"nhsj1b_10     VDHW    leaving   OCA (  .. -1.500 V ) at %7.4r  %M\n", $abstime );
        VDHW_retc=-1;
        VDHW_cnt=VDHW_cnt-1;
        $fclose(outfile);
      end
      if((VDHW >= -1.5) &&  (VDHW <= 400) && (VDHW_retc!=0))
      begin
        outfile=$fopen(errFileName,"a");
        $strobe("nhsj1b_10     VDHW    entering SOCA ( -1.500 V .. 400.000 V ) at %7.4r  %M", $abstime );
        $fwrite(outfile,"nhsj1b_10     VDHW    entering SOCA ( -1.500 V .. 400.000 V ) at %7.4r  %M\n", $abstime );
        VDHW_retc=0;
        VDHW_cnt=VDHW_cnt-1;
        $fclose(outfile);
      end
      if((VDHW > 400) &&  (VDHW_retc!=1))
      begin
        outfile=$fopen(errFileName,"a");
        $strobe("nhsj1b_10     VDHW    leaving   OCA ( 400.000 V ..  ) at %7.4r  %M", $abstime );
        $fwrite(outfile,"nhsj1b_10     VDHW    leaving   OCA ( 400.000 V ..  ) at %7.4r  %M\n", $abstime );
        VDHW_retc=1;
        VDHW_cnt=VDHW_cnt-1;
        $fclose(outfile);
      end
   end
   else
   begin
      if(VDHW_cnt==0)
      begin
        outfile=$fopen(errFileName,"a");
        $strobe("nhsj1b_10     VDHW    error limit ( %d ) reached at %7.4r  %M", maxEv, $abstime );
        $fwrite(outfile,"nhsj1b_10     VDHW    error limit ( %d ) reached at %7.4r  %M\n", maxEv, $abstime );
        VDHW_cnt=VDHW_cnt-1;
        $fclose(outfile);
      end
   end

end // analog
endmodule // nhsj1b_10

// Verilog-A OC Watch for device nhsj1a_13 Parameters  VGS VGD VDS VDB VDHW
module nhsj1a_13_ahdl(D,G,S,B,HW);
parameter tstep_occ=100n;
parameter errFileName="./occ.err";
parameter maxEv = 25;
parameter maxEv_flg = 0;
inout D,G,S,B,HW;
electrical D,G,S,B,HW;

integer outfile;
real V_D_HW;
real V_D_B;
real V_D_S;
real V_G_D;
real V_G_S;
real VGS;
integer VGS_retc;
integer VGS_cnt;
real VGD;
integer VGD_retc;
integer VGD_cnt;
real VDS;
integer VDS_retc;
integer VDS_cnt;
real VDB;
integer VDB_retc;
integer VDB_cnt;
real VDHW;
integer VDHW_retc;
integer VDHW_cnt;

analog begin
   $bound_step( tstep_occ );
   @(initial_step) begin
      VGS_retc=0;
      VGS_cnt = maxEv;
      VGD_retc=0;
      VGD_cnt = maxEv;
      VDS_retc=0;
      VDS_cnt = maxEv;
      VDB_retc=0;
      VDB_cnt = maxEv;
      VDHW_retc=0;
      VDHW_cnt = maxEv;
   end
   V_D_HW = V(D,HW);
   V_D_B = V(D,B);
   V_D_S = V(D,S);
   V_G_D = V(G,D);
   V_G_S = V(G,S);

//      VGS
   VGS = V_G_S;
   if((VGS_cnt>0) || ( maxEv_flg==0 ))   begin
      if( (VGS < -5.5) && (VGS_retc!=-1))
      begin
        outfile=$fopen(errFileName,"a");
        $strobe("nhsj1a_13     VGS     leaving   OCA (  .. -5.500 V ) at %7.4r  %M", $abstime );
        $fwrite(outfile,"nhsj1a_13     VGS     leaving   OCA (  .. -5.500 V ) at %7.4r  %M\n", $abstime );
        VGS_retc=-1;
        VGS_cnt=VGS_cnt-1;
        $fclose(outfile);
      end
      if((VGS >= -5.5) &&  (VGS <= 5.5) && (VGS_retc!=0))
      begin
        outfile=$fopen(errFileName,"a");
        $strobe("nhsj1a_13     VGS     entering SOCA ( -5.500 V .. 5.500 V ) at %7.4r  %M", $abstime );
        $fwrite(outfile,"nhsj1a_13     VGS     entering SOCA ( -5.500 V .. 5.500 V ) at %7.4r  %M\n", $abstime );
        VGS_retc=0;
        VGS_cnt=VGS_cnt-1;
        $fclose(outfile);
      end
      if((VGS > 5.5) &&  (VGS_retc!=1))
      begin
        outfile=$fopen(errFileName,"a");
        $strobe("nhsj1a_13     VGS     leaving   OCA ( 5.500 V ..  ) at %7.4r  %M", $abstime );
        $fwrite(outfile,"nhsj1a_13     VGS     leaving   OCA ( 5.500 V ..  ) at %7.4r  %M\n", $abstime );
        VGS_retc=1;
        VGS_cnt=VGS_cnt-1;
        $fclose(outfile);
      end
   end
   else
   begin
      if(VGS_cnt==0)
      begin
        outfile=$fopen(errFileName,"a");
        $strobe("nhsj1a_13     VGS     error limit ( %d ) reached at %7.4r  %M", maxEv, $abstime );
        $fwrite(outfile,"nhsj1a_13     VGS     error limit ( %d ) reached at %7.4r  %M\n", maxEv, $abstime );
        VGS_cnt=VGS_cnt-1;
        $fclose(outfile);
      end
   end

//      VGD
   VGD = V_G_D;
   if((VGD_cnt>0) || ( maxEv_flg==0 ))   begin
      if( (VGD < -195) && (VGD_retc!=-1))
      begin
        outfile=$fopen(errFileName,"a");
        $strobe("nhsj1a_13     VGD     leaving   OCA (  .. -195.000 V ) at %7.4r  %M", $abstime );
        $fwrite(outfile,"nhsj1a_13     VGD     leaving   OCA (  .. -195.000 V ) at %7.4r  %M\n", $abstime );
        VGD_retc=-1;
        VGD_cnt=VGD_cnt-1;
        $fclose(outfile);
      end
      if((VGD >= -195) &&  (VGD <= 5.5) && (VGD_retc!=0))
      begin
        outfile=$fopen(errFileName,"a");
        $strobe("nhsj1a_13     VGD     entering SOCA ( -195.000 V .. 5.500 V ) at %7.4r  %M", $abstime );
        $fwrite(outfile,"nhsj1a_13     VGD     entering SOCA ( -195.000 V .. 5.500 V ) at %7.4r  %M\n", $abstime );
        VGD_retc=0;
        VGD_cnt=VGD_cnt-1;
        $fclose(outfile);
      end
      if((VGD > 5.5) &&  (VGD_retc!=1))
      begin
        outfile=$fopen(errFileName,"a");
        $strobe("nhsj1a_13     VGD     leaving   OCA ( 5.500 V ..  ) at %7.4r  %M", $abstime );
        $fwrite(outfile,"nhsj1a_13     VGD     leaving   OCA ( 5.500 V ..  ) at %7.4r  %M\n", $abstime );
        VGD_retc=1;
        VGD_cnt=VGD_cnt-1;
        $fclose(outfile);
      end
   end
   else
   begin
      if(VGD_cnt==0)
      begin
        outfile=$fopen(errFileName,"a");
        $strobe("nhsj1a_13     VGD     error limit ( %d ) reached at %7.4r  %M", maxEv, $abstime );
        $fwrite(outfile,"nhsj1a_13     VGD     error limit ( %d ) reached at %7.4r  %M\n", maxEv, $abstime );
        VGD_cnt=VGD_cnt-1;
        $fclose(outfile);
      end
   end

//      VDS
   VDS = V_D_S;
   if((VDS_cnt>0) || ( maxEv_flg==0 ))   begin
      if( (VDS < -1.5) && (VDS_retc!=-1))
      begin
        outfile=$fopen(errFileName,"a");
        $strobe("nhsj1a_13     VDS     leaving   OCA (  .. -1.500 V ) at %7.4r  %M", $abstime );
        $fwrite(outfile,"nhsj1a_13     VDS     leaving   OCA (  .. -1.500 V ) at %7.4r  %M\n", $abstime );
        VDS_retc=-1;
        VDS_cnt=VDS_cnt-1;
        $fclose(outfile);
      end
      if((VDS >= -1.5) &&  (VDS <= 195) && (VDS_retc!=0))
      begin
        outfile=$fopen(errFileName,"a");
        $strobe("nhsj1a_13     VDS     entering SOCA ( -1.500 V .. 195.000 V ) at %7.4r  %M", $abstime );
        $fwrite(outfile,"nhsj1a_13     VDS     entering SOCA ( -1.500 V .. 195.000 V ) at %7.4r  %M\n", $abstime );
        VDS_retc=0;
        VDS_cnt=VDS_cnt-1;
        $fclose(outfile);
      end
      if((VDS > 195) &&  (VDS_retc!=1))
      begin
        outfile=$fopen(errFileName,"a");
        $strobe("nhsj1a_13     VDS     leaving   OCA ( 195.000 V ..  ) at %7.4r  %M", $abstime );
        $fwrite(outfile,"nhsj1a_13     VDS     leaving   OCA ( 195.000 V ..  ) at %7.4r  %M\n", $abstime );
        VDS_retc=1;
        VDS_cnt=VDS_cnt-1;
        $fclose(outfile);
      end
   end
   else
   begin
      if(VDS_cnt==0)
      begin
        outfile=$fopen(errFileName,"a");
        $strobe("nhsj1a_13     VDS     error limit ( %d ) reached at %7.4r  %M", maxEv, $abstime );
        $fwrite(outfile,"nhsj1a_13     VDS     error limit ( %d ) reached at %7.4r  %M\n", maxEv, $abstime );
        VDS_cnt=VDS_cnt-1;
        $fclose(outfile);
      end
   end

//      VDB
   VDB = V_D_B;
   if((VDB_cnt>0) || ( maxEv_flg==0 ))   begin
      if( (VDB < -1.5) && (VDB_retc!=-1))
      begin
        outfile=$fopen(errFileName,"a");
        $strobe("nhsj1a_13     VDB     leaving   OCA (  .. -1.500 V ) at %7.4r  %M", $abstime );
        $fwrite(outfile,"nhsj1a_13     VDB     leaving   OCA (  .. -1.500 V ) at %7.4r  %M\n", $abstime );
        VDB_retc=-1;
        VDB_cnt=VDB_cnt-1;
        $fclose(outfile);
      end
      if((VDB >= -1.5) &&  (VDB <= 195) && (VDB_retc!=0))
      begin
        outfile=$fopen(errFileName,"a");
        $strobe("nhsj1a_13     VDB     entering SOCA ( -1.500 V .. 195.000 V ) at %7.4r  %M", $abstime );
        $fwrite(outfile,"nhsj1a_13     VDB     entering SOCA ( -1.500 V .. 195.000 V ) at %7.4r  %M\n", $abstime );
        VDB_retc=0;
        VDB_cnt=VDB_cnt-1;
        $fclose(outfile);
      end
      if((VDB > 195) &&  (VDB_retc!=1))
      begin
        outfile=$fopen(errFileName,"a");
        $strobe("nhsj1a_13     VDB     leaving   OCA ( 195.000 V ..  ) at %7.4r  %M", $abstime );
        $fwrite(outfile,"nhsj1a_13     VDB     leaving   OCA ( 195.000 V ..  ) at %7.4r  %M\n", $abstime );
        VDB_retc=1;
        VDB_cnt=VDB_cnt-1;
        $fclose(outfile);
      end
   end
   else
   begin
      if(VDB_cnt==0)
      begin
        outfile=$fopen(errFileName,"a");
        $strobe("nhsj1a_13     VDB     error limit ( %d ) reached at %7.4r  %M", maxEv, $abstime );
        $fwrite(outfile,"nhsj1a_13     VDB     error limit ( %d ) reached at %7.4r  %M\n", maxEv, $abstime );
        VDB_cnt=VDB_cnt-1;
        $fclose(outfile);
      end
   end

//      VDHW
   VDHW = V_D_HW;
   if((VDHW_cnt>0) || ( maxEv_flg==0 ))   begin
      if( (VDHW < -1.5) && (VDHW_retc!=-1))
      begin
        outfile=$fopen(errFileName,"a");
        $strobe("nhsj1a_13     VDHW    leaving   OCA (  .. -1.500 V ) at %7.4r  %M", $abstime );
        $fwrite(outfile,"nhsj1a_13     VDHW    leaving   OCA (  .. -1.500 V ) at %7.4r  %M\n", $abstime );
        VDHW_retc=-1;
        VDHW_cnt=VDHW_cnt-1;
        $fclose(outfile);
      end
      if((VDHW >= -1.5) &&  (VDHW <= 400) && (VDHW_retc!=0))
      begin
        outfile=$fopen(errFileName,"a");
        $strobe("nhsj1a_13     VDHW    entering SOCA ( -1.500 V .. 400.000 V ) at %7.4r  %M", $abstime );
        $fwrite(outfile,"nhsj1a_13     VDHW    entering SOCA ( -1.500 V .. 400.000 V ) at %7.4r  %M\n", $abstime );
        VDHW_retc=0;
        VDHW_cnt=VDHW_cnt-1;
        $fclose(outfile);
      end
      if((VDHW > 400) &&  (VDHW_retc!=1))
      begin
        outfile=$fopen(errFileName,"a");
        $strobe("nhsj1a_13     VDHW    leaving   OCA ( 400.000 V ..  ) at %7.4r  %M", $abstime );
        $fwrite(outfile,"nhsj1a_13     VDHW    leaving   OCA ( 400.000 V ..  ) at %7.4r  %M\n", $abstime );
        VDHW_retc=1;
        VDHW_cnt=VDHW_cnt-1;
        $fclose(outfile);
      end
   end
   else
   begin
      if(VDHW_cnt==0)
      begin
        outfile=$fopen(errFileName,"a");
        $strobe("nhsj1a_13     VDHW    error limit ( %d ) reached at %7.4r  %M", maxEv, $abstime );
        $fwrite(outfile,"nhsj1a_13     VDHW    error limit ( %d ) reached at %7.4r  %M\n", maxEv, $abstime );
        VDHW_cnt=VDHW_cnt-1;
        $fclose(outfile);
      end
   end

end // analog
endmodule // nhsj1a_13

// Verilog-A OC Watch for device nhsj1a_16 Parameters  VGS VGD VDS VDB VDHW
module nhsj1a_16_ahdl(D,G,S,B,HW);
parameter tstep_occ=100n;
parameter errFileName="./occ.err";
parameter maxEv = 25;
parameter maxEv_flg = 0;
inout D,G,S,B,HW;
electrical D,G,S,B,HW;

integer outfile;
real V_D_HW;
real V_D_B;
real V_D_S;
real V_G_D;
real V_G_S;
real VGS;
integer VGS_retc;
integer VGS_cnt;
real VGD;
integer VGD_retc;
integer VGD_cnt;
real VDS;
integer VDS_retc;
integer VDS_cnt;
real VDB;
integer VDB_retc;
integer VDB_cnt;
real VDHW;
integer VDHW_retc;
integer VDHW_cnt;

analog begin
   $bound_step( tstep_occ );
   @(initial_step) begin
      VGS_retc=0;
      VGS_cnt = maxEv;
      VGD_retc=0;
      VGD_cnt = maxEv;
      VDS_retc=0;
      VDS_cnt = maxEv;
      VDB_retc=0;
      VDB_cnt = maxEv;
      VDHW_retc=0;
      VDHW_cnt = maxEv;
   end
   V_D_HW = V(D,HW);
   V_D_B = V(D,B);
   V_D_S = V(D,S);
   V_G_D = V(G,D);
   V_G_S = V(G,S);

//      VGS
   VGS = V_G_S;
   if((VGS_cnt>0) || ( maxEv_flg==0 ))   begin
      if( (VGS < -5.5) && (VGS_retc!=-1))
      begin
        outfile=$fopen(errFileName,"a");
        $strobe("nhsj1a_16     VGS     leaving   OCA (  .. -5.500 V ) at %7.4r  %M", $abstime );
        $fwrite(outfile,"nhsj1a_16     VGS     leaving   OCA (  .. -5.500 V ) at %7.4r  %M\n", $abstime );
        VGS_retc=-1;
        VGS_cnt=VGS_cnt-1;
        $fclose(outfile);
      end
      if((VGS >= -5.5) &&  (VGS <= 5.5) && (VGS_retc!=0))
      begin
        outfile=$fopen(errFileName,"a");
        $strobe("nhsj1a_16     VGS     entering SOCA ( -5.500 V .. 5.500 V ) at %7.4r  %M", $abstime );
        $fwrite(outfile,"nhsj1a_16     VGS     entering SOCA ( -5.500 V .. 5.500 V ) at %7.4r  %M\n", $abstime );
        VGS_retc=0;
        VGS_cnt=VGS_cnt-1;
        $fclose(outfile);
      end
      if((VGS > 5.5) &&  (VGS_retc!=1))
      begin
        outfile=$fopen(errFileName,"a");
        $strobe("nhsj1a_16     VGS     leaving   OCA ( 5.500 V ..  ) at %7.4r  %M", $abstime );
        $fwrite(outfile,"nhsj1a_16     VGS     leaving   OCA ( 5.500 V ..  ) at %7.4r  %M\n", $abstime );
        VGS_retc=1;
        VGS_cnt=VGS_cnt-1;
        $fclose(outfile);
      end
   end
   else
   begin
      if(VGS_cnt==0)
      begin
        outfile=$fopen(errFileName,"a");
        $strobe("nhsj1a_16     VGS     error limit ( %d ) reached at %7.4r  %M", maxEv, $abstime );
        $fwrite(outfile,"nhsj1a_16     VGS     error limit ( %d ) reached at %7.4r  %M\n", maxEv, $abstime );
        VGS_cnt=VGS_cnt-1;
        $fclose(outfile);
      end
   end

//      VGD
   VGD = V_G_D;
   if((VGD_cnt>0) || ( maxEv_flg==0 ))   begin
      if( (VGD < -235) && (VGD_retc!=-1))
      begin
        outfile=$fopen(errFileName,"a");
        $strobe("nhsj1a_16     VGD     leaving   OCA (  .. -235.000 V ) at %7.4r  %M", $abstime );
        $fwrite(outfile,"nhsj1a_16     VGD     leaving   OCA (  .. -235.000 V ) at %7.4r  %M\n", $abstime );
        VGD_retc=-1;
        VGD_cnt=VGD_cnt-1;
        $fclose(outfile);
      end
      if((VGD >= -235) &&  (VGD <= 5.5) && (VGD_retc!=0))
      begin
        outfile=$fopen(errFileName,"a");
        $strobe("nhsj1a_16     VGD     entering SOCA ( -235.000 V .. 5.500 V ) at %7.4r  %M", $abstime );
        $fwrite(outfile,"nhsj1a_16     VGD     entering SOCA ( -235.000 V .. 5.500 V ) at %7.4r  %M\n", $abstime );
        VGD_retc=0;
        VGD_cnt=VGD_cnt-1;
        $fclose(outfile);
      end
      if((VGD > 5.5) &&  (VGD_retc!=1))
      begin
        outfile=$fopen(errFileName,"a");
        $strobe("nhsj1a_16     VGD     leaving   OCA ( 5.500 V ..  ) at %7.4r  %M", $abstime );
        $fwrite(outfile,"nhsj1a_16     VGD     leaving   OCA ( 5.500 V ..  ) at %7.4r  %M\n", $abstime );
        VGD_retc=1;
        VGD_cnt=VGD_cnt-1;
        $fclose(outfile);
      end
   end
   else
   begin
      if(VGD_cnt==0)
      begin
        outfile=$fopen(errFileName,"a");
        $strobe("nhsj1a_16     VGD     error limit ( %d ) reached at %7.4r  %M", maxEv, $abstime );
        $fwrite(outfile,"nhsj1a_16     VGD     error limit ( %d ) reached at %7.4r  %M\n", maxEv, $abstime );
        VGD_cnt=VGD_cnt-1;
        $fclose(outfile);
      end
   end

//      VDS
   VDS = V_D_S;
   if((VDS_cnt>0) || ( maxEv_flg==0 ))   begin
      if( (VDS < -1.5) && (VDS_retc!=-1))
      begin
        outfile=$fopen(errFileName,"a");
        $strobe("nhsj1a_16     VDS     leaving   OCA (  .. -1.500 V ) at %7.4r  %M", $abstime );
        $fwrite(outfile,"nhsj1a_16     VDS     leaving   OCA (  .. -1.500 V ) at %7.4r  %M\n", $abstime );
        VDS_retc=-1;
        VDS_cnt=VDS_cnt-1;
        $fclose(outfile);
      end
      if((VDS >= -1.5) &&  (VDS <= 235) && (VDS_retc!=0))
      begin
        outfile=$fopen(errFileName,"a");
        $strobe("nhsj1a_16     VDS     entering SOCA ( -1.500 V .. 235.000 V ) at %7.4r  %M", $abstime );
        $fwrite(outfile,"nhsj1a_16     VDS     entering SOCA ( -1.500 V .. 235.000 V ) at %7.4r  %M\n", $abstime );
        VDS_retc=0;
        VDS_cnt=VDS_cnt-1;
        $fclose(outfile);
      end
      if((VDS > 235) &&  (VDS_retc!=1))
      begin
        outfile=$fopen(errFileName,"a");
        $strobe("nhsj1a_16     VDS     leaving   OCA ( 235.000 V ..  ) at %7.4r  %M", $abstime );
        $fwrite(outfile,"nhsj1a_16     VDS     leaving   OCA ( 235.000 V ..  ) at %7.4r  %M\n", $abstime );
        VDS_retc=1;
        VDS_cnt=VDS_cnt-1;
        $fclose(outfile);
      end
   end
   else
   begin
      if(VDS_cnt==0)
      begin
        outfile=$fopen(errFileName,"a");
        $strobe("nhsj1a_16     VDS     error limit ( %d ) reached at %7.4r  %M", maxEv, $abstime );
        $fwrite(outfile,"nhsj1a_16     VDS     error limit ( %d ) reached at %7.4r  %M\n", maxEv, $abstime );
        VDS_cnt=VDS_cnt-1;
        $fclose(outfile);
      end
   end

//      VDB
   VDB = V_D_B;
   if((VDB_cnt>0) || ( maxEv_flg==0 ))   begin
      if( (VDB < -1.5) && (VDB_retc!=-1))
      begin
        outfile=$fopen(errFileName,"a");
        $strobe("nhsj1a_16     VDB     leaving   OCA (  .. -1.500 V ) at %7.4r  %M", $abstime );
        $fwrite(outfile,"nhsj1a_16     VDB     leaving   OCA (  .. -1.500 V ) at %7.4r  %M\n", $abstime );
        VDB_retc=-1;
        VDB_cnt=VDB_cnt-1;
        $fclose(outfile);
      end
      if((VDB >= -1.5) &&  (VDB <= 235) && (VDB_retc!=0))
      begin
        outfile=$fopen(errFileName,"a");
        $strobe("nhsj1a_16     VDB     entering SOCA ( -1.500 V .. 235.000 V ) at %7.4r  %M", $abstime );
        $fwrite(outfile,"nhsj1a_16     VDB     entering SOCA ( -1.500 V .. 235.000 V ) at %7.4r  %M\n", $abstime );
        VDB_retc=0;
        VDB_cnt=VDB_cnt-1;
        $fclose(outfile);
      end
      if((VDB > 235) &&  (VDB_retc!=1))
      begin
        outfile=$fopen(errFileName,"a");
        $strobe("nhsj1a_16     VDB     leaving   OCA ( 235.000 V ..  ) at %7.4r  %M", $abstime );
        $fwrite(outfile,"nhsj1a_16     VDB     leaving   OCA ( 235.000 V ..  ) at %7.4r  %M\n", $abstime );
        VDB_retc=1;
        VDB_cnt=VDB_cnt-1;
        $fclose(outfile);
      end
   end
   else
   begin
      if(VDB_cnt==0)
      begin
        outfile=$fopen(errFileName,"a");
        $strobe("nhsj1a_16     VDB     error limit ( %d ) reached at %7.4r  %M", maxEv, $abstime );
        $fwrite(outfile,"nhsj1a_16     VDB     error limit ( %d ) reached at %7.4r  %M\n", maxEv, $abstime );
        VDB_cnt=VDB_cnt-1;
        $fclose(outfile);
      end
   end

//      VDHW
   VDHW = V_D_HW;
   if((VDHW_cnt>0) || ( maxEv_flg==0 ))   begin
      if( (VDHW < -1.5) && (VDHW_retc!=-1))
      begin
        outfile=$fopen(errFileName,"a");
        $strobe("nhsj1a_16     VDHW    leaving   OCA (  .. -1.500 V ) at %7.4r  %M", $abstime );
        $fwrite(outfile,"nhsj1a_16     VDHW    leaving   OCA (  .. -1.500 V ) at %7.4r  %M\n", $abstime );
        VDHW_retc=-1;
        VDHW_cnt=VDHW_cnt-1;
        $fclose(outfile);
      end
      if((VDHW >= -1.5) &&  (VDHW <= 400) && (VDHW_retc!=0))
      begin
        outfile=$fopen(errFileName,"a");
        $strobe("nhsj1a_16     VDHW    entering SOCA ( -1.500 V .. 400.000 V ) at %7.4r  %M", $abstime );
        $fwrite(outfile,"nhsj1a_16     VDHW    entering SOCA ( -1.500 V .. 400.000 V ) at %7.4r  %M\n", $abstime );
        VDHW_retc=0;
        VDHW_cnt=VDHW_cnt-1;
        $fclose(outfile);
      end
      if((VDHW > 400) &&  (VDHW_retc!=1))
      begin
        outfile=$fopen(errFileName,"a");
        $strobe("nhsj1a_16     VDHW    leaving   OCA ( 400.000 V ..  ) at %7.4r  %M", $abstime );
        $fwrite(outfile,"nhsj1a_16     VDHW    leaving   OCA ( 400.000 V ..  ) at %7.4r  %M\n", $abstime );
        VDHW_retc=1;
        VDHW_cnt=VDHW_cnt-1;
        $fclose(outfile);
      end
   end
   else
   begin
      if(VDHW_cnt==0)
      begin
        outfile=$fopen(errFileName,"a");
        $strobe("nhsj1a_16     VDHW    error limit ( %d ) reached at %7.4r  %M", maxEv, $abstime );
        $fwrite(outfile,"nhsj1a_16     VDHW    error limit ( %d ) reached at %7.4r  %M\n", maxEv, $abstime );
        VDHW_cnt=VDHW_cnt-1;
        $fclose(outfile);
      end
   end

end // analog
endmodule // nhsj1a_16

// Verilog-A OC Watch for device nhsj1a_20 Parameters  VGS VGD VDS VDB VDHW
module nhsj1a_20_ahdl(D,G,S,B,HW);
parameter tstep_occ=100n;
parameter errFileName="./occ.err";
parameter maxEv = 25;
parameter maxEv_flg = 0;
inout D,G,S,B,HW;
electrical D,G,S,B,HW;

integer outfile;
real V_D_HW;
real V_D_B;
real V_D_S;
real V_G_D;
real V_G_S;
real VGS;
integer VGS_retc;
integer VGS_cnt;
real VGD;
integer VGD_retc;
integer VGD_cnt;
real VDS;
integer VDS_retc;
integer VDS_cnt;
real VDB;
integer VDB_retc;
integer VDB_cnt;
real VDHW;
integer VDHW_retc;
integer VDHW_cnt;

analog begin
   $bound_step( tstep_occ );
   @(initial_step) begin
      VGS_retc=0;
      VGS_cnt = maxEv;
      VGD_retc=0;
      VGD_cnt = maxEv;
      VDS_retc=0;
      VDS_cnt = maxEv;
      VDB_retc=0;
      VDB_cnt = maxEv;
      VDHW_retc=0;
      VDHW_cnt = maxEv;
   end
   V_D_HW = V(D,HW);
   V_D_B = V(D,B);
   V_D_S = V(D,S);
   V_G_D = V(G,D);
   V_G_S = V(G,S);

//      VGS
   VGS = V_G_S;
   if((VGS_cnt>0) || ( maxEv_flg==0 ))   begin
      if( (VGS < -5.5) && (VGS_retc!=-1))
      begin
        outfile=$fopen(errFileName,"a");
        $strobe("nhsj1a_20     VGS     leaving   OCA (  .. -5.500 V ) at %7.4r  %M", $abstime );
        $fwrite(outfile,"nhsj1a_20     VGS     leaving   OCA (  .. -5.500 V ) at %7.4r  %M\n", $abstime );
        VGS_retc=-1;
        VGS_cnt=VGS_cnt-1;
        $fclose(outfile);
      end
      if((VGS >= -5.5) &&  (VGS <= 5.5) && (VGS_retc!=0))
      begin
        outfile=$fopen(errFileName,"a");
        $strobe("nhsj1a_20     VGS     entering SOCA ( -5.500 V .. 5.500 V ) at %7.4r  %M", $abstime );
        $fwrite(outfile,"nhsj1a_20     VGS     entering SOCA ( -5.500 V .. 5.500 V ) at %7.4r  %M\n", $abstime );
        VGS_retc=0;
        VGS_cnt=VGS_cnt-1;
        $fclose(outfile);
      end
      if((VGS > 5.5) &&  (VGS_retc!=1))
      begin
        outfile=$fopen(errFileName,"a");
        $strobe("nhsj1a_20     VGS     leaving   OCA ( 5.500 V ..  ) at %7.4r  %M", $abstime );
        $fwrite(outfile,"nhsj1a_20     VGS     leaving   OCA ( 5.500 V ..  ) at %7.4r  %M\n", $abstime );
        VGS_retc=1;
        VGS_cnt=VGS_cnt-1;
        $fclose(outfile);
      end
   end
   else
   begin
      if(VGS_cnt==0)
      begin
        outfile=$fopen(errFileName,"a");
        $strobe("nhsj1a_20     VGS     error limit ( %d ) reached at %7.4r  %M", maxEv, $abstime );
        $fwrite(outfile,"nhsj1a_20     VGS     error limit ( %d ) reached at %7.4r  %M\n", maxEv, $abstime );
        VGS_cnt=VGS_cnt-1;
        $fclose(outfile);
      end
   end

//      VGD
   VGD = V_G_D;
   if((VGD_cnt>0) || ( maxEv_flg==0 ))   begin
      if( (VGD < -290) && (VGD_retc!=-1))
      begin
        outfile=$fopen(errFileName,"a");
        $strobe("nhsj1a_20     VGD     leaving   OCA (  .. -290.000 V ) at %7.4r  %M", $abstime );
        $fwrite(outfile,"nhsj1a_20     VGD     leaving   OCA (  .. -290.000 V ) at %7.4r  %M\n", $abstime );
        VGD_retc=-1;
        VGD_cnt=VGD_cnt-1;
        $fclose(outfile);
      end
      if((VGD >= -290) &&  (VGD <= 5.5) && (VGD_retc!=0))
      begin
        outfile=$fopen(errFileName,"a");
        $strobe("nhsj1a_20     VGD     entering SOCA ( -290.000 V .. 5.500 V ) at %7.4r  %M", $abstime );
        $fwrite(outfile,"nhsj1a_20     VGD     entering SOCA ( -290.000 V .. 5.500 V ) at %7.4r  %M\n", $abstime );
        VGD_retc=0;
        VGD_cnt=VGD_cnt-1;
        $fclose(outfile);
      end
      if((VGD > 5.5) &&  (VGD_retc!=1))
      begin
        outfile=$fopen(errFileName,"a");
        $strobe("nhsj1a_20     VGD     leaving   OCA ( 5.500 V ..  ) at %7.4r  %M", $abstime );
        $fwrite(outfile,"nhsj1a_20     VGD     leaving   OCA ( 5.500 V ..  ) at %7.4r  %M\n", $abstime );
        VGD_retc=1;
        VGD_cnt=VGD_cnt-1;
        $fclose(outfile);
      end
   end
   else
   begin
      if(VGD_cnt==0)
      begin
        outfile=$fopen(errFileName,"a");
        $strobe("nhsj1a_20     VGD     error limit ( %d ) reached at %7.4r  %M", maxEv, $abstime );
        $fwrite(outfile,"nhsj1a_20     VGD     error limit ( %d ) reached at %7.4r  %M\n", maxEv, $abstime );
        VGD_cnt=VGD_cnt-1;
        $fclose(outfile);
      end
   end

//      VDS
   VDS = V_D_S;
   if((VDS_cnt>0) || ( maxEv_flg==0 ))   begin
      if( (VDS < -1.5) && (VDS_retc!=-1))
      begin
        outfile=$fopen(errFileName,"a");
        $strobe("nhsj1a_20     VDS     leaving   OCA (  .. -1.500 V ) at %7.4r  %M", $abstime );
        $fwrite(outfile,"nhsj1a_20     VDS     leaving   OCA (  .. -1.500 V ) at %7.4r  %M\n", $abstime );
        VDS_retc=-1;
        VDS_cnt=VDS_cnt-1;
        $fclose(outfile);
      end
      if((VDS >= -1.5) &&  (VDS <= 290) && (VDS_retc!=0))
      begin
        outfile=$fopen(errFileName,"a");
        $strobe("nhsj1a_20     VDS     entering SOCA ( -1.500 V .. 290.000 V ) at %7.4r  %M", $abstime );
        $fwrite(outfile,"nhsj1a_20     VDS     entering SOCA ( -1.500 V .. 290.000 V ) at %7.4r  %M\n", $abstime );
        VDS_retc=0;
        VDS_cnt=VDS_cnt-1;
        $fclose(outfile);
      end
      if((VDS > 290) &&  (VDS_retc!=1))
      begin
        outfile=$fopen(errFileName,"a");
        $strobe("nhsj1a_20     VDS     leaving   OCA ( 290.000 V ..  ) at %7.4r  %M", $abstime );
        $fwrite(outfile,"nhsj1a_20     VDS     leaving   OCA ( 290.000 V ..  ) at %7.4r  %M\n", $abstime );
        VDS_retc=1;
        VDS_cnt=VDS_cnt-1;
        $fclose(outfile);
      end
   end
   else
   begin
      if(VDS_cnt==0)
      begin
        outfile=$fopen(errFileName,"a");
        $strobe("nhsj1a_20     VDS     error limit ( %d ) reached at %7.4r  %M", maxEv, $abstime );
        $fwrite(outfile,"nhsj1a_20     VDS     error limit ( %d ) reached at %7.4r  %M\n", maxEv, $abstime );
        VDS_cnt=VDS_cnt-1;
        $fclose(outfile);
      end
   end

//      VDB
   VDB = V_D_B;
   if((VDB_cnt>0) || ( maxEv_flg==0 ))   begin
      if( (VDB < -1.5) && (VDB_retc!=-1))
      begin
        outfile=$fopen(errFileName,"a");
        $strobe("nhsj1a_20     VDB     leaving   OCA (  .. -1.500 V ) at %7.4r  %M", $abstime );
        $fwrite(outfile,"nhsj1a_20     VDB     leaving   OCA (  .. -1.500 V ) at %7.4r  %M\n", $abstime );
        VDB_retc=-1;
        VDB_cnt=VDB_cnt-1;
        $fclose(outfile);
      end
      if((VDB >= -1.5) &&  (VDB <= 290) && (VDB_retc!=0))
      begin
        outfile=$fopen(errFileName,"a");
        $strobe("nhsj1a_20     VDB     entering SOCA ( -1.500 V .. 290.000 V ) at %7.4r  %M", $abstime );
        $fwrite(outfile,"nhsj1a_20     VDB     entering SOCA ( -1.500 V .. 290.000 V ) at %7.4r  %M\n", $abstime );
        VDB_retc=0;
        VDB_cnt=VDB_cnt-1;
        $fclose(outfile);
      end
      if((VDB > 290) &&  (VDB_retc!=1))
      begin
        outfile=$fopen(errFileName,"a");
        $strobe("nhsj1a_20     VDB     leaving   OCA ( 290.000 V ..  ) at %7.4r  %M", $abstime );
        $fwrite(outfile,"nhsj1a_20     VDB     leaving   OCA ( 290.000 V ..  ) at %7.4r  %M\n", $abstime );
        VDB_retc=1;
        VDB_cnt=VDB_cnt-1;
        $fclose(outfile);
      end
   end
   else
   begin
      if(VDB_cnt==0)
      begin
        outfile=$fopen(errFileName,"a");
        $strobe("nhsj1a_20     VDB     error limit ( %d ) reached at %7.4r  %M", maxEv, $abstime );
        $fwrite(outfile,"nhsj1a_20     VDB     error limit ( %d ) reached at %7.4r  %M\n", maxEv, $abstime );
        VDB_cnt=VDB_cnt-1;
        $fclose(outfile);
      end
   end

//      VDHW
   VDHW = V_D_HW;
   if((VDHW_cnt>0) || ( maxEv_flg==0 ))   begin
      if( (VDHW < -1.5) && (VDHW_retc!=-1))
      begin
        outfile=$fopen(errFileName,"a");
        $strobe("nhsj1a_20     VDHW    leaving   OCA (  .. -1.500 V ) at %7.4r  %M", $abstime );
        $fwrite(outfile,"nhsj1a_20     VDHW    leaving   OCA (  .. -1.500 V ) at %7.4r  %M\n", $abstime );
        VDHW_retc=-1;
        VDHW_cnt=VDHW_cnt-1;
        $fclose(outfile);
      end
      if((VDHW >= -1.5) &&  (VDHW <= 400) && (VDHW_retc!=0))
      begin
        outfile=$fopen(errFileName,"a");
        $strobe("nhsj1a_20     VDHW    entering SOCA ( -1.500 V .. 400.000 V ) at %7.4r  %M", $abstime );
        $fwrite(outfile,"nhsj1a_20     VDHW    entering SOCA ( -1.500 V .. 400.000 V ) at %7.4r  %M\n", $abstime );
        VDHW_retc=0;
        VDHW_cnt=VDHW_cnt-1;
        $fclose(outfile);
      end
      if((VDHW > 400) &&  (VDHW_retc!=1))
      begin
        outfile=$fopen(errFileName,"a");
        $strobe("nhsj1a_20     VDHW    leaving   OCA ( 400.000 V ..  ) at %7.4r  %M", $abstime );
        $fwrite(outfile,"nhsj1a_20     VDHW    leaving   OCA ( 400.000 V ..  ) at %7.4r  %M\n", $abstime );
        VDHW_retc=1;
        VDHW_cnt=VDHW_cnt-1;
        $fclose(outfile);
      end
   end
   else
   begin
      if(VDHW_cnt==0)
      begin
        outfile=$fopen(errFileName,"a");
        $strobe("nhsj1a_20     VDHW    error limit ( %d ) reached at %7.4r  %M", maxEv, $abstime );
        $fwrite(outfile,"nhsj1a_20     VDHW    error limit ( %d ) reached at %7.4r  %M\n", maxEv, $abstime );
        VDHW_cnt=VDHW_cnt-1;
        $fclose(outfile);
      end
   end

end // analog
endmodule // nhsj1a_20

// Verilog-A OC Watch for device nhsj1a_28 Parameters  VGS VGD VDS VDB VDHW
module nhsj1a_28_ahdl(D,G,S,B,HW);
parameter tstep_occ=100n;
parameter errFileName="./occ.err";
parameter maxEv = 25;
parameter maxEv_flg = 0;
inout D,G,S,B,HW;
electrical D,G,S,B,HW;

integer outfile;
real V_D_HW;
real V_D_B;
real V_D_S;
real V_G_D;
real V_G_S;
real VGS;
integer VGS_retc;
integer VGS_cnt;
real VGD;
integer VGD_retc;
integer VGD_cnt;
real VDS;
integer VDS_retc;
integer VDS_cnt;
real VDB;
integer VDB_retc;
integer VDB_cnt;
real VDHW;
integer VDHW_retc;
integer VDHW_cnt;

analog begin
   $bound_step( tstep_occ );
   @(initial_step) begin
      VGS_retc=0;
      VGS_cnt = maxEv;
      VGD_retc=0;
      VGD_cnt = maxEv;
      VDS_retc=0;
      VDS_cnt = maxEv;
      VDB_retc=0;
      VDB_cnt = maxEv;
      VDHW_retc=0;
      VDHW_cnt = maxEv;
   end
   V_D_HW = V(D,HW);
   V_D_B = V(D,B);
   V_D_S = V(D,S);
   V_G_D = V(G,D);
   V_G_S = V(G,S);

//      VGS
   VGS = V_G_S;
   if((VGS_cnt>0) || ( maxEv_flg==0 ))   begin
      if( (VGS < -5.5) && (VGS_retc!=-1))
      begin
        outfile=$fopen(errFileName,"a");
        $strobe("nhsj1a_28     VGS     leaving   OCA (  .. -5.500 V ) at %7.4r  %M", $abstime );
        $fwrite(outfile,"nhsj1a_28     VGS     leaving   OCA (  .. -5.500 V ) at %7.4r  %M\n", $abstime );
        VGS_retc=-1;
        VGS_cnt=VGS_cnt-1;
        $fclose(outfile);
      end
      if((VGS >= -5.5) &&  (VGS <= 5.5) && (VGS_retc!=0))
      begin
        outfile=$fopen(errFileName,"a");
        $strobe("nhsj1a_28     VGS     entering SOCA ( -5.500 V .. 5.500 V ) at %7.4r  %M", $abstime );
        $fwrite(outfile,"nhsj1a_28     VGS     entering SOCA ( -5.500 V .. 5.500 V ) at %7.4r  %M\n", $abstime );
        VGS_retc=0;
        VGS_cnt=VGS_cnt-1;
        $fclose(outfile);
      end
      if((VGS > 5.5) &&  (VGS_retc!=1))
      begin
        outfile=$fopen(errFileName,"a");
        $strobe("nhsj1a_28     VGS     leaving   OCA ( 5.500 V ..  ) at %7.4r  %M", $abstime );
        $fwrite(outfile,"nhsj1a_28     VGS     leaving   OCA ( 5.500 V ..  ) at %7.4r  %M\n", $abstime );
        VGS_retc=1;
        VGS_cnt=VGS_cnt-1;
        $fclose(outfile);
      end
   end
   else
   begin
      if(VGS_cnt==0)
      begin
        outfile=$fopen(errFileName,"a");
        $strobe("nhsj1a_28     VGS     error limit ( %d ) reached at %7.4r  %M", maxEv, $abstime );
        $fwrite(outfile,"nhsj1a_28     VGS     error limit ( %d ) reached at %7.4r  %M\n", maxEv, $abstime );
        VGS_cnt=VGS_cnt-1;
        $fclose(outfile);
      end
   end

//      VGD
   VGD = V_G_D;
   if((VGD_cnt>0) || ( maxEv_flg==0 ))   begin
      if( (VGD < -375) && (VGD_retc!=-1))
      begin
        outfile=$fopen(errFileName,"a");
        $strobe("nhsj1a_28     VGD     leaving   OCA (  .. -375.000 V ) at %7.4r  %M", $abstime );
        $fwrite(outfile,"nhsj1a_28     VGD     leaving   OCA (  .. -375.000 V ) at %7.4r  %M\n", $abstime );
        VGD_retc=-1;
        VGD_cnt=VGD_cnt-1;
        $fclose(outfile);
      end
      if((VGD >= -375) &&  (VGD <= 5.5) && (VGD_retc!=0))
      begin
        outfile=$fopen(errFileName,"a");
        $strobe("nhsj1a_28     VGD     entering SOCA ( -375.000 V .. 5.500 V ) at %7.4r  %M", $abstime );
        $fwrite(outfile,"nhsj1a_28     VGD     entering SOCA ( -375.000 V .. 5.500 V ) at %7.4r  %M\n", $abstime );
        VGD_retc=0;
        VGD_cnt=VGD_cnt-1;
        $fclose(outfile);
      end
      if((VGD > 5.5) &&  (VGD_retc!=1))
      begin
        outfile=$fopen(errFileName,"a");
        $strobe("nhsj1a_28     VGD     leaving   OCA ( 5.500 V ..  ) at %7.4r  %M", $abstime );
        $fwrite(outfile,"nhsj1a_28     VGD     leaving   OCA ( 5.500 V ..  ) at %7.4r  %M\n", $abstime );
        VGD_retc=1;
        VGD_cnt=VGD_cnt-1;
        $fclose(outfile);
      end
   end
   else
   begin
      if(VGD_cnt==0)
      begin
        outfile=$fopen(errFileName,"a");
        $strobe("nhsj1a_28     VGD     error limit ( %d ) reached at %7.4r  %M", maxEv, $abstime );
        $fwrite(outfile,"nhsj1a_28     VGD     error limit ( %d ) reached at %7.4r  %M\n", maxEv, $abstime );
        VGD_cnt=VGD_cnt-1;
        $fclose(outfile);
      end
   end

//      VDS
   VDS = V_D_S;
   if((VDS_cnt>0) || ( maxEv_flg==0 ))   begin
      if( (VDS < -1.5) && (VDS_retc!=-1))
      begin
        outfile=$fopen(errFileName,"a");
        $strobe("nhsj1a_28     VDS     leaving   OCA (  .. -1.500 V ) at %7.4r  %M", $abstime );
        $fwrite(outfile,"nhsj1a_28     VDS     leaving   OCA (  .. -1.500 V ) at %7.4r  %M\n", $abstime );
        VDS_retc=-1;
        VDS_cnt=VDS_cnt-1;
        $fclose(outfile);
      end
      if((VDS >= -1.5) &&  (VDS <= 375) && (VDS_retc!=0))
      begin
        outfile=$fopen(errFileName,"a");
        $strobe("nhsj1a_28     VDS     entering SOCA ( -1.500 V .. 375.000 V ) at %7.4r  %M", $abstime );
        $fwrite(outfile,"nhsj1a_28     VDS     entering SOCA ( -1.500 V .. 375.000 V ) at %7.4r  %M\n", $abstime );
        VDS_retc=0;
        VDS_cnt=VDS_cnt-1;
        $fclose(outfile);
      end
      if((VDS > 375) &&  (VDS_retc!=1))
      begin
        outfile=$fopen(errFileName,"a");
        $strobe("nhsj1a_28     VDS     leaving   OCA ( 375.000 V ..  ) at %7.4r  %M", $abstime );
        $fwrite(outfile,"nhsj1a_28     VDS     leaving   OCA ( 375.000 V ..  ) at %7.4r  %M\n", $abstime );
        VDS_retc=1;
        VDS_cnt=VDS_cnt-1;
        $fclose(outfile);
      end
   end
   else
   begin
      if(VDS_cnt==0)
      begin
        outfile=$fopen(errFileName,"a");
        $strobe("nhsj1a_28     VDS     error limit ( %d ) reached at %7.4r  %M", maxEv, $abstime );
        $fwrite(outfile,"nhsj1a_28     VDS     error limit ( %d ) reached at %7.4r  %M\n", maxEv, $abstime );
        VDS_cnt=VDS_cnt-1;
        $fclose(outfile);
      end
   end

//      VDB
   VDB = V_D_B;
   if((VDB_cnt>0) || ( maxEv_flg==0 ))   begin
      if( (VDB < -1.5) && (VDB_retc!=-1))
      begin
        outfile=$fopen(errFileName,"a");
        $strobe("nhsj1a_28     VDB     leaving   OCA (  .. -1.500 V ) at %7.4r  %M", $abstime );
        $fwrite(outfile,"nhsj1a_28     VDB     leaving   OCA (  .. -1.500 V ) at %7.4r  %M\n", $abstime );
        VDB_retc=-1;
        VDB_cnt=VDB_cnt-1;
        $fclose(outfile);
      end
      if((VDB >= -1.5) &&  (VDB <= 375) && (VDB_retc!=0))
      begin
        outfile=$fopen(errFileName,"a");
        $strobe("nhsj1a_28     VDB     entering SOCA ( -1.500 V .. 375.000 V ) at %7.4r  %M", $abstime );
        $fwrite(outfile,"nhsj1a_28     VDB     entering SOCA ( -1.500 V .. 375.000 V ) at %7.4r  %M\n", $abstime );
        VDB_retc=0;
        VDB_cnt=VDB_cnt-1;
        $fclose(outfile);
      end
      if((VDB > 375) &&  (VDB_retc!=1))
      begin
        outfile=$fopen(errFileName,"a");
        $strobe("nhsj1a_28     VDB     leaving   OCA ( 375.000 V ..  ) at %7.4r  %M", $abstime );
        $fwrite(outfile,"nhsj1a_28     VDB     leaving   OCA ( 375.000 V ..  ) at %7.4r  %M\n", $abstime );
        VDB_retc=1;
        VDB_cnt=VDB_cnt-1;
        $fclose(outfile);
      end
   end
   else
   begin
      if(VDB_cnt==0)
      begin
        outfile=$fopen(errFileName,"a");
        $strobe("nhsj1a_28     VDB     error limit ( %d ) reached at %7.4r  %M", maxEv, $abstime );
        $fwrite(outfile,"nhsj1a_28     VDB     error limit ( %d ) reached at %7.4r  %M\n", maxEv, $abstime );
        VDB_cnt=VDB_cnt-1;
        $fclose(outfile);
      end
   end

//      VDHW
   VDHW = V_D_HW;
   if((VDHW_cnt>0) || ( maxEv_flg==0 ))   begin
      if( (VDHW < -1.5) && (VDHW_retc!=-1))
      begin
        outfile=$fopen(errFileName,"a");
        $strobe("nhsj1a_28     VDHW    leaving   OCA (  .. -1.500 V ) at %7.4r  %M", $abstime );
        $fwrite(outfile,"nhsj1a_28     VDHW    leaving   OCA (  .. -1.500 V ) at %7.4r  %M\n", $abstime );
        VDHW_retc=-1;
        VDHW_cnt=VDHW_cnt-1;
        $fclose(outfile);
      end
      if((VDHW >= -1.5) &&  (VDHW <= 400) && (VDHW_retc!=0))
      begin
        outfile=$fopen(errFileName,"a");
        $strobe("nhsj1a_28     VDHW    entering SOCA ( -1.500 V .. 400.000 V ) at %7.4r  %M", $abstime );
        $fwrite(outfile,"nhsj1a_28     VDHW    entering SOCA ( -1.500 V .. 400.000 V ) at %7.4r  %M\n", $abstime );
        VDHW_retc=0;
        VDHW_cnt=VDHW_cnt-1;
        $fclose(outfile);
      end
      if((VDHW > 400) &&  (VDHW_retc!=1))
      begin
        outfile=$fopen(errFileName,"a");
        $strobe("nhsj1a_28     VDHW    leaving   OCA ( 400.000 V ..  ) at %7.4r  %M", $abstime );
        $fwrite(outfile,"nhsj1a_28     VDHW    leaving   OCA ( 400.000 V ..  ) at %7.4r  %M\n", $abstime );
        VDHW_retc=1;
        VDHW_cnt=VDHW_cnt-1;
        $fclose(outfile);
      end
   end
   else
   begin
      if(VDHW_cnt==0)
      begin
        outfile=$fopen(errFileName,"a");
        $strobe("nhsj1a_28     VDHW    error limit ( %d ) reached at %7.4r  %M", maxEv, $abstime );
        $fwrite(outfile,"nhsj1a_28     VDHW    error limit ( %d ) reached at %7.4r  %M\n", maxEv, $abstime );
        VDHW_cnt=VDHW_cnt-1;
        $fclose(outfile);
      end
   end

end // analog
endmodule // nhsj1a_28

// Verilog-A OC Watch for device phsj1a_4 Parameters  VGS VGD VDS VDB VBHW
module phsj1a_4_ahdl(D,G,S,B,HW);
parameter tstep_occ=100n;
parameter errFileName="./occ.err";
parameter maxEv = 25;
parameter maxEv_flg = 0;
inout D,G,S,B,HW;
electrical D,G,S,B,HW;

integer outfile;
real V_B_HW;
real V_D_B;
real V_D_S;
real V_G_D;
real V_G_S;
real VGS;
integer VGS_retc;
integer VGS_cnt;
real VGD;
integer VGD_retc;
integer VGD_cnt;
real VDS;
integer VDS_retc;
integer VDS_cnt;
real VDB;
integer VDB_retc;
integer VDB_cnt;
real VBHW;
integer VBHW_retc;
integer VBHW_cnt;

analog begin
   $bound_step( tstep_occ );
   @(initial_step) begin
      VGS_retc=0;
      VGS_cnt = maxEv;
      VGD_retc=0;
      VGD_cnt = maxEv;
      VDS_retc=0;
      VDS_cnt = maxEv;
      VDB_retc=0;
      VDB_cnt = maxEv;
      VBHW_retc=0;
      VBHW_cnt = maxEv;
   end
   V_B_HW = V(B,HW);
   V_D_B = V(D,B);
   V_D_S = V(D,S);
   V_G_D = V(G,D);
   V_G_S = V(G,S);

//      VGS
   VGS = V_G_S;
   if((VGS_cnt>0) || ( maxEv_flg==0 ))   begin
      if( (VGS < -5.5) && (VGS_retc!=-1))
      begin
        outfile=$fopen(errFileName,"a");
        $strobe("phsj1a_4      VGS     leaving   OCA (  .. -5.500 V ) at %7.4r  %M", $abstime );
        $fwrite(outfile,"phsj1a_4      VGS     leaving   OCA (  .. -5.500 V ) at %7.4r  %M\n", $abstime );
        VGS_retc=-1;
        VGS_cnt=VGS_cnt-1;
        $fclose(outfile);
      end
      if((VGS >= -5.5) &&  (VGS <= 5.5) && (VGS_retc!=0))
      begin
        outfile=$fopen(errFileName,"a");
        $strobe("phsj1a_4      VGS     entering SOCA ( -5.500 V .. 5.500 V ) at %7.4r  %M", $abstime );
        $fwrite(outfile,"phsj1a_4      VGS     entering SOCA ( -5.500 V .. 5.500 V ) at %7.4r  %M\n", $abstime );
        VGS_retc=0;
        VGS_cnt=VGS_cnt-1;
        $fclose(outfile);
      end
      if((VGS > 5.5) &&  (VGS_retc!=1))
      begin
        outfile=$fopen(errFileName,"a");
        $strobe("phsj1a_4      VGS     leaving   OCA ( 5.500 V ..  ) at %7.4r  %M", $abstime );
        $fwrite(outfile,"phsj1a_4      VGS     leaving   OCA ( 5.500 V ..  ) at %7.4r  %M\n", $abstime );
        VGS_retc=1;
        VGS_cnt=VGS_cnt-1;
        $fclose(outfile);
      end
   end
   else
   begin
      if(VGS_cnt==0)
      begin
        outfile=$fopen(errFileName,"a");
        $strobe("phsj1a_4      VGS     error limit ( %d ) reached at %7.4r  %M", maxEv, $abstime );
        $fwrite(outfile,"phsj1a_4      VGS     error limit ( %d ) reached at %7.4r  %M\n", maxEv, $abstime );
        VGS_cnt=VGS_cnt-1;
        $fclose(outfile);
      end
   end

//      VGD
   VGD = V_G_D;
   if((VGD_cnt>0) || ( maxEv_flg==0 ))   begin
      if( (VGD < -5.5) && (VGD_retc!=-1))
      begin
        outfile=$fopen(errFileName,"a");
        $strobe("phsj1a_4      VGD     leaving   OCA (  .. -5.500 V ) at %7.4r  %M", $abstime );
        $fwrite(outfile,"phsj1a_4      VGD     leaving   OCA (  .. -5.500 V ) at %7.4r  %M\n", $abstime );
        VGD_retc=-1;
        VGD_cnt=VGD_cnt-1;
        $fclose(outfile);
      end
      if((VGD >= -5.5) &&  (VGD <= 72) && (VGD_retc!=0))
      begin
        outfile=$fopen(errFileName,"a");
        $strobe("phsj1a_4      VGD     entering SOCA ( -5.500 V .. 72.000 V ) at %7.4r  %M", $abstime );
        $fwrite(outfile,"phsj1a_4      VGD     entering SOCA ( -5.500 V .. 72.000 V ) at %7.4r  %M\n", $abstime );
        VGD_retc=0;
        VGD_cnt=VGD_cnt-1;
        $fclose(outfile);
      end
      if((VGD > 72) &&  (VGD_retc!=1))
      begin
        outfile=$fopen(errFileName,"a");
        $strobe("phsj1a_4      VGD     leaving   OCA ( 72.000 V ..  ) at %7.4r  %M", $abstime );
        $fwrite(outfile,"phsj1a_4      VGD     leaving   OCA ( 72.000 V ..  ) at %7.4r  %M\n", $abstime );
        VGD_retc=1;
        VGD_cnt=VGD_cnt-1;
        $fclose(outfile);
      end
   end
   else
   begin
      if(VGD_cnt==0)
      begin
        outfile=$fopen(errFileName,"a");
        $strobe("phsj1a_4      VGD     error limit ( %d ) reached at %7.4r  %M", maxEv, $abstime );
        $fwrite(outfile,"phsj1a_4      VGD     error limit ( %d ) reached at %7.4r  %M\n", maxEv, $abstime );
        VGD_cnt=VGD_cnt-1;
        $fclose(outfile);
      end
   end

//      VDS
   VDS = V_D_S;
   if((VDS_cnt>0) || ( maxEv_flg==0 ))   begin
      if( (VDS < -72) && (VDS_retc!=-1))
      begin
        outfile=$fopen(errFileName,"a");
        $strobe("phsj1a_4      VDS     leaving   OCA (  .. -72.000 V ) at %7.4r  %M", $abstime );
        $fwrite(outfile,"phsj1a_4      VDS     leaving   OCA (  .. -72.000 V ) at %7.4r  %M\n", $abstime );
        VDS_retc=-1;
        VDS_cnt=VDS_cnt-1;
        $fclose(outfile);
      end
      if((VDS >= -72) &&  (VDS <= 1.5) && (VDS_retc!=0))
      begin
        outfile=$fopen(errFileName,"a");
        $strobe("phsj1a_4      VDS     entering SOCA ( -72.000 V .. 1.500 V ) at %7.4r  %M", $abstime );
        $fwrite(outfile,"phsj1a_4      VDS     entering SOCA ( -72.000 V .. 1.500 V ) at %7.4r  %M\n", $abstime );
        VDS_retc=0;
        VDS_cnt=VDS_cnt-1;
        $fclose(outfile);
      end
      if((VDS > 1.5) &&  (VDS_retc!=1))
      begin
        outfile=$fopen(errFileName,"a");
        $strobe("phsj1a_4      VDS     leaving   OCA ( 1.500 V ..  ) at %7.4r  %M", $abstime );
        $fwrite(outfile,"phsj1a_4      VDS     leaving   OCA ( 1.500 V ..  ) at %7.4r  %M\n", $abstime );
        VDS_retc=1;
        VDS_cnt=VDS_cnt-1;
        $fclose(outfile);
      end
   end
   else
   begin
      if(VDS_cnt==0)
      begin
        outfile=$fopen(errFileName,"a");
        $strobe("phsj1a_4      VDS     error limit ( %d ) reached at %7.4r  %M", maxEv, $abstime );
        $fwrite(outfile,"phsj1a_4      VDS     error limit ( %d ) reached at %7.4r  %M\n", maxEv, $abstime );
        VDS_cnt=VDS_cnt-1;
        $fclose(outfile);
      end
   end

//      VDB
   VDB = V_D_B;
   if((VDB_cnt>0) || ( maxEv_flg==0 ))   begin
      if( (VDB < -72) && (VDB_retc!=-1))
      begin
        outfile=$fopen(errFileName,"a");
        $strobe("phsj1a_4      VDB     leaving   OCA (  .. -72.000 V ) at %7.4r  %M", $abstime );
        $fwrite(outfile,"phsj1a_4      VDB     leaving   OCA (  .. -72.000 V ) at %7.4r  %M\n", $abstime );
        VDB_retc=-1;
        VDB_cnt=VDB_cnt-1;
        $fclose(outfile);
      end
      if((VDB >= -72) &&  (VDB <= 1.5) && (VDB_retc!=0))
      begin
        outfile=$fopen(errFileName,"a");
        $strobe("phsj1a_4      VDB     entering SOCA ( -72.000 V .. 1.500 V ) at %7.4r  %M", $abstime );
        $fwrite(outfile,"phsj1a_4      VDB     entering SOCA ( -72.000 V .. 1.500 V ) at %7.4r  %M\n", $abstime );
        VDB_retc=0;
        VDB_cnt=VDB_cnt-1;
        $fclose(outfile);
      end
      if((VDB > 1.5) &&  (VDB_retc!=1))
      begin
        outfile=$fopen(errFileName,"a");
        $strobe("phsj1a_4      VDB     leaving   OCA ( 1.500 V ..  ) at %7.4r  %M", $abstime );
        $fwrite(outfile,"phsj1a_4      VDB     leaving   OCA ( 1.500 V ..  ) at %7.4r  %M\n", $abstime );
        VDB_retc=1;
        VDB_cnt=VDB_cnt-1;
        $fclose(outfile);
      end
   end
   else
   begin
      if(VDB_cnt==0)
      begin
        outfile=$fopen(errFileName,"a");
        $strobe("phsj1a_4      VDB     error limit ( %d ) reached at %7.4r  %M", maxEv, $abstime );
        $fwrite(outfile,"phsj1a_4      VDB     error limit ( %d ) reached at %7.4r  %M\n", maxEv, $abstime );
        VDB_cnt=VDB_cnt-1;
        $fclose(outfile);
      end
   end

//      VBHW
   VBHW = V_B_HW;
   if((VBHW_cnt>0) || ( maxEv_flg==0 ))   begin
      if( (VBHW < -0.1) && (VBHW_retc!=-1))
      begin
        outfile=$fopen(errFileName,"a");
        $strobe("phsj1a_4      VBHW    leaving   OCA (  .. -0.100 V ) at %7.4r  %M", $abstime );
        $fwrite(outfile,"phsj1a_4      VBHW    leaving   OCA (  .. -0.100 V ) at %7.4r  %M\n", $abstime );
        VBHW_retc=-1;
        VBHW_cnt=VBHW_cnt-1;
        $fclose(outfile);
      end
      if((VBHW >= -0.1) &&  (VBHW <= 400) && (VBHW_retc!=0))
      begin
        outfile=$fopen(errFileName,"a");
        $strobe("phsj1a_4      VBHW    entering SOCA ( -0.100 V .. 400.000 V ) at %7.4r  %M", $abstime );
        $fwrite(outfile,"phsj1a_4      VBHW    entering SOCA ( -0.100 V .. 400.000 V ) at %7.4r  %M\n", $abstime );
        VBHW_retc=0;
        VBHW_cnt=VBHW_cnt-1;
        $fclose(outfile);
      end
      if((VBHW > 400) &&  (VBHW_retc!=1))
      begin
        outfile=$fopen(errFileName,"a");
        $strobe("phsj1a_4      VBHW    leaving   OCA ( 400.000 V ..  ) at %7.4r  %M", $abstime );
        $fwrite(outfile,"phsj1a_4      VBHW    leaving   OCA ( 400.000 V ..  ) at %7.4r  %M\n", $abstime );
        VBHW_retc=1;
        VBHW_cnt=VBHW_cnt-1;
        $fclose(outfile);
      end
   end
   else
   begin
      if(VBHW_cnt==0)
      begin
        outfile=$fopen(errFileName,"a");
        $strobe("phsj1a_4      VBHW    error limit ( %d ) reached at %7.4r  %M", maxEv, $abstime );
        $fwrite(outfile,"phsj1a_4      VBHW    error limit ( %d ) reached at %7.4r  %M\n", maxEv, $abstime );
        VBHW_cnt=VBHW_cnt-1;
        $fclose(outfile);
      end
   end

end // analog
endmodule // phsj1a_4

// Verilog-A OC Watch for device phsj1a_5 Parameters  VGS VGD VDS VDB VBHW
module phsj1a_5_ahdl(D,G,S,B,HW);
parameter tstep_occ=100n;
parameter errFileName="./occ.err";
parameter maxEv = 25;
parameter maxEv_flg = 0;
inout D,G,S,B,HW;
electrical D,G,S,B,HW;

integer outfile;
real V_B_HW;
real V_D_B;
real V_D_S;
real V_G_D;
real V_G_S;
real VGS;
integer VGS_retc;
integer VGS_cnt;
real VGD;
integer VGD_retc;
integer VGD_cnt;
real VDS;
integer VDS_retc;
integer VDS_cnt;
real VDB;
integer VDB_retc;
integer VDB_cnt;
real VBHW;
integer VBHW_retc;
integer VBHW_cnt;

analog begin
   $bound_step( tstep_occ );
   @(initial_step) begin
      VGS_retc=0;
      VGS_cnt = maxEv;
      VGD_retc=0;
      VGD_cnt = maxEv;
      VDS_retc=0;
      VDS_cnt = maxEv;
      VDB_retc=0;
      VDB_cnt = maxEv;
      VBHW_retc=0;
      VBHW_cnt = maxEv;
   end
   V_B_HW = V(B,HW);
   V_D_B = V(D,B);
   V_D_S = V(D,S);
   V_G_D = V(G,D);
   V_G_S = V(G,S);

//      VGS
   VGS = V_G_S;
   if((VGS_cnt>0) || ( maxEv_flg==0 ))   begin
      if( (VGS < -5.5) && (VGS_retc!=-1))
      begin
        outfile=$fopen(errFileName,"a");
        $strobe("phsj1a_5      VGS     leaving   OCA (  .. -5.500 V ) at %7.4r  %M", $abstime );
        $fwrite(outfile,"phsj1a_5      VGS     leaving   OCA (  .. -5.500 V ) at %7.4r  %M\n", $abstime );
        VGS_retc=-1;
        VGS_cnt=VGS_cnt-1;
        $fclose(outfile);
      end
      if((VGS >= -5.5) &&  (VGS <= 5.5) && (VGS_retc!=0))
      begin
        outfile=$fopen(errFileName,"a");
        $strobe("phsj1a_5      VGS     entering SOCA ( -5.500 V .. 5.500 V ) at %7.4r  %M", $abstime );
        $fwrite(outfile,"phsj1a_5      VGS     entering SOCA ( -5.500 V .. 5.500 V ) at %7.4r  %M\n", $abstime );
        VGS_retc=0;
        VGS_cnt=VGS_cnt-1;
        $fclose(outfile);
      end
      if((VGS > 5.5) &&  (VGS_retc!=1))
      begin
        outfile=$fopen(errFileName,"a");
        $strobe("phsj1a_5      VGS     leaving   OCA ( 5.500 V ..  ) at %7.4r  %M", $abstime );
        $fwrite(outfile,"phsj1a_5      VGS     leaving   OCA ( 5.500 V ..  ) at %7.4r  %M\n", $abstime );
        VGS_retc=1;
        VGS_cnt=VGS_cnt-1;
        $fclose(outfile);
      end
   end
   else
   begin
      if(VGS_cnt==0)
      begin
        outfile=$fopen(errFileName,"a");
        $strobe("phsj1a_5      VGS     error limit ( %d ) reached at %7.4r  %M", maxEv, $abstime );
        $fwrite(outfile,"phsj1a_5      VGS     error limit ( %d ) reached at %7.4r  %M\n", maxEv, $abstime );
        VGS_cnt=VGS_cnt-1;
        $fclose(outfile);
      end
   end

//      VGD
   VGD = V_G_D;
   if((VGD_cnt>0) || ( maxEv_flg==0 ))   begin
      if( (VGD < -5.5) && (VGD_retc!=-1))
      begin
        outfile=$fopen(errFileName,"a");
        $strobe("phsj1a_5      VGD     leaving   OCA (  .. -5.500 V ) at %7.4r  %M", $abstime );
        $fwrite(outfile,"phsj1a_5      VGD     leaving   OCA (  .. -5.500 V ) at %7.4r  %M\n", $abstime );
        VGD_retc=-1;
        VGD_cnt=VGD_cnt-1;
        $fclose(outfile);
      end
      if((VGD >= -5.5) &&  (VGD <= 95) && (VGD_retc!=0))
      begin
        outfile=$fopen(errFileName,"a");
        $strobe("phsj1a_5      VGD     entering SOCA ( -5.500 V .. 95.000 V ) at %7.4r  %M", $abstime );
        $fwrite(outfile,"phsj1a_5      VGD     entering SOCA ( -5.500 V .. 95.000 V ) at %7.4r  %M\n", $abstime );
        VGD_retc=0;
        VGD_cnt=VGD_cnt-1;
        $fclose(outfile);
      end
      if((VGD > 95) &&  (VGD_retc!=1))
      begin
        outfile=$fopen(errFileName,"a");
        $strobe("phsj1a_5      VGD     leaving   OCA ( 95.000 V ..  ) at %7.4r  %M", $abstime );
        $fwrite(outfile,"phsj1a_5      VGD     leaving   OCA ( 95.000 V ..  ) at %7.4r  %M\n", $abstime );
        VGD_retc=1;
        VGD_cnt=VGD_cnt-1;
        $fclose(outfile);
      end
   end
   else
   begin
      if(VGD_cnt==0)
      begin
        outfile=$fopen(errFileName,"a");
        $strobe("phsj1a_5      VGD     error limit ( %d ) reached at %7.4r  %M", maxEv, $abstime );
        $fwrite(outfile,"phsj1a_5      VGD     error limit ( %d ) reached at %7.4r  %M\n", maxEv, $abstime );
        VGD_cnt=VGD_cnt-1;
        $fclose(outfile);
      end
   end

//      VDS
   VDS = V_D_S;
   if((VDS_cnt>0) || ( maxEv_flg==0 ))   begin
      if( (VDS < -95) && (VDS_retc!=-1))
      begin
        outfile=$fopen(errFileName,"a");
        $strobe("phsj1a_5      VDS     leaving   OCA (  .. -95.000 V ) at %7.4r  %M", $abstime );
        $fwrite(outfile,"phsj1a_5      VDS     leaving   OCA (  .. -95.000 V ) at %7.4r  %M\n", $abstime );
        VDS_retc=-1;
        VDS_cnt=VDS_cnt-1;
        $fclose(outfile);
      end
      if((VDS >= -95) &&  (VDS <= 1.5) && (VDS_retc!=0))
      begin
        outfile=$fopen(errFileName,"a");
        $strobe("phsj1a_5      VDS     entering SOCA ( -95.000 V .. 1.500 V ) at %7.4r  %M", $abstime );
        $fwrite(outfile,"phsj1a_5      VDS     entering SOCA ( -95.000 V .. 1.500 V ) at %7.4r  %M\n", $abstime );
        VDS_retc=0;
        VDS_cnt=VDS_cnt-1;
        $fclose(outfile);
      end
      if((VDS > 1.5) &&  (VDS_retc!=1))
      begin
        outfile=$fopen(errFileName,"a");
        $strobe("phsj1a_5      VDS     leaving   OCA ( 1.500 V ..  ) at %7.4r  %M", $abstime );
        $fwrite(outfile,"phsj1a_5      VDS     leaving   OCA ( 1.500 V ..  ) at %7.4r  %M\n", $abstime );
        VDS_retc=1;
        VDS_cnt=VDS_cnt-1;
        $fclose(outfile);
      end
   end
   else
   begin
      if(VDS_cnt==0)
      begin
        outfile=$fopen(errFileName,"a");
        $strobe("phsj1a_5      VDS     error limit ( %d ) reached at %7.4r  %M", maxEv, $abstime );
        $fwrite(outfile,"phsj1a_5      VDS     error limit ( %d ) reached at %7.4r  %M\n", maxEv, $abstime );
        VDS_cnt=VDS_cnt-1;
        $fclose(outfile);
      end
   end

//      VDB
   VDB = V_D_B;
   if((VDB_cnt>0) || ( maxEv_flg==0 ))   begin
      if( (VDB < -95) && (VDB_retc!=-1))
      begin
        outfile=$fopen(errFileName,"a");
        $strobe("phsj1a_5      VDB     leaving   OCA (  .. -95.000 V ) at %7.4r  %M", $abstime );
        $fwrite(outfile,"phsj1a_5      VDB     leaving   OCA (  .. -95.000 V ) at %7.4r  %M\n", $abstime );
        VDB_retc=-1;
        VDB_cnt=VDB_cnt-1;
        $fclose(outfile);
      end
      if((VDB >= -95) &&  (VDB <= 1.5) && (VDB_retc!=0))
      begin
        outfile=$fopen(errFileName,"a");
        $strobe("phsj1a_5      VDB     entering SOCA ( -95.000 V .. 1.500 V ) at %7.4r  %M", $abstime );
        $fwrite(outfile,"phsj1a_5      VDB     entering SOCA ( -95.000 V .. 1.500 V ) at %7.4r  %M\n", $abstime );
        VDB_retc=0;
        VDB_cnt=VDB_cnt-1;
        $fclose(outfile);
      end
      if((VDB > 1.5) &&  (VDB_retc!=1))
      begin
        outfile=$fopen(errFileName,"a");
        $strobe("phsj1a_5      VDB     leaving   OCA ( 1.500 V ..  ) at %7.4r  %M", $abstime );
        $fwrite(outfile,"phsj1a_5      VDB     leaving   OCA ( 1.500 V ..  ) at %7.4r  %M\n", $abstime );
        VDB_retc=1;
        VDB_cnt=VDB_cnt-1;
        $fclose(outfile);
      end
   end
   else
   begin
      if(VDB_cnt==0)
      begin
        outfile=$fopen(errFileName,"a");
        $strobe("phsj1a_5      VDB     error limit ( %d ) reached at %7.4r  %M", maxEv, $abstime );
        $fwrite(outfile,"phsj1a_5      VDB     error limit ( %d ) reached at %7.4r  %M\n", maxEv, $abstime );
        VDB_cnt=VDB_cnt-1;
        $fclose(outfile);
      end
   end

//      VBHW
   VBHW = V_B_HW;
   if((VBHW_cnt>0) || ( maxEv_flg==0 ))   begin
      if( (VBHW < -0.1) && (VBHW_retc!=-1))
      begin
        outfile=$fopen(errFileName,"a");
        $strobe("phsj1a_5      VBHW    leaving   OCA (  .. -0.100 V ) at %7.4r  %M", $abstime );
        $fwrite(outfile,"phsj1a_5      VBHW    leaving   OCA (  .. -0.100 V ) at %7.4r  %M\n", $abstime );
        VBHW_retc=-1;
        VBHW_cnt=VBHW_cnt-1;
        $fclose(outfile);
      end
      if((VBHW >= -0.1) &&  (VBHW <= 400) && (VBHW_retc!=0))
      begin
        outfile=$fopen(errFileName,"a");
        $strobe("phsj1a_5      VBHW    entering SOCA ( -0.100 V .. 400.000 V ) at %7.4r  %M", $abstime );
        $fwrite(outfile,"phsj1a_5      VBHW    entering SOCA ( -0.100 V .. 400.000 V ) at %7.4r  %M\n", $abstime );
        VBHW_retc=0;
        VBHW_cnt=VBHW_cnt-1;
        $fclose(outfile);
      end
      if((VBHW > 400) &&  (VBHW_retc!=1))
      begin
        outfile=$fopen(errFileName,"a");
        $strobe("phsj1a_5      VBHW    leaving   OCA ( 400.000 V ..  ) at %7.4r  %M", $abstime );
        $fwrite(outfile,"phsj1a_5      VBHW    leaving   OCA ( 400.000 V ..  ) at %7.4r  %M\n", $abstime );
        VBHW_retc=1;
        VBHW_cnt=VBHW_cnt-1;
        $fclose(outfile);
      end
   end
   else
   begin
      if(VBHW_cnt==0)
      begin
        outfile=$fopen(errFileName,"a");
        $strobe("phsj1a_5      VBHW    error limit ( %d ) reached at %7.4r  %M", maxEv, $abstime );
        $fwrite(outfile,"phsj1a_5      VBHW    error limit ( %d ) reached at %7.4r  %M\n", maxEv, $abstime );
        VBHW_cnt=VBHW_cnt-1;
        $fclose(outfile);
      end
   end

end // analog
endmodule // phsj1a_5

// Verilog-A OC Watch for device phsj1a_7 Parameters  VGS VGD VDS VDB VBHW
module phsj1a_7_ahdl(D,G,S,B,HW);
parameter tstep_occ=100n;
parameter errFileName="./occ.err";
parameter maxEv = 25;
parameter maxEv_flg = 0;
inout D,G,S,B,HW;
electrical D,G,S,B,HW;

integer outfile;
real V_B_HW;
real V_D_B;
real V_D_S;
real V_G_D;
real V_G_S;
real VGS;
integer VGS_retc;
integer VGS_cnt;
real VGD;
integer VGD_retc;
integer VGD_cnt;
real VDS;
integer VDS_retc;
integer VDS_cnt;
real VDB;
integer VDB_retc;
integer VDB_cnt;
real VBHW;
integer VBHW_retc;
integer VBHW_cnt;

analog begin
   $bound_step( tstep_occ );
   @(initial_step) begin
      VGS_retc=0;
      VGS_cnt = maxEv;
      VGD_retc=0;
      VGD_cnt = maxEv;
      VDS_retc=0;
      VDS_cnt = maxEv;
      VDB_retc=0;
      VDB_cnt = maxEv;
      VBHW_retc=0;
      VBHW_cnt = maxEv;
   end
   V_B_HW = V(B,HW);
   V_D_B = V(D,B);
   V_D_S = V(D,S);
   V_G_D = V(G,D);
   V_G_S = V(G,S);

//      VGS
   VGS = V_G_S;
   if((VGS_cnt>0) || ( maxEv_flg==0 ))   begin
      if( (VGS < -5.5) && (VGS_retc!=-1))
      begin
        outfile=$fopen(errFileName,"a");
        $strobe("phsj1a_7      VGS     leaving   OCA (  .. -5.500 V ) at %7.4r  %M", $abstime );
        $fwrite(outfile,"phsj1a_7      VGS     leaving   OCA (  .. -5.500 V ) at %7.4r  %M\n", $abstime );
        VGS_retc=-1;
        VGS_cnt=VGS_cnt-1;
        $fclose(outfile);
      end
      if((VGS >= -5.5) &&  (VGS <= 5.5) && (VGS_retc!=0))
      begin
        outfile=$fopen(errFileName,"a");
        $strobe("phsj1a_7      VGS     entering SOCA ( -5.500 V .. 5.500 V ) at %7.4r  %M", $abstime );
        $fwrite(outfile,"phsj1a_7      VGS     entering SOCA ( -5.500 V .. 5.500 V ) at %7.4r  %M\n", $abstime );
        VGS_retc=0;
        VGS_cnt=VGS_cnt-1;
        $fclose(outfile);
      end
      if((VGS > 5.5) &&  (VGS_retc!=1))
      begin
        outfile=$fopen(errFileName,"a");
        $strobe("phsj1a_7      VGS     leaving   OCA ( 5.500 V ..  ) at %7.4r  %M", $abstime );
        $fwrite(outfile,"phsj1a_7      VGS     leaving   OCA ( 5.500 V ..  ) at %7.4r  %M\n", $abstime );
        VGS_retc=1;
        VGS_cnt=VGS_cnt-1;
        $fclose(outfile);
      end
   end
   else
   begin
      if(VGS_cnt==0)
      begin
        outfile=$fopen(errFileName,"a");
        $strobe("phsj1a_7      VGS     error limit ( %d ) reached at %7.4r  %M", maxEv, $abstime );
        $fwrite(outfile,"phsj1a_7      VGS     error limit ( %d ) reached at %7.4r  %M\n", maxEv, $abstime );
        VGS_cnt=VGS_cnt-1;
        $fclose(outfile);
      end
   end

//      VGD
   VGD = V_G_D;
   if((VGD_cnt>0) || ( maxEv_flg==0 ))   begin
      if( (VGD < -5.5) && (VGD_retc!=-1))
      begin
        outfile=$fopen(errFileName,"a");
        $strobe("phsj1a_7      VGD     leaving   OCA (  .. -5.500 V ) at %7.4r  %M", $abstime );
        $fwrite(outfile,"phsj1a_7      VGD     leaving   OCA (  .. -5.500 V ) at %7.4r  %M\n", $abstime );
        VGD_retc=-1;
        VGD_cnt=VGD_cnt-1;
        $fclose(outfile);
      end
      if((VGD >= -5.5) &&  (VGD <= 115) && (VGD_retc!=0))
      begin
        outfile=$fopen(errFileName,"a");
        $strobe("phsj1a_7      VGD     entering SOCA ( -5.500 V .. 115.000 V ) at %7.4r  %M", $abstime );
        $fwrite(outfile,"phsj1a_7      VGD     entering SOCA ( -5.500 V .. 115.000 V ) at %7.4r  %M\n", $abstime );
        VGD_retc=0;
        VGD_cnt=VGD_cnt-1;
        $fclose(outfile);
      end
      if((VGD > 115) &&  (VGD_retc!=1))
      begin
        outfile=$fopen(errFileName,"a");
        $strobe("phsj1a_7      VGD     leaving   OCA ( 115.000 V ..  ) at %7.4r  %M", $abstime );
        $fwrite(outfile,"phsj1a_7      VGD     leaving   OCA ( 115.000 V ..  ) at %7.4r  %M\n", $abstime );
        VGD_retc=1;
        VGD_cnt=VGD_cnt-1;
        $fclose(outfile);
      end
   end
   else
   begin
      if(VGD_cnt==0)
      begin
        outfile=$fopen(errFileName,"a");
        $strobe("phsj1a_7      VGD     error limit ( %d ) reached at %7.4r  %M", maxEv, $abstime );
        $fwrite(outfile,"phsj1a_7      VGD     error limit ( %d ) reached at %7.4r  %M\n", maxEv, $abstime );
        VGD_cnt=VGD_cnt-1;
        $fclose(outfile);
      end
   end

//      VDS
   VDS = V_D_S;
   if((VDS_cnt>0) || ( maxEv_flg==0 ))   begin
      if( (VDS < -115) && (VDS_retc!=-1))
      begin
        outfile=$fopen(errFileName,"a");
        $strobe("phsj1a_7      VDS     leaving   OCA (  .. -115.000 V ) at %7.4r  %M", $abstime );
        $fwrite(outfile,"phsj1a_7      VDS     leaving   OCA (  .. -115.000 V ) at %7.4r  %M\n", $abstime );
        VDS_retc=-1;
        VDS_cnt=VDS_cnt-1;
        $fclose(outfile);
      end
      if((VDS >= -115) &&  (VDS <= 1.5) && (VDS_retc!=0))
      begin
        outfile=$fopen(errFileName,"a");
        $strobe("phsj1a_7      VDS     entering SOCA ( -115.000 V .. 1.500 V ) at %7.4r  %M", $abstime );
        $fwrite(outfile,"phsj1a_7      VDS     entering SOCA ( -115.000 V .. 1.500 V ) at %7.4r  %M\n", $abstime );
        VDS_retc=0;
        VDS_cnt=VDS_cnt-1;
        $fclose(outfile);
      end
      if((VDS > 1.5) &&  (VDS_retc!=1))
      begin
        outfile=$fopen(errFileName,"a");
        $strobe("phsj1a_7      VDS     leaving   OCA ( 1.500 V ..  ) at %7.4r  %M", $abstime );
        $fwrite(outfile,"phsj1a_7      VDS     leaving   OCA ( 1.500 V ..  ) at %7.4r  %M\n", $abstime );
        VDS_retc=1;
        VDS_cnt=VDS_cnt-1;
        $fclose(outfile);
      end
   end
   else
   begin
      if(VDS_cnt==0)
      begin
        outfile=$fopen(errFileName,"a");
        $strobe("phsj1a_7      VDS     error limit ( %d ) reached at %7.4r  %M", maxEv, $abstime );
        $fwrite(outfile,"phsj1a_7      VDS     error limit ( %d ) reached at %7.4r  %M\n", maxEv, $abstime );
        VDS_cnt=VDS_cnt-1;
        $fclose(outfile);
      end
   end

//      VDB
   VDB = V_D_B;
   if((VDB_cnt>0) || ( maxEv_flg==0 ))   begin
      if( (VDB < -115) && (VDB_retc!=-1))
      begin
        outfile=$fopen(errFileName,"a");
        $strobe("phsj1a_7      VDB     leaving   OCA (  .. -115.000 V ) at %7.4r  %M", $abstime );
        $fwrite(outfile,"phsj1a_7      VDB     leaving   OCA (  .. -115.000 V ) at %7.4r  %M\n", $abstime );
        VDB_retc=-1;
        VDB_cnt=VDB_cnt-1;
        $fclose(outfile);
      end
      if((VDB >= -115) &&  (VDB <= 1.5) && (VDB_retc!=0))
      begin
        outfile=$fopen(errFileName,"a");
        $strobe("phsj1a_7      VDB     entering SOCA ( -115.000 V .. 1.500 V ) at %7.4r  %M", $abstime );
        $fwrite(outfile,"phsj1a_7      VDB     entering SOCA ( -115.000 V .. 1.500 V ) at %7.4r  %M\n", $abstime );
        VDB_retc=0;
        VDB_cnt=VDB_cnt-1;
        $fclose(outfile);
      end
      if((VDB > 1.5) &&  (VDB_retc!=1))
      begin
        outfile=$fopen(errFileName,"a");
        $strobe("phsj1a_7      VDB     leaving   OCA ( 1.500 V ..  ) at %7.4r  %M", $abstime );
        $fwrite(outfile,"phsj1a_7      VDB     leaving   OCA ( 1.500 V ..  ) at %7.4r  %M\n", $abstime );
        VDB_retc=1;
        VDB_cnt=VDB_cnt-1;
        $fclose(outfile);
      end
   end
   else
   begin
      if(VDB_cnt==0)
      begin
        outfile=$fopen(errFileName,"a");
        $strobe("phsj1a_7      VDB     error limit ( %d ) reached at %7.4r  %M", maxEv, $abstime );
        $fwrite(outfile,"phsj1a_7      VDB     error limit ( %d ) reached at %7.4r  %M\n", maxEv, $abstime );
        VDB_cnt=VDB_cnt-1;
        $fclose(outfile);
      end
   end

//      VBHW
   VBHW = V_B_HW;
   if((VBHW_cnt>0) || ( maxEv_flg==0 ))   begin
      if( (VBHW < -0.1) && (VBHW_retc!=-1))
      begin
        outfile=$fopen(errFileName,"a");
        $strobe("phsj1a_7      VBHW    leaving   OCA (  .. -0.100 V ) at %7.4r  %M", $abstime );
        $fwrite(outfile,"phsj1a_7      VBHW    leaving   OCA (  .. -0.100 V ) at %7.4r  %M\n", $abstime );
        VBHW_retc=-1;
        VBHW_cnt=VBHW_cnt-1;
        $fclose(outfile);
      end
      if((VBHW >= -0.1) &&  (VBHW <= 375) && (VBHW_retc!=0))
      begin
        outfile=$fopen(errFileName,"a");
        $strobe("phsj1a_7      VBHW    entering SOCA ( -0.100 V .. 375.000 V ) at %7.4r  %M", $abstime );
        $fwrite(outfile,"phsj1a_7      VBHW    entering SOCA ( -0.100 V .. 375.000 V ) at %7.4r  %M\n", $abstime );
        VBHW_retc=0;
        VBHW_cnt=VBHW_cnt-1;
        $fclose(outfile);
      end
      if((VBHW > 375) &&  (VBHW_retc!=1))
      begin
        outfile=$fopen(errFileName,"a");
        $strobe("phsj1a_7      VBHW    leaving   OCA ( 375.000 V ..  ) at %7.4r  %M", $abstime );
        $fwrite(outfile,"phsj1a_7      VBHW    leaving   OCA ( 375.000 V ..  ) at %7.4r  %M\n", $abstime );
        VBHW_retc=1;
        VBHW_cnt=VBHW_cnt-1;
        $fclose(outfile);
      end
   end
   else
   begin
      if(VBHW_cnt==0)
      begin
        outfile=$fopen(errFileName,"a");
        $strobe("phsj1a_7      VBHW    error limit ( %d ) reached at %7.4r  %M", maxEv, $abstime );
        $fwrite(outfile,"phsj1a_7      VBHW    error limit ( %d ) reached at %7.4r  %M\n", maxEv, $abstime );
        VBHW_cnt=VBHW_cnt-1;
        $fclose(outfile);
      end
   end

end // analog
endmodule // phsj1a_7

// Verilog-A OC Watch for device phsj2b_7 Parameters  VGS VGD VDS VDB VBHW
module phsj2b_7_ahdl(D,G,S,B,HW);
parameter tstep_occ=100n;
parameter errFileName="./occ.err";
parameter maxEv = 25;
parameter maxEv_flg = 0;
inout D,G,S,B,HW;
electrical D,G,S,B,HW;

integer outfile;
real V_B_HW;
real V_D_B;
real V_D_S;
real V_G_D;
real V_G_S;
real VGS;
integer VGS_retc;
integer VGS_cnt;
real VGD;
integer VGD_retc;
integer VGD_cnt;
real VDS;
integer VDS_retc;
integer VDS_cnt;
real VDB;
integer VDB_retc;
integer VDB_cnt;
real VBHW;
integer VBHW_retc;
integer VBHW_cnt;

analog begin
   $bound_step( tstep_occ );
   @(initial_step) begin
      VGS_retc=0;
      VGS_cnt = maxEv;
      VGD_retc=0;
      VGD_cnt = maxEv;
      VDS_retc=0;
      VDS_cnt = maxEv;
      VDB_retc=0;
      VDB_cnt = maxEv;
      VBHW_retc=0;
      VBHW_cnt = maxEv;
   end
   V_B_HW = V(B,HW);
   V_D_B = V(D,B);
   V_D_S = V(D,S);
   V_G_D = V(G,D);
   V_G_S = V(G,S);

//      VGS
   VGS = V_G_S;
   if((VGS_cnt>0) || ( maxEv_flg==0 ))   begin
      if( (VGS < -5.5) && (VGS_retc!=-1))
      begin
        outfile=$fopen(errFileName,"a");
        $strobe("phsj2b_7      VGS     leaving   OCA (  .. -5.500 V ) at %7.4r  %M", $abstime );
        $fwrite(outfile,"phsj2b_7      VGS     leaving   OCA (  .. -5.500 V ) at %7.4r  %M\n", $abstime );
        VGS_retc=-1;
        VGS_cnt=VGS_cnt-1;
        $fclose(outfile);
      end
      if((VGS >= -5.5) &&  (VGS <= 5.5) && (VGS_retc!=0))
      begin
        outfile=$fopen(errFileName,"a");
        $strobe("phsj2b_7      VGS     entering SOCA ( -5.500 V .. 5.500 V ) at %7.4r  %M", $abstime );
        $fwrite(outfile,"phsj2b_7      VGS     entering SOCA ( -5.500 V .. 5.500 V ) at %7.4r  %M\n", $abstime );
        VGS_retc=0;
        VGS_cnt=VGS_cnt-1;
        $fclose(outfile);
      end
      if((VGS > 5.5) &&  (VGS_retc!=1))
      begin
        outfile=$fopen(errFileName,"a");
        $strobe("phsj2b_7      VGS     leaving   OCA ( 5.500 V ..  ) at %7.4r  %M", $abstime );
        $fwrite(outfile,"phsj2b_7      VGS     leaving   OCA ( 5.500 V ..  ) at %7.4r  %M\n", $abstime );
        VGS_retc=1;
        VGS_cnt=VGS_cnt-1;
        $fclose(outfile);
      end
   end
   else
   begin
      if(VGS_cnt==0)
      begin
        outfile=$fopen(errFileName,"a");
        $strobe("phsj2b_7      VGS     error limit ( %d ) reached at %7.4r  %M", maxEv, $abstime );
        $fwrite(outfile,"phsj2b_7      VGS     error limit ( %d ) reached at %7.4r  %M\n", maxEv, $abstime );
        VGS_cnt=VGS_cnt-1;
        $fclose(outfile);
      end
   end

//      VGD
   VGD = V_G_D;
   if((VGD_cnt>0) || ( maxEv_flg==0 ))   begin
      if( (VGD < -5.5) && (VGD_retc!=-1))
      begin
        outfile=$fopen(errFileName,"a");
        $strobe("phsj2b_7      VGD     leaving   OCA (  .. -5.500 V ) at %7.4r  %M", $abstime );
        $fwrite(outfile,"phsj2b_7      VGD     leaving   OCA (  .. -5.500 V ) at %7.4r  %M\n", $abstime );
        VGD_retc=-1;
        VGD_cnt=VGD_cnt-1;
        $fclose(outfile);
      end
      if((VGD >= -5.5) &&  (VGD <= 115) && (VGD_retc!=0))
      begin
        outfile=$fopen(errFileName,"a");
        $strobe("phsj2b_7      VGD     entering SOCA ( -5.500 V .. 115.000 V ) at %7.4r  %M", $abstime );
        $fwrite(outfile,"phsj2b_7      VGD     entering SOCA ( -5.500 V .. 115.000 V ) at %7.4r  %M\n", $abstime );
        VGD_retc=0;
        VGD_cnt=VGD_cnt-1;
        $fclose(outfile);
      end
      if((VGD > 115) &&  (VGD_retc!=1))
      begin
        outfile=$fopen(errFileName,"a");
        $strobe("phsj2b_7      VGD     leaving   OCA ( 115.000 V ..  ) at %7.4r  %M", $abstime );
        $fwrite(outfile,"phsj2b_7      VGD     leaving   OCA ( 115.000 V ..  ) at %7.4r  %M\n", $abstime );
        VGD_retc=1;
        VGD_cnt=VGD_cnt-1;
        $fclose(outfile);
      end
   end
   else
   begin
      if(VGD_cnt==0)
      begin
        outfile=$fopen(errFileName,"a");
        $strobe("phsj2b_7      VGD     error limit ( %d ) reached at %7.4r  %M", maxEv, $abstime );
        $fwrite(outfile,"phsj2b_7      VGD     error limit ( %d ) reached at %7.4r  %M\n", maxEv, $abstime );
        VGD_cnt=VGD_cnt-1;
        $fclose(outfile);
      end
   end

//      VDS
   VDS = V_D_S;
   if((VDS_cnt>0) || ( maxEv_flg==0 ))   begin
      if( (VDS < -115) && (VDS_retc!=-1))
      begin
        outfile=$fopen(errFileName,"a");
        $strobe("phsj2b_7      VDS     leaving   OCA (  .. -115.000 V ) at %7.4r  %M", $abstime );
        $fwrite(outfile,"phsj2b_7      VDS     leaving   OCA (  .. -115.000 V ) at %7.4r  %M\n", $abstime );
        VDS_retc=-1;
        VDS_cnt=VDS_cnt-1;
        $fclose(outfile);
      end
      if((VDS >= -115) &&  (VDS <= 1.5) && (VDS_retc!=0))
      begin
        outfile=$fopen(errFileName,"a");
        $strobe("phsj2b_7      VDS     entering SOCA ( -115.000 V .. 1.500 V ) at %7.4r  %M", $abstime );
        $fwrite(outfile,"phsj2b_7      VDS     entering SOCA ( -115.000 V .. 1.500 V ) at %7.4r  %M\n", $abstime );
        VDS_retc=0;
        VDS_cnt=VDS_cnt-1;
        $fclose(outfile);
      end
      if((VDS > 1.5) &&  (VDS_retc!=1))
      begin
        outfile=$fopen(errFileName,"a");
        $strobe("phsj2b_7      VDS     leaving   OCA ( 1.500 V ..  ) at %7.4r  %M", $abstime );
        $fwrite(outfile,"phsj2b_7      VDS     leaving   OCA ( 1.500 V ..  ) at %7.4r  %M\n", $abstime );
        VDS_retc=1;
        VDS_cnt=VDS_cnt-1;
        $fclose(outfile);
      end
   end
   else
   begin
      if(VDS_cnt==0)
      begin
        outfile=$fopen(errFileName,"a");
        $strobe("phsj2b_7      VDS     error limit ( %d ) reached at %7.4r  %M", maxEv, $abstime );
        $fwrite(outfile,"phsj2b_7      VDS     error limit ( %d ) reached at %7.4r  %M\n", maxEv, $abstime );
        VDS_cnt=VDS_cnt-1;
        $fclose(outfile);
      end
   end

//      VDB
   VDB = V_D_B;
   if((VDB_cnt>0) || ( maxEv_flg==0 ))   begin
      if( (VDB < -115) && (VDB_retc!=-1))
      begin
        outfile=$fopen(errFileName,"a");
        $strobe("phsj2b_7      VDB     leaving   OCA (  .. -115.000 V ) at %7.4r  %M", $abstime );
        $fwrite(outfile,"phsj2b_7      VDB     leaving   OCA (  .. -115.000 V ) at %7.4r  %M\n", $abstime );
        VDB_retc=-1;
        VDB_cnt=VDB_cnt-1;
        $fclose(outfile);
      end
      if((VDB >= -115) &&  (VDB <= 1.5) && (VDB_retc!=0))
      begin
        outfile=$fopen(errFileName,"a");
        $strobe("phsj2b_7      VDB     entering SOCA ( -115.000 V .. 1.500 V ) at %7.4r  %M", $abstime );
        $fwrite(outfile,"phsj2b_7      VDB     entering SOCA ( -115.000 V .. 1.500 V ) at %7.4r  %M\n", $abstime );
        VDB_retc=0;
        VDB_cnt=VDB_cnt-1;
        $fclose(outfile);
      end
      if((VDB > 1.5) &&  (VDB_retc!=1))
      begin
        outfile=$fopen(errFileName,"a");
        $strobe("phsj2b_7      VDB     leaving   OCA ( 1.500 V ..  ) at %7.4r  %M", $abstime );
        $fwrite(outfile,"phsj2b_7      VDB     leaving   OCA ( 1.500 V ..  ) at %7.4r  %M\n", $abstime );
        VDB_retc=1;
        VDB_cnt=VDB_cnt-1;
        $fclose(outfile);
      end
   end
   else
   begin
      if(VDB_cnt==0)
      begin
        outfile=$fopen(errFileName,"a");
        $strobe("phsj2b_7      VDB     error limit ( %d ) reached at %7.4r  %M", maxEv, $abstime );
        $fwrite(outfile,"phsj2b_7      VDB     error limit ( %d ) reached at %7.4r  %M\n", maxEv, $abstime );
        VDB_cnt=VDB_cnt-1;
        $fclose(outfile);
      end
   end

//      VBHW
   VBHW = V_B_HW;
   if((VBHW_cnt>0) || ( maxEv_flg==0 ))   begin
      if( (VBHW < -0.1) && (VBHW_retc!=-1))
      begin
        outfile=$fopen(errFileName,"a");
        $strobe("phsj2b_7      VBHW    leaving   OCA (  .. -0.100 V ) at %7.4r  %M", $abstime );
        $fwrite(outfile,"phsj2b_7      VBHW    leaving   OCA (  .. -0.100 V ) at %7.4r  %M\n", $abstime );
        VBHW_retc=-1;
        VBHW_cnt=VBHW_cnt-1;
        $fclose(outfile);
      end
      if((VBHW >= -0.1) &&  (VBHW <= 375) && (VBHW_retc!=0))
      begin
        outfile=$fopen(errFileName,"a");
        $strobe("phsj2b_7      VBHW    entering SOCA ( -0.100 V .. 375.000 V ) at %7.4r  %M", $abstime );
        $fwrite(outfile,"phsj2b_7      VBHW    entering SOCA ( -0.100 V .. 375.000 V ) at %7.4r  %M\n", $abstime );
        VBHW_retc=0;
        VBHW_cnt=VBHW_cnt-1;
        $fclose(outfile);
      end
      if((VBHW > 375) &&  (VBHW_retc!=1))
      begin
        outfile=$fopen(errFileName,"a");
        $strobe("phsj2b_7      VBHW    leaving   OCA ( 375.000 V ..  ) at %7.4r  %M", $abstime );
        $fwrite(outfile,"phsj2b_7      VBHW    leaving   OCA ( 375.000 V ..  ) at %7.4r  %M\n", $abstime );
        VBHW_retc=1;
        VBHW_cnt=VBHW_cnt-1;
        $fclose(outfile);
      end
   end
   else
   begin
      if(VBHW_cnt==0)
      begin
        outfile=$fopen(errFileName,"a");
        $strobe("phsj2b_7      VBHW    error limit ( %d ) reached at %7.4r  %M", maxEv, $abstime );
        $fwrite(outfile,"phsj2b_7      VBHW    error limit ( %d ) reached at %7.4r  %M\n", maxEv, $abstime );
        VBHW_cnt=VBHW_cnt-1;
        $fclose(outfile);
      end
   end

end // analog
endmodule // phsj2b_7

// Verilog-A OC Watch for device phsj1a_8 Parameters  VGS VGD VDS VDB VBHW
module phsj1a_8_ahdl(D,G,S,B,HW);
parameter tstep_occ=100n;
parameter errFileName="./occ.err";
parameter maxEv = 25;
parameter maxEv_flg = 0;
inout D,G,S,B,HW;
electrical D,G,S,B,HW;

integer outfile;
real V_B_HW;
real V_D_B;
real V_D_S;
real V_G_D;
real V_G_S;
real VGS;
integer VGS_retc;
integer VGS_cnt;
real VGD;
integer VGD_retc;
integer VGD_cnt;
real VDS;
integer VDS_retc;
integer VDS_cnt;
real VDB;
integer VDB_retc;
integer VDB_cnt;
real VBHW;
integer VBHW_retc;
integer VBHW_cnt;

analog begin
   $bound_step( tstep_occ );
   @(initial_step) begin
      VGS_retc=0;
      VGS_cnt = maxEv;
      VGD_retc=0;
      VGD_cnt = maxEv;
      VDS_retc=0;
      VDS_cnt = maxEv;
      VDB_retc=0;
      VDB_cnt = maxEv;
      VBHW_retc=0;
      VBHW_cnt = maxEv;
   end
   V_B_HW = V(B,HW);
   V_D_B = V(D,B);
   V_D_S = V(D,S);
   V_G_D = V(G,D);
   V_G_S = V(G,S);

//      VGS
   VGS = V_G_S;
   if((VGS_cnt>0) || ( maxEv_flg==0 ))   begin
      if( (VGS < -5.5) && (VGS_retc!=-1))
      begin
        outfile=$fopen(errFileName,"a");
        $strobe("phsj1a_8      VGS     leaving   OCA (  .. -5.500 V ) at %7.4r  %M", $abstime );
        $fwrite(outfile,"phsj1a_8      VGS     leaving   OCA (  .. -5.500 V ) at %7.4r  %M\n", $abstime );
        VGS_retc=-1;
        VGS_cnt=VGS_cnt-1;
        $fclose(outfile);
      end
      if((VGS >= -5.5) &&  (VGS <= 5.5) && (VGS_retc!=0))
      begin
        outfile=$fopen(errFileName,"a");
        $strobe("phsj1a_8      VGS     entering SOCA ( -5.500 V .. 5.500 V ) at %7.4r  %M", $abstime );
        $fwrite(outfile,"phsj1a_8      VGS     entering SOCA ( -5.500 V .. 5.500 V ) at %7.4r  %M\n", $abstime );
        VGS_retc=0;
        VGS_cnt=VGS_cnt-1;
        $fclose(outfile);
      end
      if((VGS > 5.5) &&  (VGS_retc!=1))
      begin
        outfile=$fopen(errFileName,"a");
        $strobe("phsj1a_8      VGS     leaving   OCA ( 5.500 V ..  ) at %7.4r  %M", $abstime );
        $fwrite(outfile,"phsj1a_8      VGS     leaving   OCA ( 5.500 V ..  ) at %7.4r  %M\n", $abstime );
        VGS_retc=1;
        VGS_cnt=VGS_cnt-1;
        $fclose(outfile);
      end
   end
   else
   begin
      if(VGS_cnt==0)
      begin
        outfile=$fopen(errFileName,"a");
        $strobe("phsj1a_8      VGS     error limit ( %d ) reached at %7.4r  %M", maxEv, $abstime );
        $fwrite(outfile,"phsj1a_8      VGS     error limit ( %d ) reached at %7.4r  %M\n", maxEv, $abstime );
        VGS_cnt=VGS_cnt-1;
        $fclose(outfile);
      end
   end

//      VGD
   VGD = V_G_D;
   if((VGD_cnt>0) || ( maxEv_flg==0 ))   begin
      if( (VGD < -5.5) && (VGD_retc!=-1))
      begin
        outfile=$fopen(errFileName,"a");
        $strobe("phsj1a_8      VGD     leaving   OCA (  .. -5.500 V ) at %7.4r  %M", $abstime );
        $fwrite(outfile,"phsj1a_8      VGD     leaving   OCA (  .. -5.500 V ) at %7.4r  %M\n", $abstime );
        VGD_retc=-1;
        VGD_cnt=VGD_cnt-1;
        $fclose(outfile);
      end
      if((VGD >= -5.5) &&  (VGD <= 140) && (VGD_retc!=0))
      begin
        outfile=$fopen(errFileName,"a");
        $strobe("phsj1a_8      VGD     entering SOCA ( -5.500 V .. 140.000 V ) at %7.4r  %M", $abstime );
        $fwrite(outfile,"phsj1a_8      VGD     entering SOCA ( -5.500 V .. 140.000 V ) at %7.4r  %M\n", $abstime );
        VGD_retc=0;
        VGD_cnt=VGD_cnt-1;
        $fclose(outfile);
      end
      if((VGD > 140) &&  (VGD_retc!=1))
      begin
        outfile=$fopen(errFileName,"a");
        $strobe("phsj1a_8      VGD     leaving   OCA ( 140.000 V ..  ) at %7.4r  %M", $abstime );
        $fwrite(outfile,"phsj1a_8      VGD     leaving   OCA ( 140.000 V ..  ) at %7.4r  %M\n", $abstime );
        VGD_retc=1;
        VGD_cnt=VGD_cnt-1;
        $fclose(outfile);
      end
   end
   else
   begin
      if(VGD_cnt==0)
      begin
        outfile=$fopen(errFileName,"a");
        $strobe("phsj1a_8      VGD     error limit ( %d ) reached at %7.4r  %M", maxEv, $abstime );
        $fwrite(outfile,"phsj1a_8      VGD     error limit ( %d ) reached at %7.4r  %M\n", maxEv, $abstime );
        VGD_cnt=VGD_cnt-1;
        $fclose(outfile);
      end
   end

//      VDS
   VDS = V_D_S;
   if((VDS_cnt>0) || ( maxEv_flg==0 ))   begin
      if( (VDS < -140) && (VDS_retc!=-1))
      begin
        outfile=$fopen(errFileName,"a");
        $strobe("phsj1a_8      VDS     leaving   OCA (  .. -140.000 V ) at %7.4r  %M", $abstime );
        $fwrite(outfile,"phsj1a_8      VDS     leaving   OCA (  .. -140.000 V ) at %7.4r  %M\n", $abstime );
        VDS_retc=-1;
        VDS_cnt=VDS_cnt-1;
        $fclose(outfile);
      end
      if((VDS >= -140) &&  (VDS <= 1.5) && (VDS_retc!=0))
      begin
        outfile=$fopen(errFileName,"a");
        $strobe("phsj1a_8      VDS     entering SOCA ( -140.000 V .. 1.500 V ) at %7.4r  %M", $abstime );
        $fwrite(outfile,"phsj1a_8      VDS     entering SOCA ( -140.000 V .. 1.500 V ) at %7.4r  %M\n", $abstime );
        VDS_retc=0;
        VDS_cnt=VDS_cnt-1;
        $fclose(outfile);
      end
      if((VDS > 1.5) &&  (VDS_retc!=1))
      begin
        outfile=$fopen(errFileName,"a");
        $strobe("phsj1a_8      VDS     leaving   OCA ( 1.500 V ..  ) at %7.4r  %M", $abstime );
        $fwrite(outfile,"phsj1a_8      VDS     leaving   OCA ( 1.500 V ..  ) at %7.4r  %M\n", $abstime );
        VDS_retc=1;
        VDS_cnt=VDS_cnt-1;
        $fclose(outfile);
      end
   end
   else
   begin
      if(VDS_cnt==0)
      begin
        outfile=$fopen(errFileName,"a");
        $strobe("phsj1a_8      VDS     error limit ( %d ) reached at %7.4r  %M", maxEv, $abstime );
        $fwrite(outfile,"phsj1a_8      VDS     error limit ( %d ) reached at %7.4r  %M\n", maxEv, $abstime );
        VDS_cnt=VDS_cnt-1;
        $fclose(outfile);
      end
   end

//      VDB
   VDB = V_D_B;
   if((VDB_cnt>0) || ( maxEv_flg==0 ))   begin
      if( (VDB < -140) && (VDB_retc!=-1))
      begin
        outfile=$fopen(errFileName,"a");
        $strobe("phsj1a_8      VDB     leaving   OCA (  .. -140.000 V ) at %7.4r  %M", $abstime );
        $fwrite(outfile,"phsj1a_8      VDB     leaving   OCA (  .. -140.000 V ) at %7.4r  %M\n", $abstime );
        VDB_retc=-1;
        VDB_cnt=VDB_cnt-1;
        $fclose(outfile);
      end
      if((VDB >= -140) &&  (VDB <= 1.5) && (VDB_retc!=0))
      begin
        outfile=$fopen(errFileName,"a");
        $strobe("phsj1a_8      VDB     entering SOCA ( -140.000 V .. 1.500 V ) at %7.4r  %M", $abstime );
        $fwrite(outfile,"phsj1a_8      VDB     entering SOCA ( -140.000 V .. 1.500 V ) at %7.4r  %M\n", $abstime );
        VDB_retc=0;
        VDB_cnt=VDB_cnt-1;
        $fclose(outfile);
      end
      if((VDB > 1.5) &&  (VDB_retc!=1))
      begin
        outfile=$fopen(errFileName,"a");
        $strobe("phsj1a_8      VDB     leaving   OCA ( 1.500 V ..  ) at %7.4r  %M", $abstime );
        $fwrite(outfile,"phsj1a_8      VDB     leaving   OCA ( 1.500 V ..  ) at %7.4r  %M\n", $abstime );
        VDB_retc=1;
        VDB_cnt=VDB_cnt-1;
        $fclose(outfile);
      end
   end
   else
   begin
      if(VDB_cnt==0)
      begin
        outfile=$fopen(errFileName,"a");
        $strobe("phsj1a_8      VDB     error limit ( %d ) reached at %7.4r  %M", maxEv, $abstime );
        $fwrite(outfile,"phsj1a_8      VDB     error limit ( %d ) reached at %7.4r  %M\n", maxEv, $abstime );
        VDB_cnt=VDB_cnt-1;
        $fclose(outfile);
      end
   end

//      VBHW
   VBHW = V_B_HW;
   if((VBHW_cnt>0) || ( maxEv_flg==0 ))   begin
      if( (VBHW < -0.1) && (VBHW_retc!=-1))
      begin
        outfile=$fopen(errFileName,"a");
        $strobe("phsj1a_8      VBHW    leaving   OCA (  .. -0.100 V ) at %7.4r  %M", $abstime );
        $fwrite(outfile,"phsj1a_8      VBHW    leaving   OCA (  .. -0.100 V ) at %7.4r  %M\n", $abstime );
        VBHW_retc=-1;
        VBHW_cnt=VBHW_cnt-1;
        $fclose(outfile);
      end
      if((VBHW >= -0.1) &&  (VBHW <= 400) && (VBHW_retc!=0))
      begin
        outfile=$fopen(errFileName,"a");
        $strobe("phsj1a_8      VBHW    entering SOCA ( -0.100 V .. 400.000 V ) at %7.4r  %M", $abstime );
        $fwrite(outfile,"phsj1a_8      VBHW    entering SOCA ( -0.100 V .. 400.000 V ) at %7.4r  %M\n", $abstime );
        VBHW_retc=0;
        VBHW_cnt=VBHW_cnt-1;
        $fclose(outfile);
      end
      if((VBHW > 400) &&  (VBHW_retc!=1))
      begin
        outfile=$fopen(errFileName,"a");
        $strobe("phsj1a_8      VBHW    leaving   OCA ( 400.000 V ..  ) at %7.4r  %M", $abstime );
        $fwrite(outfile,"phsj1a_8      VBHW    leaving   OCA ( 400.000 V ..  ) at %7.4r  %M\n", $abstime );
        VBHW_retc=1;
        VBHW_cnt=VBHW_cnt-1;
        $fclose(outfile);
      end
   end
   else
   begin
      if(VBHW_cnt==0)
      begin
        outfile=$fopen(errFileName,"a");
        $strobe("phsj1a_8      VBHW    error limit ( %d ) reached at %7.4r  %M", maxEv, $abstime );
        $fwrite(outfile,"phsj1a_8      VBHW    error limit ( %d ) reached at %7.4r  %M\n", maxEv, $abstime );
        VBHW_cnt=VBHW_cnt-1;
        $fclose(outfile);
      end
   end

end // analog
endmodule // phsj1a_8

// Verilog-A OC Watch for device phsj2b_8 Parameters  VGS VGD VDS VDB VBHW
module phsj2b_8_ahdl(D,G,S,B,HW);
parameter tstep_occ=100n;
parameter errFileName="./occ.err";
parameter maxEv = 25;
parameter maxEv_flg = 0;
inout D,G,S,B,HW;
electrical D,G,S,B,HW;

integer outfile;
real V_B_HW;
real V_D_B;
real V_D_S;
real V_G_D;
real V_G_S;
real VGS;
integer VGS_retc;
integer VGS_cnt;
real VGD;
integer VGD_retc;
integer VGD_cnt;
real VDS;
integer VDS_retc;
integer VDS_cnt;
real VDB;
integer VDB_retc;
integer VDB_cnt;
real VBHW;
integer VBHW_retc;
integer VBHW_cnt;

analog begin
   $bound_step( tstep_occ );
   @(initial_step) begin
      VGS_retc=0;
      VGS_cnt = maxEv;
      VGD_retc=0;
      VGD_cnt = maxEv;
      VDS_retc=0;
      VDS_cnt = maxEv;
      VDB_retc=0;
      VDB_cnt = maxEv;
      VBHW_retc=0;
      VBHW_cnt = maxEv;
   end
   V_B_HW = V(B,HW);
   V_D_B = V(D,B);
   V_D_S = V(D,S);
   V_G_D = V(G,D);
   V_G_S = V(G,S);

//      VGS
   VGS = V_G_S;
   if((VGS_cnt>0) || ( maxEv_flg==0 ))   begin
      if( (VGS < -5.5) && (VGS_retc!=-1))
      begin
        outfile=$fopen(errFileName,"a");
        $strobe("phsj2b_8      VGS     leaving   OCA (  .. -5.500 V ) at %7.4r  %M", $abstime );
        $fwrite(outfile,"phsj2b_8      VGS     leaving   OCA (  .. -5.500 V ) at %7.4r  %M\n", $abstime );
        VGS_retc=-1;
        VGS_cnt=VGS_cnt-1;
        $fclose(outfile);
      end
      if((VGS >= -5.5) &&  (VGS <= 5.5) && (VGS_retc!=0))
      begin
        outfile=$fopen(errFileName,"a");
        $strobe("phsj2b_8      VGS     entering SOCA ( -5.500 V .. 5.500 V ) at %7.4r  %M", $abstime );
        $fwrite(outfile,"phsj2b_8      VGS     entering SOCA ( -5.500 V .. 5.500 V ) at %7.4r  %M\n", $abstime );
        VGS_retc=0;
        VGS_cnt=VGS_cnt-1;
        $fclose(outfile);
      end
      if((VGS > 5.5) &&  (VGS_retc!=1))
      begin
        outfile=$fopen(errFileName,"a");
        $strobe("phsj2b_8      VGS     leaving   OCA ( 5.500 V ..  ) at %7.4r  %M", $abstime );
        $fwrite(outfile,"phsj2b_8      VGS     leaving   OCA ( 5.500 V ..  ) at %7.4r  %M\n", $abstime );
        VGS_retc=1;
        VGS_cnt=VGS_cnt-1;
        $fclose(outfile);
      end
   end
   else
   begin
      if(VGS_cnt==0)
      begin
        outfile=$fopen(errFileName,"a");
        $strobe("phsj2b_8      VGS     error limit ( %d ) reached at %7.4r  %M", maxEv, $abstime );
        $fwrite(outfile,"phsj2b_8      VGS     error limit ( %d ) reached at %7.4r  %M\n", maxEv, $abstime );
        VGS_cnt=VGS_cnt-1;
        $fclose(outfile);
      end
   end

//      VGD
   VGD = V_G_D;
   if((VGD_cnt>0) || ( maxEv_flg==0 ))   begin
      if( (VGD < -5.5) && (VGD_retc!=-1))
      begin
        outfile=$fopen(errFileName,"a");
        $strobe("phsj2b_8      VGD     leaving   OCA (  .. -5.500 V ) at %7.4r  %M", $abstime );
        $fwrite(outfile,"phsj2b_8      VGD     leaving   OCA (  .. -5.500 V ) at %7.4r  %M\n", $abstime );
        VGD_retc=-1;
        VGD_cnt=VGD_cnt-1;
        $fclose(outfile);
      end
      if((VGD >= -5.5) &&  (VGD <= 140) && (VGD_retc!=0))
      begin
        outfile=$fopen(errFileName,"a");
        $strobe("phsj2b_8      VGD     entering SOCA ( -5.500 V .. 140.000 V ) at %7.4r  %M", $abstime );
        $fwrite(outfile,"phsj2b_8      VGD     entering SOCA ( -5.500 V .. 140.000 V ) at %7.4r  %M\n", $abstime );
        VGD_retc=0;
        VGD_cnt=VGD_cnt-1;
        $fclose(outfile);
      end
      if((VGD > 140) &&  (VGD_retc!=1))
      begin
        outfile=$fopen(errFileName,"a");
        $strobe("phsj2b_8      VGD     leaving   OCA ( 140.000 V ..  ) at %7.4r  %M", $abstime );
        $fwrite(outfile,"phsj2b_8      VGD     leaving   OCA ( 140.000 V ..  ) at %7.4r  %M\n", $abstime );
        VGD_retc=1;
        VGD_cnt=VGD_cnt-1;
        $fclose(outfile);
      end
   end
   else
   begin
      if(VGD_cnt==0)
      begin
        outfile=$fopen(errFileName,"a");
        $strobe("phsj2b_8      VGD     error limit ( %d ) reached at %7.4r  %M", maxEv, $abstime );
        $fwrite(outfile,"phsj2b_8      VGD     error limit ( %d ) reached at %7.4r  %M\n", maxEv, $abstime );
        VGD_cnt=VGD_cnt-1;
        $fclose(outfile);
      end
   end

//      VDS
   VDS = V_D_S;
   if((VDS_cnt>0) || ( maxEv_flg==0 ))   begin
      if( (VDS < -140) && (VDS_retc!=-1))
      begin
        outfile=$fopen(errFileName,"a");
        $strobe("phsj2b_8      VDS     leaving   OCA (  .. -140.000 V ) at %7.4r  %M", $abstime );
        $fwrite(outfile,"phsj2b_8      VDS     leaving   OCA (  .. -140.000 V ) at %7.4r  %M\n", $abstime );
        VDS_retc=-1;
        VDS_cnt=VDS_cnt-1;
        $fclose(outfile);
      end
      if((VDS >= -140) &&  (VDS <= 1.5) && (VDS_retc!=0))
      begin
        outfile=$fopen(errFileName,"a");
        $strobe("phsj2b_8      VDS     entering SOCA ( -140.000 V .. 1.500 V ) at %7.4r  %M", $abstime );
        $fwrite(outfile,"phsj2b_8      VDS     entering SOCA ( -140.000 V .. 1.500 V ) at %7.4r  %M\n", $abstime );
        VDS_retc=0;
        VDS_cnt=VDS_cnt-1;
        $fclose(outfile);
      end
      if((VDS > 1.5) &&  (VDS_retc!=1))
      begin
        outfile=$fopen(errFileName,"a");
        $strobe("phsj2b_8      VDS     leaving   OCA ( 1.500 V ..  ) at %7.4r  %M", $abstime );
        $fwrite(outfile,"phsj2b_8      VDS     leaving   OCA ( 1.500 V ..  ) at %7.4r  %M\n", $abstime );
        VDS_retc=1;
        VDS_cnt=VDS_cnt-1;
        $fclose(outfile);
      end
   end
   else
   begin
      if(VDS_cnt==0)
      begin
        outfile=$fopen(errFileName,"a");
        $strobe("phsj2b_8      VDS     error limit ( %d ) reached at %7.4r  %M", maxEv, $abstime );
        $fwrite(outfile,"phsj2b_8      VDS     error limit ( %d ) reached at %7.4r  %M\n", maxEv, $abstime );
        VDS_cnt=VDS_cnt-1;
        $fclose(outfile);
      end
   end

//      VDB
   VDB = V_D_B;
   if((VDB_cnt>0) || ( maxEv_flg==0 ))   begin
      if( (VDB < -140) && (VDB_retc!=-1))
      begin
        outfile=$fopen(errFileName,"a");
        $strobe("phsj2b_8      VDB     leaving   OCA (  .. -140.000 V ) at %7.4r  %M", $abstime );
        $fwrite(outfile,"phsj2b_8      VDB     leaving   OCA (  .. -140.000 V ) at %7.4r  %M\n", $abstime );
        VDB_retc=-1;
        VDB_cnt=VDB_cnt-1;
        $fclose(outfile);
      end
      if((VDB >= -140) &&  (VDB <= 1.5) && (VDB_retc!=0))
      begin
        outfile=$fopen(errFileName,"a");
        $strobe("phsj2b_8      VDB     entering SOCA ( -140.000 V .. 1.500 V ) at %7.4r  %M", $abstime );
        $fwrite(outfile,"phsj2b_8      VDB     entering SOCA ( -140.000 V .. 1.500 V ) at %7.4r  %M\n", $abstime );
        VDB_retc=0;
        VDB_cnt=VDB_cnt-1;
        $fclose(outfile);
      end
      if((VDB > 1.5) &&  (VDB_retc!=1))
      begin
        outfile=$fopen(errFileName,"a");
        $strobe("phsj2b_8      VDB     leaving   OCA ( 1.500 V ..  ) at %7.4r  %M", $abstime );
        $fwrite(outfile,"phsj2b_8      VDB     leaving   OCA ( 1.500 V ..  ) at %7.4r  %M\n", $abstime );
        VDB_retc=1;
        VDB_cnt=VDB_cnt-1;
        $fclose(outfile);
      end
   end
   else
   begin
      if(VDB_cnt==0)
      begin
        outfile=$fopen(errFileName,"a");
        $strobe("phsj2b_8      VDB     error limit ( %d ) reached at %7.4r  %M", maxEv, $abstime );
        $fwrite(outfile,"phsj2b_8      VDB     error limit ( %d ) reached at %7.4r  %M\n", maxEv, $abstime );
        VDB_cnt=VDB_cnt-1;
        $fclose(outfile);
      end
   end

//      VBHW
   VBHW = V_B_HW;
   if((VBHW_cnt>0) || ( maxEv_flg==0 ))   begin
      if( (VBHW < -0.1) && (VBHW_retc!=-1))
      begin
        outfile=$fopen(errFileName,"a");
        $strobe("phsj2b_8      VBHW    leaving   OCA (  .. -0.100 V ) at %7.4r  %M", $abstime );
        $fwrite(outfile,"phsj2b_8      VBHW    leaving   OCA (  .. -0.100 V ) at %7.4r  %M\n", $abstime );
        VBHW_retc=-1;
        VBHW_cnt=VBHW_cnt-1;
        $fclose(outfile);
      end
      if((VBHW >= -0.1) &&  (VBHW <= 400) && (VBHW_retc!=0))
      begin
        outfile=$fopen(errFileName,"a");
        $strobe("phsj2b_8      VBHW    entering SOCA ( -0.100 V .. 400.000 V ) at %7.4r  %M", $abstime );
        $fwrite(outfile,"phsj2b_8      VBHW    entering SOCA ( -0.100 V .. 400.000 V ) at %7.4r  %M\n", $abstime );
        VBHW_retc=0;
        VBHW_cnt=VBHW_cnt-1;
        $fclose(outfile);
      end
      if((VBHW > 400) &&  (VBHW_retc!=1))
      begin
        outfile=$fopen(errFileName,"a");
        $strobe("phsj2b_8      VBHW    leaving   OCA ( 400.000 V ..  ) at %7.4r  %M", $abstime );
        $fwrite(outfile,"phsj2b_8      VBHW    leaving   OCA ( 400.000 V ..  ) at %7.4r  %M\n", $abstime );
        VBHW_retc=1;
        VBHW_cnt=VBHW_cnt-1;
        $fclose(outfile);
      end
   end
   else
   begin
      if(VBHW_cnt==0)
      begin
        outfile=$fopen(errFileName,"a");
        $strobe("phsj2b_8      VBHW    error limit ( %d ) reached at %7.4r  %M", maxEv, $abstime );
        $fwrite(outfile,"phsj2b_8      VBHW    error limit ( %d ) reached at %7.4r  %M\n", maxEv, $abstime );
        VBHW_cnt=VBHW_cnt-1;
        $fclose(outfile);
      end
   end

end // analog
endmodule // phsj2b_8

// Verilog-A OC Watch for device phsj1a_10 Parameters  VGS VGD VDS VDB VBHW
module phsj1a_10_ahdl(D,G,S,B,HW);
parameter tstep_occ=100n;
parameter errFileName="./occ.err";
parameter maxEv = 25;
parameter maxEv_flg = 0;
inout D,G,S,B,HW;
electrical D,G,S,B,HW;

integer outfile;
real V_B_HW;
real V_D_B;
real V_D_S;
real V_G_D;
real V_G_S;
real VGS;
integer VGS_retc;
integer VGS_cnt;
real VGD;
integer VGD_retc;
integer VGD_cnt;
real VDS;
integer VDS_retc;
integer VDS_cnt;
real VDB;
integer VDB_retc;
integer VDB_cnt;
real VBHW;
integer VBHW_retc;
integer VBHW_cnt;

analog begin
   $bound_step( tstep_occ );
   @(initial_step) begin
      VGS_retc=0;
      VGS_cnt = maxEv;
      VGD_retc=0;
      VGD_cnt = maxEv;
      VDS_retc=0;
      VDS_cnt = maxEv;
      VDB_retc=0;
      VDB_cnt = maxEv;
      VBHW_retc=0;
      VBHW_cnt = maxEv;
   end
   V_B_HW = V(B,HW);
   V_D_B = V(D,B);
   V_D_S = V(D,S);
   V_G_D = V(G,D);
   V_G_S = V(G,S);

//      VGS
   VGS = V_G_S;
   if((VGS_cnt>0) || ( maxEv_flg==0 ))   begin
      if( (VGS < -5.5) && (VGS_retc!=-1))
      begin
        outfile=$fopen(errFileName,"a");
        $strobe("phsj1a_10     VGS     leaving   OCA (  .. -5.500 V ) at %7.4r  %M", $abstime );
        $fwrite(outfile,"phsj1a_10     VGS     leaving   OCA (  .. -5.500 V ) at %7.4r  %M\n", $abstime );
        VGS_retc=-1;
        VGS_cnt=VGS_cnt-1;
        $fclose(outfile);
      end
      if((VGS >= -5.5) &&  (VGS <= 5.5) && (VGS_retc!=0))
      begin
        outfile=$fopen(errFileName,"a");
        $strobe("phsj1a_10     VGS     entering SOCA ( -5.500 V .. 5.500 V ) at %7.4r  %M", $abstime );
        $fwrite(outfile,"phsj1a_10     VGS     entering SOCA ( -5.500 V .. 5.500 V ) at %7.4r  %M\n", $abstime );
        VGS_retc=0;
        VGS_cnt=VGS_cnt-1;
        $fclose(outfile);
      end
      if((VGS > 5.5) &&  (VGS_retc!=1))
      begin
        outfile=$fopen(errFileName,"a");
        $strobe("phsj1a_10     VGS     leaving   OCA ( 5.500 V ..  ) at %7.4r  %M", $abstime );
        $fwrite(outfile,"phsj1a_10     VGS     leaving   OCA ( 5.500 V ..  ) at %7.4r  %M\n", $abstime );
        VGS_retc=1;
        VGS_cnt=VGS_cnt-1;
        $fclose(outfile);
      end
   end
   else
   begin
      if(VGS_cnt==0)
      begin
        outfile=$fopen(errFileName,"a");
        $strobe("phsj1a_10     VGS     error limit ( %d ) reached at %7.4r  %M", maxEv, $abstime );
        $fwrite(outfile,"phsj1a_10     VGS     error limit ( %d ) reached at %7.4r  %M\n", maxEv, $abstime );
        VGS_cnt=VGS_cnt-1;
        $fclose(outfile);
      end
   end

//      VGD
   VGD = V_G_D;
   if((VGD_cnt>0) || ( maxEv_flg==0 ))   begin
      if( (VGD < -5.5) && (VGD_retc!=-1))
      begin
        outfile=$fopen(errFileName,"a");
        $strobe("phsj1a_10     VGD     leaving   OCA (  .. -5.500 V ) at %7.4r  %M", $abstime );
        $fwrite(outfile,"phsj1a_10     VGD     leaving   OCA (  .. -5.500 V ) at %7.4r  %M\n", $abstime );
        VGD_retc=-1;
        VGD_cnt=VGD_cnt-1;
        $fclose(outfile);
      end
      if((VGD >= -5.5) &&  (VGD <= 155) && (VGD_retc!=0))
      begin
        outfile=$fopen(errFileName,"a");
        $strobe("phsj1a_10     VGD     entering SOCA ( -5.500 V .. 155.000 V ) at %7.4r  %M", $abstime );
        $fwrite(outfile,"phsj1a_10     VGD     entering SOCA ( -5.500 V .. 155.000 V ) at %7.4r  %M\n", $abstime );
        VGD_retc=0;
        VGD_cnt=VGD_cnt-1;
        $fclose(outfile);
      end
      if((VGD > 155) &&  (VGD_retc!=1))
      begin
        outfile=$fopen(errFileName,"a");
        $strobe("phsj1a_10     VGD     leaving   OCA ( 155.000 V ..  ) at %7.4r  %M", $abstime );
        $fwrite(outfile,"phsj1a_10     VGD     leaving   OCA ( 155.000 V ..  ) at %7.4r  %M\n", $abstime );
        VGD_retc=1;
        VGD_cnt=VGD_cnt-1;
        $fclose(outfile);
      end
   end
   else
   begin
      if(VGD_cnt==0)
      begin
        outfile=$fopen(errFileName,"a");
        $strobe("phsj1a_10     VGD     error limit ( %d ) reached at %7.4r  %M", maxEv, $abstime );
        $fwrite(outfile,"phsj1a_10     VGD     error limit ( %d ) reached at %7.4r  %M\n", maxEv, $abstime );
        VGD_cnt=VGD_cnt-1;
        $fclose(outfile);
      end
   end

//      VDS
   VDS = V_D_S;
   if((VDS_cnt>0) || ( maxEv_flg==0 ))   begin
      if( (VDS < -155) && (VDS_retc!=-1))
      begin
        outfile=$fopen(errFileName,"a");
        $strobe("phsj1a_10     VDS     leaving   OCA (  .. -155.000 V ) at %7.4r  %M", $abstime );
        $fwrite(outfile,"phsj1a_10     VDS     leaving   OCA (  .. -155.000 V ) at %7.4r  %M\n", $abstime );
        VDS_retc=-1;
        VDS_cnt=VDS_cnt-1;
        $fclose(outfile);
      end
      if((VDS >= -155) &&  (VDS <= 1.5) && (VDS_retc!=0))
      begin
        outfile=$fopen(errFileName,"a");
        $strobe("phsj1a_10     VDS     entering SOCA ( -155.000 V .. 1.500 V ) at %7.4r  %M", $abstime );
        $fwrite(outfile,"phsj1a_10     VDS     entering SOCA ( -155.000 V .. 1.500 V ) at %7.4r  %M\n", $abstime );
        VDS_retc=0;
        VDS_cnt=VDS_cnt-1;
        $fclose(outfile);
      end
      if((VDS > 1.5) &&  (VDS_retc!=1))
      begin
        outfile=$fopen(errFileName,"a");
        $strobe("phsj1a_10     VDS     leaving   OCA ( 1.500 V ..  ) at %7.4r  %M", $abstime );
        $fwrite(outfile,"phsj1a_10     VDS     leaving   OCA ( 1.500 V ..  ) at %7.4r  %M\n", $abstime );
        VDS_retc=1;
        VDS_cnt=VDS_cnt-1;
        $fclose(outfile);
      end
   end
   else
   begin
      if(VDS_cnt==0)
      begin
        outfile=$fopen(errFileName,"a");
        $strobe("phsj1a_10     VDS     error limit ( %d ) reached at %7.4r  %M", maxEv, $abstime );
        $fwrite(outfile,"phsj1a_10     VDS     error limit ( %d ) reached at %7.4r  %M\n", maxEv, $abstime );
        VDS_cnt=VDS_cnt-1;
        $fclose(outfile);
      end
   end

//      VDB
   VDB = V_D_B;
   if((VDB_cnt>0) || ( maxEv_flg==0 ))   begin
      if( (VDB < -155) && (VDB_retc!=-1))
      begin
        outfile=$fopen(errFileName,"a");
        $strobe("phsj1a_10     VDB     leaving   OCA (  .. -155.000 V ) at %7.4r  %M", $abstime );
        $fwrite(outfile,"phsj1a_10     VDB     leaving   OCA (  .. -155.000 V ) at %7.4r  %M\n", $abstime );
        VDB_retc=-1;
        VDB_cnt=VDB_cnt-1;
        $fclose(outfile);
      end
      if((VDB >= -155) &&  (VDB <= 1.5) && (VDB_retc!=0))
      begin
        outfile=$fopen(errFileName,"a");
        $strobe("phsj1a_10     VDB     entering SOCA ( -155.000 V .. 1.500 V ) at %7.4r  %M", $abstime );
        $fwrite(outfile,"phsj1a_10     VDB     entering SOCA ( -155.000 V .. 1.500 V ) at %7.4r  %M\n", $abstime );
        VDB_retc=0;
        VDB_cnt=VDB_cnt-1;
        $fclose(outfile);
      end
      if((VDB > 1.5) &&  (VDB_retc!=1))
      begin
        outfile=$fopen(errFileName,"a");
        $strobe("phsj1a_10     VDB     leaving   OCA ( 1.500 V ..  ) at %7.4r  %M", $abstime );
        $fwrite(outfile,"phsj1a_10     VDB     leaving   OCA ( 1.500 V ..  ) at %7.4r  %M\n", $abstime );
        VDB_retc=1;
        VDB_cnt=VDB_cnt-1;
        $fclose(outfile);
      end
   end
   else
   begin
      if(VDB_cnt==0)
      begin
        outfile=$fopen(errFileName,"a");
        $strobe("phsj1a_10     VDB     error limit ( %d ) reached at %7.4r  %M", maxEv, $abstime );
        $fwrite(outfile,"phsj1a_10     VDB     error limit ( %d ) reached at %7.4r  %M\n", maxEv, $abstime );
        VDB_cnt=VDB_cnt-1;
        $fclose(outfile);
      end
   end

//      VBHW
   VBHW = V_B_HW;
   if((VBHW_cnt>0) || ( maxEv_flg==0 ))   begin
      if( (VBHW < -0.1) && (VBHW_retc!=-1))
      begin
        outfile=$fopen(errFileName,"a");
        $strobe("phsj1a_10     VBHW    leaving   OCA (  .. -0.100 V ) at %7.4r  %M", $abstime );
        $fwrite(outfile,"phsj1a_10     VBHW    leaving   OCA (  .. -0.100 V ) at %7.4r  %M\n", $abstime );
        VBHW_retc=-1;
        VBHW_cnt=VBHW_cnt-1;
        $fclose(outfile);
      end
      if((VBHW >= -0.1) &&  (VBHW <= 375) && (VBHW_retc!=0))
      begin
        outfile=$fopen(errFileName,"a");
        $strobe("phsj1a_10     VBHW    entering SOCA ( -0.100 V .. 375.000 V ) at %7.4r  %M", $abstime );
        $fwrite(outfile,"phsj1a_10     VBHW    entering SOCA ( -0.100 V .. 375.000 V ) at %7.4r  %M\n", $abstime );
        VBHW_retc=0;
        VBHW_cnt=VBHW_cnt-1;
        $fclose(outfile);
      end
      if((VBHW > 375) &&  (VBHW_retc!=1))
      begin
        outfile=$fopen(errFileName,"a");
        $strobe("phsj1a_10     VBHW    leaving   OCA ( 375.000 V ..  ) at %7.4r  %M", $abstime );
        $fwrite(outfile,"phsj1a_10     VBHW    leaving   OCA ( 375.000 V ..  ) at %7.4r  %M\n", $abstime );
        VBHW_retc=1;
        VBHW_cnt=VBHW_cnt-1;
        $fclose(outfile);
      end
   end
   else
   begin
      if(VBHW_cnt==0)
      begin
        outfile=$fopen(errFileName,"a");
        $strobe("phsj1a_10     VBHW    error limit ( %d ) reached at %7.4r  %M", maxEv, $abstime );
        $fwrite(outfile,"phsj1a_10     VBHW    error limit ( %d ) reached at %7.4r  %M\n", maxEv, $abstime );
        VBHW_cnt=VBHW_cnt-1;
        $fclose(outfile);
      end
   end

end // analog
endmodule // phsj1a_10

// Verilog-A OC Watch for device phsj2b_10 Parameters  VGS VGD VDS VDB VBHW
module phsj2b_10_ahdl(D,G,S,B,HW);
parameter tstep_occ=100n;
parameter errFileName="./occ.err";
parameter maxEv = 25;
parameter maxEv_flg = 0;
inout D,G,S,B,HW;
electrical D,G,S,B,HW;

integer outfile;
real V_B_HW;
real V_D_B;
real V_D_S;
real V_G_D;
real V_G_S;
real VGS;
integer VGS_retc;
integer VGS_cnt;
real VGD;
integer VGD_retc;
integer VGD_cnt;
real VDS;
integer VDS_retc;
integer VDS_cnt;
real VDB;
integer VDB_retc;
integer VDB_cnt;
real VBHW;
integer VBHW_retc;
integer VBHW_cnt;

analog begin
   $bound_step( tstep_occ );
   @(initial_step) begin
      VGS_retc=0;
      VGS_cnt = maxEv;
      VGD_retc=0;
      VGD_cnt = maxEv;
      VDS_retc=0;
      VDS_cnt = maxEv;
      VDB_retc=0;
      VDB_cnt = maxEv;
      VBHW_retc=0;
      VBHW_cnt = maxEv;
   end
   V_B_HW = V(B,HW);
   V_D_B = V(D,B);
   V_D_S = V(D,S);
   V_G_D = V(G,D);
   V_G_S = V(G,S);

//      VGS
   VGS = V_G_S;
   if((VGS_cnt>0) || ( maxEv_flg==0 ))   begin
      if( (VGS < -5.5) && (VGS_retc!=-1))
      begin
        outfile=$fopen(errFileName,"a");
        $strobe("phsj2b_10     VGS     leaving   OCA (  .. -5.500 V ) at %7.4r  %M", $abstime );
        $fwrite(outfile,"phsj2b_10     VGS     leaving   OCA (  .. -5.500 V ) at %7.4r  %M\n", $abstime );
        VGS_retc=-1;
        VGS_cnt=VGS_cnt-1;
        $fclose(outfile);
      end
      if((VGS >= -5.5) &&  (VGS <= 5.5) && (VGS_retc!=0))
      begin
        outfile=$fopen(errFileName,"a");
        $strobe("phsj2b_10     VGS     entering SOCA ( -5.500 V .. 5.500 V ) at %7.4r  %M", $abstime );
        $fwrite(outfile,"phsj2b_10     VGS     entering SOCA ( -5.500 V .. 5.500 V ) at %7.4r  %M\n", $abstime );
        VGS_retc=0;
        VGS_cnt=VGS_cnt-1;
        $fclose(outfile);
      end
      if((VGS > 5.5) &&  (VGS_retc!=1))
      begin
        outfile=$fopen(errFileName,"a");
        $strobe("phsj2b_10     VGS     leaving   OCA ( 5.500 V ..  ) at %7.4r  %M", $abstime );
        $fwrite(outfile,"phsj2b_10     VGS     leaving   OCA ( 5.500 V ..  ) at %7.4r  %M\n", $abstime );
        VGS_retc=1;
        VGS_cnt=VGS_cnt-1;
        $fclose(outfile);
      end
   end
   else
   begin
      if(VGS_cnt==0)
      begin
        outfile=$fopen(errFileName,"a");
        $strobe("phsj2b_10     VGS     error limit ( %d ) reached at %7.4r  %M", maxEv, $abstime );
        $fwrite(outfile,"phsj2b_10     VGS     error limit ( %d ) reached at %7.4r  %M\n", maxEv, $abstime );
        VGS_cnt=VGS_cnt-1;
        $fclose(outfile);
      end
   end

//      VGD
   VGD = V_G_D;
   if((VGD_cnt>0) || ( maxEv_flg==0 ))   begin
      if( (VGD < -5.5) && (VGD_retc!=-1))
      begin
        outfile=$fopen(errFileName,"a");
        $strobe("phsj2b_10     VGD     leaving   OCA (  .. -5.500 V ) at %7.4r  %M", $abstime );
        $fwrite(outfile,"phsj2b_10     VGD     leaving   OCA (  .. -5.500 V ) at %7.4r  %M\n", $abstime );
        VGD_retc=-1;
        VGD_cnt=VGD_cnt-1;
        $fclose(outfile);
      end
      if((VGD >= -5.5) &&  (VGD <= 155) && (VGD_retc!=0))
      begin
        outfile=$fopen(errFileName,"a");
        $strobe("phsj2b_10     VGD     entering SOCA ( -5.500 V .. 155.000 V ) at %7.4r  %M", $abstime );
        $fwrite(outfile,"phsj2b_10     VGD     entering SOCA ( -5.500 V .. 155.000 V ) at %7.4r  %M\n", $abstime );
        VGD_retc=0;
        VGD_cnt=VGD_cnt-1;
        $fclose(outfile);
      end
      if((VGD > 155) &&  (VGD_retc!=1))
      begin
        outfile=$fopen(errFileName,"a");
        $strobe("phsj2b_10     VGD     leaving   OCA ( 155.000 V ..  ) at %7.4r  %M", $abstime );
        $fwrite(outfile,"phsj2b_10     VGD     leaving   OCA ( 155.000 V ..  ) at %7.4r  %M\n", $abstime );
        VGD_retc=1;
        VGD_cnt=VGD_cnt-1;
        $fclose(outfile);
      end
   end
   else
   begin
      if(VGD_cnt==0)
      begin
        outfile=$fopen(errFileName,"a");
        $strobe("phsj2b_10     VGD     error limit ( %d ) reached at %7.4r  %M", maxEv, $abstime );
        $fwrite(outfile,"phsj2b_10     VGD     error limit ( %d ) reached at %7.4r  %M\n", maxEv, $abstime );
        VGD_cnt=VGD_cnt-1;
        $fclose(outfile);
      end
   end

//      VDS
   VDS = V_D_S;
   if((VDS_cnt>0) || ( maxEv_flg==0 ))   begin
      if( (VDS < -155) && (VDS_retc!=-1))
      begin
        outfile=$fopen(errFileName,"a");
        $strobe("phsj2b_10     VDS     leaving   OCA (  .. -155.000 V ) at %7.4r  %M", $abstime );
        $fwrite(outfile,"phsj2b_10     VDS     leaving   OCA (  .. -155.000 V ) at %7.4r  %M\n", $abstime );
        VDS_retc=-1;
        VDS_cnt=VDS_cnt-1;
        $fclose(outfile);
      end
      if((VDS >= -155) &&  (VDS <= 1.5) && (VDS_retc!=0))
      begin
        outfile=$fopen(errFileName,"a");
        $strobe("phsj2b_10     VDS     entering SOCA ( -155.000 V .. 1.500 V ) at %7.4r  %M", $abstime );
        $fwrite(outfile,"phsj2b_10     VDS     entering SOCA ( -155.000 V .. 1.500 V ) at %7.4r  %M\n", $abstime );
        VDS_retc=0;
        VDS_cnt=VDS_cnt-1;
        $fclose(outfile);
      end
      if((VDS > 1.5) &&  (VDS_retc!=1))
      begin
        outfile=$fopen(errFileName,"a");
        $strobe("phsj2b_10     VDS     leaving   OCA ( 1.500 V ..  ) at %7.4r  %M", $abstime );
        $fwrite(outfile,"phsj2b_10     VDS     leaving   OCA ( 1.500 V ..  ) at %7.4r  %M\n", $abstime );
        VDS_retc=1;
        VDS_cnt=VDS_cnt-1;
        $fclose(outfile);
      end
   end
   else
   begin
      if(VDS_cnt==0)
      begin
        outfile=$fopen(errFileName,"a");
        $strobe("phsj2b_10     VDS     error limit ( %d ) reached at %7.4r  %M", maxEv, $abstime );
        $fwrite(outfile,"phsj2b_10     VDS     error limit ( %d ) reached at %7.4r  %M\n", maxEv, $abstime );
        VDS_cnt=VDS_cnt-1;
        $fclose(outfile);
      end
   end

//      VDB
   VDB = V_D_B;
   if((VDB_cnt>0) || ( maxEv_flg==0 ))   begin
      if( (VDB < -155) && (VDB_retc!=-1))
      begin
        outfile=$fopen(errFileName,"a");
        $strobe("phsj2b_10     VDB     leaving   OCA (  .. -155.000 V ) at %7.4r  %M", $abstime );
        $fwrite(outfile,"phsj2b_10     VDB     leaving   OCA (  .. -155.000 V ) at %7.4r  %M\n", $abstime );
        VDB_retc=-1;
        VDB_cnt=VDB_cnt-1;
        $fclose(outfile);
      end
      if((VDB >= -155) &&  (VDB <= 1.5) && (VDB_retc!=0))
      begin
        outfile=$fopen(errFileName,"a");
        $strobe("phsj2b_10     VDB     entering SOCA ( -155.000 V .. 1.500 V ) at %7.4r  %M", $abstime );
        $fwrite(outfile,"phsj2b_10     VDB     entering SOCA ( -155.000 V .. 1.500 V ) at %7.4r  %M\n", $abstime );
        VDB_retc=0;
        VDB_cnt=VDB_cnt-1;
        $fclose(outfile);
      end
      if((VDB > 1.5) &&  (VDB_retc!=1))
      begin
        outfile=$fopen(errFileName,"a");
        $strobe("phsj2b_10     VDB     leaving   OCA ( 1.500 V ..  ) at %7.4r  %M", $abstime );
        $fwrite(outfile,"phsj2b_10     VDB     leaving   OCA ( 1.500 V ..  ) at %7.4r  %M\n", $abstime );
        VDB_retc=1;
        VDB_cnt=VDB_cnt-1;
        $fclose(outfile);
      end
   end
   else
   begin
      if(VDB_cnt==0)
      begin
        outfile=$fopen(errFileName,"a");
        $strobe("phsj2b_10     VDB     error limit ( %d ) reached at %7.4r  %M", maxEv, $abstime );
        $fwrite(outfile,"phsj2b_10     VDB     error limit ( %d ) reached at %7.4r  %M\n", maxEv, $abstime );
        VDB_cnt=VDB_cnt-1;
        $fclose(outfile);
      end
   end

//      VBHW
   VBHW = V_B_HW;
   if((VBHW_cnt>0) || ( maxEv_flg==0 ))   begin
      if( (VBHW < -0.1) && (VBHW_retc!=-1))
      begin
        outfile=$fopen(errFileName,"a");
        $strobe("phsj2b_10     VBHW    leaving   OCA (  .. -0.100 V ) at %7.4r  %M", $abstime );
        $fwrite(outfile,"phsj2b_10     VBHW    leaving   OCA (  .. -0.100 V ) at %7.4r  %M\n", $abstime );
        VBHW_retc=-1;
        VBHW_cnt=VBHW_cnt-1;
        $fclose(outfile);
      end
      if((VBHW >= -0.1) &&  (VBHW <= 375) && (VBHW_retc!=0))
      begin
        outfile=$fopen(errFileName,"a");
        $strobe("phsj2b_10     VBHW    entering SOCA ( -0.100 V .. 375.000 V ) at %7.4r  %M", $abstime );
        $fwrite(outfile,"phsj2b_10     VBHW    entering SOCA ( -0.100 V .. 375.000 V ) at %7.4r  %M\n", $abstime );
        VBHW_retc=0;
        VBHW_cnt=VBHW_cnt-1;
        $fclose(outfile);
      end
      if((VBHW > 375) &&  (VBHW_retc!=1))
      begin
        outfile=$fopen(errFileName,"a");
        $strobe("phsj2b_10     VBHW    leaving   OCA ( 375.000 V ..  ) at %7.4r  %M", $abstime );
        $fwrite(outfile,"phsj2b_10     VBHW    leaving   OCA ( 375.000 V ..  ) at %7.4r  %M\n", $abstime );
        VBHW_retc=1;
        VBHW_cnt=VBHW_cnt-1;
        $fclose(outfile);
      end
   end
   else
   begin
      if(VBHW_cnt==0)
      begin
        outfile=$fopen(errFileName,"a");
        $strobe("phsj2b_10     VBHW    error limit ( %d ) reached at %7.4r  %M", maxEv, $abstime );
        $fwrite(outfile,"phsj2b_10     VBHW    error limit ( %d ) reached at %7.4r  %M\n", maxEv, $abstime );
        VBHW_cnt=VBHW_cnt-1;
        $fclose(outfile);
      end
   end

end // analog
endmodule // phsj2b_10

// Verilog-A OC Watch for device phsj1a_13 Parameters  VGS VGD VDS VDB VBHW
module phsj1a_13_ahdl(D,G,S,B,HW);
parameter tstep_occ=100n;
parameter errFileName="./occ.err";
parameter maxEv = 25;
parameter maxEv_flg = 0;
inout D,G,S,B,HW;
electrical D,G,S,B,HW;

integer outfile;
real V_B_HW;
real V_D_B;
real V_D_S;
real V_G_D;
real V_G_S;
real VGS;
integer VGS_retc;
integer VGS_cnt;
real VGD;
integer VGD_retc;
integer VGD_cnt;
real VDS;
integer VDS_retc;
integer VDS_cnt;
real VDB;
integer VDB_retc;
integer VDB_cnt;
real VBHW;
integer VBHW_retc;
integer VBHW_cnt;

analog begin
   $bound_step( tstep_occ );
   @(initial_step) begin
      VGS_retc=0;
      VGS_cnt = maxEv;
      VGD_retc=0;
      VGD_cnt = maxEv;
      VDS_retc=0;
      VDS_cnt = maxEv;
      VDB_retc=0;
      VDB_cnt = maxEv;
      VBHW_retc=0;
      VBHW_cnt = maxEv;
   end
   V_B_HW = V(B,HW);
   V_D_B = V(D,B);
   V_D_S = V(D,S);
   V_G_D = V(G,D);
   V_G_S = V(G,S);

//      VGS
   VGS = V_G_S;
   if((VGS_cnt>0) || ( maxEv_flg==0 ))   begin
      if( (VGS < -5.5) && (VGS_retc!=-1))
      begin
        outfile=$fopen(errFileName,"a");
        $strobe("phsj1a_13     VGS     leaving   OCA (  .. -5.500 V ) at %7.4r  %M", $abstime );
        $fwrite(outfile,"phsj1a_13     VGS     leaving   OCA (  .. -5.500 V ) at %7.4r  %M\n", $abstime );
        VGS_retc=-1;
        VGS_cnt=VGS_cnt-1;
        $fclose(outfile);
      end
      if((VGS >= -5.5) &&  (VGS <= 5.5) && (VGS_retc!=0))
      begin
        outfile=$fopen(errFileName,"a");
        $strobe("phsj1a_13     VGS     entering SOCA ( -5.500 V .. 5.500 V ) at %7.4r  %M", $abstime );
        $fwrite(outfile,"phsj1a_13     VGS     entering SOCA ( -5.500 V .. 5.500 V ) at %7.4r  %M\n", $abstime );
        VGS_retc=0;
        VGS_cnt=VGS_cnt-1;
        $fclose(outfile);
      end
      if((VGS > 5.5) &&  (VGS_retc!=1))
      begin
        outfile=$fopen(errFileName,"a");
        $strobe("phsj1a_13     VGS     leaving   OCA ( 5.500 V ..  ) at %7.4r  %M", $abstime );
        $fwrite(outfile,"phsj1a_13     VGS     leaving   OCA ( 5.500 V ..  ) at %7.4r  %M\n", $abstime );
        VGS_retc=1;
        VGS_cnt=VGS_cnt-1;
        $fclose(outfile);
      end
   end
   else
   begin
      if(VGS_cnt==0)
      begin
        outfile=$fopen(errFileName,"a");
        $strobe("phsj1a_13     VGS     error limit ( %d ) reached at %7.4r  %M", maxEv, $abstime );
        $fwrite(outfile,"phsj1a_13     VGS     error limit ( %d ) reached at %7.4r  %M\n", maxEv, $abstime );
        VGS_cnt=VGS_cnt-1;
        $fclose(outfile);
      end
   end

//      VGD
   VGD = V_G_D;
   if((VGD_cnt>0) || ( maxEv_flg==0 ))   begin
      if( (VGD < -5.5) && (VGD_retc!=-1))
      begin
        outfile=$fopen(errFileName,"a");
        $strobe("phsj1a_13     VGD     leaving   OCA (  .. -5.500 V ) at %7.4r  %M", $abstime );
        $fwrite(outfile,"phsj1a_13     VGD     leaving   OCA (  .. -5.500 V ) at %7.4r  %M\n", $abstime );
        VGD_retc=-1;
        VGD_cnt=VGD_cnt-1;
        $fclose(outfile);
      end
      if((VGD >= -5.5) &&  (VGD <= 195) && (VGD_retc!=0))
      begin
        outfile=$fopen(errFileName,"a");
        $strobe("phsj1a_13     VGD     entering SOCA ( -5.500 V .. 195.000 V ) at %7.4r  %M", $abstime );
        $fwrite(outfile,"phsj1a_13     VGD     entering SOCA ( -5.500 V .. 195.000 V ) at %7.4r  %M\n", $abstime );
        VGD_retc=0;
        VGD_cnt=VGD_cnt-1;
        $fclose(outfile);
      end
      if((VGD > 195) &&  (VGD_retc!=1))
      begin
        outfile=$fopen(errFileName,"a");
        $strobe("phsj1a_13     VGD     leaving   OCA ( 195.000 V ..  ) at %7.4r  %M", $abstime );
        $fwrite(outfile,"phsj1a_13     VGD     leaving   OCA ( 195.000 V ..  ) at %7.4r  %M\n", $abstime );
        VGD_retc=1;
        VGD_cnt=VGD_cnt-1;
        $fclose(outfile);
      end
   end
   else
   begin
      if(VGD_cnt==0)
      begin
        outfile=$fopen(errFileName,"a");
        $strobe("phsj1a_13     VGD     error limit ( %d ) reached at %7.4r  %M", maxEv, $abstime );
        $fwrite(outfile,"phsj1a_13     VGD     error limit ( %d ) reached at %7.4r  %M\n", maxEv, $abstime );
        VGD_cnt=VGD_cnt-1;
        $fclose(outfile);
      end
   end

//      VDS
   VDS = V_D_S;
   if((VDS_cnt>0) || ( maxEv_flg==0 ))   begin
      if( (VDS < -195) && (VDS_retc!=-1))
      begin
        outfile=$fopen(errFileName,"a");
        $strobe("phsj1a_13     VDS     leaving   OCA (  .. -195.000 V ) at %7.4r  %M", $abstime );
        $fwrite(outfile,"phsj1a_13     VDS     leaving   OCA (  .. -195.000 V ) at %7.4r  %M\n", $abstime );
        VDS_retc=-1;
        VDS_cnt=VDS_cnt-1;
        $fclose(outfile);
      end
      if((VDS >= -195) &&  (VDS <= 1.5) && (VDS_retc!=0))
      begin
        outfile=$fopen(errFileName,"a");
        $strobe("phsj1a_13     VDS     entering SOCA ( -195.000 V .. 1.500 V ) at %7.4r  %M", $abstime );
        $fwrite(outfile,"phsj1a_13     VDS     entering SOCA ( -195.000 V .. 1.500 V ) at %7.4r  %M\n", $abstime );
        VDS_retc=0;
        VDS_cnt=VDS_cnt-1;
        $fclose(outfile);
      end
      if((VDS > 1.5) &&  (VDS_retc!=1))
      begin
        outfile=$fopen(errFileName,"a");
        $strobe("phsj1a_13     VDS     leaving   OCA ( 1.500 V ..  ) at %7.4r  %M", $abstime );
        $fwrite(outfile,"phsj1a_13     VDS     leaving   OCA ( 1.500 V ..  ) at %7.4r  %M\n", $abstime );
        VDS_retc=1;
        VDS_cnt=VDS_cnt-1;
        $fclose(outfile);
      end
   end
   else
   begin
      if(VDS_cnt==0)
      begin
        outfile=$fopen(errFileName,"a");
        $strobe("phsj1a_13     VDS     error limit ( %d ) reached at %7.4r  %M", maxEv, $abstime );
        $fwrite(outfile,"phsj1a_13     VDS     error limit ( %d ) reached at %7.4r  %M\n", maxEv, $abstime );
        VDS_cnt=VDS_cnt-1;
        $fclose(outfile);
      end
   end

//      VDB
   VDB = V_D_B;
   if((VDB_cnt>0) || ( maxEv_flg==0 ))   begin
      if( (VDB < -195) && (VDB_retc!=-1))
      begin
        outfile=$fopen(errFileName,"a");
        $strobe("phsj1a_13     VDB     leaving   OCA (  .. -195.000 V ) at %7.4r  %M", $abstime );
        $fwrite(outfile,"phsj1a_13     VDB     leaving   OCA (  .. -195.000 V ) at %7.4r  %M\n", $abstime );
        VDB_retc=-1;
        VDB_cnt=VDB_cnt-1;
        $fclose(outfile);
      end
      if((VDB >= -195) &&  (VDB <= 1.5) && (VDB_retc!=0))
      begin
        outfile=$fopen(errFileName,"a");
        $strobe("phsj1a_13     VDB     entering SOCA ( -195.000 V .. 1.500 V ) at %7.4r  %M", $abstime );
        $fwrite(outfile,"phsj1a_13     VDB     entering SOCA ( -195.000 V .. 1.500 V ) at %7.4r  %M\n", $abstime );
        VDB_retc=0;
        VDB_cnt=VDB_cnt-1;
        $fclose(outfile);
      end
      if((VDB > 1.5) &&  (VDB_retc!=1))
      begin
        outfile=$fopen(errFileName,"a");
        $strobe("phsj1a_13     VDB     leaving   OCA ( 1.500 V ..  ) at %7.4r  %M", $abstime );
        $fwrite(outfile,"phsj1a_13     VDB     leaving   OCA ( 1.500 V ..  ) at %7.4r  %M\n", $abstime );
        VDB_retc=1;
        VDB_cnt=VDB_cnt-1;
        $fclose(outfile);
      end
   end
   else
   begin
      if(VDB_cnt==0)
      begin
        outfile=$fopen(errFileName,"a");
        $strobe("phsj1a_13     VDB     error limit ( %d ) reached at %7.4r  %M", maxEv, $abstime );
        $fwrite(outfile,"phsj1a_13     VDB     error limit ( %d ) reached at %7.4r  %M\n", maxEv, $abstime );
        VDB_cnt=VDB_cnt-1;
        $fclose(outfile);
      end
   end

//      VBHW
   VBHW = V_B_HW;
   if((VBHW_cnt>0) || ( maxEv_flg==0 ))   begin
      if( (VBHW < -0.1) && (VBHW_retc!=-1))
      begin
        outfile=$fopen(errFileName,"a");
        $strobe("phsj1a_13     VBHW    leaving   OCA (  .. -0.100 V ) at %7.4r  %M", $abstime );
        $fwrite(outfile,"phsj1a_13     VBHW    leaving   OCA (  .. -0.100 V ) at %7.4r  %M\n", $abstime );
        VBHW_retc=-1;
        VBHW_cnt=VBHW_cnt-1;
        $fclose(outfile);
      end
      if((VBHW >= -0.1) &&  (VBHW <= 375) && (VBHW_retc!=0))
      begin
        outfile=$fopen(errFileName,"a");
        $strobe("phsj1a_13     VBHW    entering SOCA ( -0.100 V .. 375.000 V ) at %7.4r  %M", $abstime );
        $fwrite(outfile,"phsj1a_13     VBHW    entering SOCA ( -0.100 V .. 375.000 V ) at %7.4r  %M\n", $abstime );
        VBHW_retc=0;
        VBHW_cnt=VBHW_cnt-1;
        $fclose(outfile);
      end
      if((VBHW > 375) &&  (VBHW_retc!=1))
      begin
        outfile=$fopen(errFileName,"a");
        $strobe("phsj1a_13     VBHW    leaving   OCA ( 375.000 V ..  ) at %7.4r  %M", $abstime );
        $fwrite(outfile,"phsj1a_13     VBHW    leaving   OCA ( 375.000 V ..  ) at %7.4r  %M\n", $abstime );
        VBHW_retc=1;
        VBHW_cnt=VBHW_cnt-1;
        $fclose(outfile);
      end
   end
   else
   begin
      if(VBHW_cnt==0)
      begin
        outfile=$fopen(errFileName,"a");
        $strobe("phsj1a_13     VBHW    error limit ( %d ) reached at %7.4r  %M", maxEv, $abstime );
        $fwrite(outfile,"phsj1a_13     VBHW    error limit ( %d ) reached at %7.4r  %M\n", maxEv, $abstime );
        VBHW_cnt=VBHW_cnt-1;
        $fclose(outfile);
      end
   end

end // analog
endmodule // phsj1a_13

// Verilog-A OC Watch for device phsj1a_16 Parameters  VGS VGD VDS VDB VBHW
module phsj1a_16_ahdl(D,G,S,B,HW);
parameter tstep_occ=100n;
parameter errFileName="./occ.err";
parameter maxEv = 25;
parameter maxEv_flg = 0;
inout D,G,S,B,HW;
electrical D,G,S,B,HW;

integer outfile;
real V_B_HW;
real V_D_B;
real V_D_S;
real V_G_D;
real V_G_S;
real VGS;
integer VGS_retc;
integer VGS_cnt;
real VGD;
integer VGD_retc;
integer VGD_cnt;
real VDS;
integer VDS_retc;
integer VDS_cnt;
real VDB;
integer VDB_retc;
integer VDB_cnt;
real VBHW;
integer VBHW_retc;
integer VBHW_cnt;

analog begin
   $bound_step( tstep_occ );
   @(initial_step) begin
      VGS_retc=0;
      VGS_cnt = maxEv;
      VGD_retc=0;
      VGD_cnt = maxEv;
      VDS_retc=0;
      VDS_cnt = maxEv;
      VDB_retc=0;
      VDB_cnt = maxEv;
      VBHW_retc=0;
      VBHW_cnt = maxEv;
   end
   V_B_HW = V(B,HW);
   V_D_B = V(D,B);
   V_D_S = V(D,S);
   V_G_D = V(G,D);
   V_G_S = V(G,S);

//      VGS
   VGS = V_G_S;
   if((VGS_cnt>0) || ( maxEv_flg==0 ))   begin
      if( (VGS < -5.5) && (VGS_retc!=-1))
      begin
        outfile=$fopen(errFileName,"a");
        $strobe("phsj1a_16     VGS     leaving   OCA (  .. -5.500 V ) at %7.4r  %M", $abstime );
        $fwrite(outfile,"phsj1a_16     VGS     leaving   OCA (  .. -5.500 V ) at %7.4r  %M\n", $abstime );
        VGS_retc=-1;
        VGS_cnt=VGS_cnt-1;
        $fclose(outfile);
      end
      if((VGS >= -5.5) &&  (VGS <= 5.5) && (VGS_retc!=0))
      begin
        outfile=$fopen(errFileName,"a");
        $strobe("phsj1a_16     VGS     entering SOCA ( -5.500 V .. 5.500 V ) at %7.4r  %M", $abstime );
        $fwrite(outfile,"phsj1a_16     VGS     entering SOCA ( -5.500 V .. 5.500 V ) at %7.4r  %M\n", $abstime );
        VGS_retc=0;
        VGS_cnt=VGS_cnt-1;
        $fclose(outfile);
      end
      if((VGS > 5.5) &&  (VGS_retc!=1))
      begin
        outfile=$fopen(errFileName,"a");
        $strobe("phsj1a_16     VGS     leaving   OCA ( 5.500 V ..  ) at %7.4r  %M", $abstime );
        $fwrite(outfile,"phsj1a_16     VGS     leaving   OCA ( 5.500 V ..  ) at %7.4r  %M\n", $abstime );
        VGS_retc=1;
        VGS_cnt=VGS_cnt-1;
        $fclose(outfile);
      end
   end
   else
   begin
      if(VGS_cnt==0)
      begin
        outfile=$fopen(errFileName,"a");
        $strobe("phsj1a_16     VGS     error limit ( %d ) reached at %7.4r  %M", maxEv, $abstime );
        $fwrite(outfile,"phsj1a_16     VGS     error limit ( %d ) reached at %7.4r  %M\n", maxEv, $abstime );
        VGS_cnt=VGS_cnt-1;
        $fclose(outfile);
      end
   end

//      VGD
   VGD = V_G_D;
   if((VGD_cnt>0) || ( maxEv_flg==0 ))   begin
      if( (VGD < -5.5) && (VGD_retc!=-1))
      begin
        outfile=$fopen(errFileName,"a");
        $strobe("phsj1a_16     VGD     leaving   OCA (  .. -5.500 V ) at %7.4r  %M", $abstime );
        $fwrite(outfile,"phsj1a_16     VGD     leaving   OCA (  .. -5.500 V ) at %7.4r  %M\n", $abstime );
        VGD_retc=-1;
        VGD_cnt=VGD_cnt-1;
        $fclose(outfile);
      end
      if((VGD >= -5.5) &&  (VGD <= 235) && (VGD_retc!=0))
      begin
        outfile=$fopen(errFileName,"a");
        $strobe("phsj1a_16     VGD     entering SOCA ( -5.500 V .. 235.000 V ) at %7.4r  %M", $abstime );
        $fwrite(outfile,"phsj1a_16     VGD     entering SOCA ( -5.500 V .. 235.000 V ) at %7.4r  %M\n", $abstime );
        VGD_retc=0;
        VGD_cnt=VGD_cnt-1;
        $fclose(outfile);
      end
      if((VGD > 235) &&  (VGD_retc!=1))
      begin
        outfile=$fopen(errFileName,"a");
        $strobe("phsj1a_16     VGD     leaving   OCA ( 235.000 V ..  ) at %7.4r  %M", $abstime );
        $fwrite(outfile,"phsj1a_16     VGD     leaving   OCA ( 235.000 V ..  ) at %7.4r  %M\n", $abstime );
        VGD_retc=1;
        VGD_cnt=VGD_cnt-1;
        $fclose(outfile);
      end
   end
   else
   begin
      if(VGD_cnt==0)
      begin
        outfile=$fopen(errFileName,"a");
        $strobe("phsj1a_16     VGD     error limit ( %d ) reached at %7.4r  %M", maxEv, $abstime );
        $fwrite(outfile,"phsj1a_16     VGD     error limit ( %d ) reached at %7.4r  %M\n", maxEv, $abstime );
        VGD_cnt=VGD_cnt-1;
        $fclose(outfile);
      end
   end

//      VDS
   VDS = V_D_S;
   if((VDS_cnt>0) || ( maxEv_flg==0 ))   begin
      if( (VDS < -235) && (VDS_retc!=-1))
      begin
        outfile=$fopen(errFileName,"a");
        $strobe("phsj1a_16     VDS     leaving   OCA (  .. -235.000 V ) at %7.4r  %M", $abstime );
        $fwrite(outfile,"phsj1a_16     VDS     leaving   OCA (  .. -235.000 V ) at %7.4r  %M\n", $abstime );
        VDS_retc=-1;
        VDS_cnt=VDS_cnt-1;
        $fclose(outfile);
      end
      if((VDS >= -235) &&  (VDS <= 1.5) && (VDS_retc!=0))
      begin
        outfile=$fopen(errFileName,"a");
        $strobe("phsj1a_16     VDS     entering SOCA ( -235.000 V .. 1.500 V ) at %7.4r  %M", $abstime );
        $fwrite(outfile,"phsj1a_16     VDS     entering SOCA ( -235.000 V .. 1.500 V ) at %7.4r  %M\n", $abstime );
        VDS_retc=0;
        VDS_cnt=VDS_cnt-1;
        $fclose(outfile);
      end
      if((VDS > 1.5) &&  (VDS_retc!=1))
      begin
        outfile=$fopen(errFileName,"a");
        $strobe("phsj1a_16     VDS     leaving   OCA ( 1.500 V ..  ) at %7.4r  %M", $abstime );
        $fwrite(outfile,"phsj1a_16     VDS     leaving   OCA ( 1.500 V ..  ) at %7.4r  %M\n", $abstime );
        VDS_retc=1;
        VDS_cnt=VDS_cnt-1;
        $fclose(outfile);
      end
   end
   else
   begin
      if(VDS_cnt==0)
      begin
        outfile=$fopen(errFileName,"a");
        $strobe("phsj1a_16     VDS     error limit ( %d ) reached at %7.4r  %M", maxEv, $abstime );
        $fwrite(outfile,"phsj1a_16     VDS     error limit ( %d ) reached at %7.4r  %M\n", maxEv, $abstime );
        VDS_cnt=VDS_cnt-1;
        $fclose(outfile);
      end
   end

//      VDB
   VDB = V_D_B;
   if((VDB_cnt>0) || ( maxEv_flg==0 ))   begin
      if( (VDB < -235) && (VDB_retc!=-1))
      begin
        outfile=$fopen(errFileName,"a");
        $strobe("phsj1a_16     VDB     leaving   OCA (  .. -235.000 V ) at %7.4r  %M", $abstime );
        $fwrite(outfile,"phsj1a_16     VDB     leaving   OCA (  .. -235.000 V ) at %7.4r  %M\n", $abstime );
        VDB_retc=-1;
        VDB_cnt=VDB_cnt-1;
        $fclose(outfile);
      end
      if((VDB >= -235) &&  (VDB <= 1.5) && (VDB_retc!=0))
      begin
        outfile=$fopen(errFileName,"a");
        $strobe("phsj1a_16     VDB     entering SOCA ( -235.000 V .. 1.500 V ) at %7.4r  %M", $abstime );
        $fwrite(outfile,"phsj1a_16     VDB     entering SOCA ( -235.000 V .. 1.500 V ) at %7.4r  %M\n", $abstime );
        VDB_retc=0;
        VDB_cnt=VDB_cnt-1;
        $fclose(outfile);
      end
      if((VDB > 1.5) &&  (VDB_retc!=1))
      begin
        outfile=$fopen(errFileName,"a");
        $strobe("phsj1a_16     VDB     leaving   OCA ( 1.500 V ..  ) at %7.4r  %M", $abstime );
        $fwrite(outfile,"phsj1a_16     VDB     leaving   OCA ( 1.500 V ..  ) at %7.4r  %M\n", $abstime );
        VDB_retc=1;
        VDB_cnt=VDB_cnt-1;
        $fclose(outfile);
      end
   end
   else
   begin
      if(VDB_cnt==0)
      begin
        outfile=$fopen(errFileName,"a");
        $strobe("phsj1a_16     VDB     error limit ( %d ) reached at %7.4r  %M", maxEv, $abstime );
        $fwrite(outfile,"phsj1a_16     VDB     error limit ( %d ) reached at %7.4r  %M\n", maxEv, $abstime );
        VDB_cnt=VDB_cnt-1;
        $fclose(outfile);
      end
   end

//      VBHW
   VBHW = V_B_HW;
   if((VBHW_cnt>0) || ( maxEv_flg==0 ))   begin
      if( (VBHW < -0.1) && (VBHW_retc!=-1))
      begin
        outfile=$fopen(errFileName,"a");
        $strobe("phsj1a_16     VBHW    leaving   OCA (  .. -0.100 V ) at %7.4r  %M", $abstime );
        $fwrite(outfile,"phsj1a_16     VBHW    leaving   OCA (  .. -0.100 V ) at %7.4r  %M\n", $abstime );
        VBHW_retc=-1;
        VBHW_cnt=VBHW_cnt-1;
        $fclose(outfile);
      end
      if((VBHW >= -0.1) &&  (VBHW <= 375) && (VBHW_retc!=0))
      begin
        outfile=$fopen(errFileName,"a");
        $strobe("phsj1a_16     VBHW    entering SOCA ( -0.100 V .. 375.000 V ) at %7.4r  %M", $abstime );
        $fwrite(outfile,"phsj1a_16     VBHW    entering SOCA ( -0.100 V .. 375.000 V ) at %7.4r  %M\n", $abstime );
        VBHW_retc=0;
        VBHW_cnt=VBHW_cnt-1;
        $fclose(outfile);
      end
      if((VBHW > 375) &&  (VBHW_retc!=1))
      begin
        outfile=$fopen(errFileName,"a");
        $strobe("phsj1a_16     VBHW    leaving   OCA ( 375.000 V ..  ) at %7.4r  %M", $abstime );
        $fwrite(outfile,"phsj1a_16     VBHW    leaving   OCA ( 375.000 V ..  ) at %7.4r  %M\n", $abstime );
        VBHW_retc=1;
        VBHW_cnt=VBHW_cnt-1;
        $fclose(outfile);
      end
   end
   else
   begin
      if(VBHW_cnt==0)
      begin
        outfile=$fopen(errFileName,"a");
        $strobe("phsj1a_16     VBHW    error limit ( %d ) reached at %7.4r  %M", maxEv, $abstime );
        $fwrite(outfile,"phsj1a_16     VBHW    error limit ( %d ) reached at %7.4r  %M\n", maxEv, $abstime );
        VBHW_cnt=VBHW_cnt-1;
        $fclose(outfile);
      end
   end

end // analog
endmodule // phsj1a_16

// Verilog-A OC Watch for device phsj2b_16 Parameters  VGS VGD VDS VDB VBHW
module phsj2b_16_ahdl(D,G,S,B,HW);
parameter tstep_occ=100n;
parameter errFileName="./occ.err";
parameter maxEv = 25;
parameter maxEv_flg = 0;
inout D,G,S,B,HW;
electrical D,G,S,B,HW;

integer outfile;
real V_B_HW;
real V_D_B;
real V_D_S;
real V_G_D;
real V_G_S;
real VGS;
integer VGS_retc;
integer VGS_cnt;
real VGD;
integer VGD_retc;
integer VGD_cnt;
real VDS;
integer VDS_retc;
integer VDS_cnt;
real VDB;
integer VDB_retc;
integer VDB_cnt;
real VBHW;
integer VBHW_retc;
integer VBHW_cnt;

analog begin
   $bound_step( tstep_occ );
   @(initial_step) begin
      VGS_retc=0;
      VGS_cnt = maxEv;
      VGD_retc=0;
      VGD_cnt = maxEv;
      VDS_retc=0;
      VDS_cnt = maxEv;
      VDB_retc=0;
      VDB_cnt = maxEv;
      VBHW_retc=0;
      VBHW_cnt = maxEv;
   end
   V_B_HW = V(B,HW);
   V_D_B = V(D,B);
   V_D_S = V(D,S);
   V_G_D = V(G,D);
   V_G_S = V(G,S);

//      VGS
   VGS = V_G_S;
   if((VGS_cnt>0) || ( maxEv_flg==0 ))   begin
      if( (VGS < -5.5) && (VGS_retc!=-1))
      begin
        outfile=$fopen(errFileName,"a");
        $strobe("phsj2b_16     VGS     leaving   OCA (  .. -5.500 V ) at %7.4r  %M", $abstime );
        $fwrite(outfile,"phsj2b_16     VGS     leaving   OCA (  .. -5.500 V ) at %7.4r  %M\n", $abstime );
        VGS_retc=-1;
        VGS_cnt=VGS_cnt-1;
        $fclose(outfile);
      end
      if((VGS >= -5.5) &&  (VGS <= 5.5) && (VGS_retc!=0))
      begin
        outfile=$fopen(errFileName,"a");
        $strobe("phsj2b_16     VGS     entering SOCA ( -5.500 V .. 5.500 V ) at %7.4r  %M", $abstime );
        $fwrite(outfile,"phsj2b_16     VGS     entering SOCA ( -5.500 V .. 5.500 V ) at %7.4r  %M\n", $abstime );
        VGS_retc=0;
        VGS_cnt=VGS_cnt-1;
        $fclose(outfile);
      end
      if((VGS > 5.5) &&  (VGS_retc!=1))
      begin
        outfile=$fopen(errFileName,"a");
        $strobe("phsj2b_16     VGS     leaving   OCA ( 5.500 V ..  ) at %7.4r  %M", $abstime );
        $fwrite(outfile,"phsj2b_16     VGS     leaving   OCA ( 5.500 V ..  ) at %7.4r  %M\n", $abstime );
        VGS_retc=1;
        VGS_cnt=VGS_cnt-1;
        $fclose(outfile);
      end
   end
   else
   begin
      if(VGS_cnt==0)
      begin
        outfile=$fopen(errFileName,"a");
        $strobe("phsj2b_16     VGS     error limit ( %d ) reached at %7.4r  %M", maxEv, $abstime );
        $fwrite(outfile,"phsj2b_16     VGS     error limit ( %d ) reached at %7.4r  %M\n", maxEv, $abstime );
        VGS_cnt=VGS_cnt-1;
        $fclose(outfile);
      end
   end

//      VGD
   VGD = V_G_D;
   if((VGD_cnt>0) || ( maxEv_flg==0 ))   begin
      if( (VGD < -5.5) && (VGD_retc!=-1))
      begin
        outfile=$fopen(errFileName,"a");
        $strobe("phsj2b_16     VGD     leaving   OCA (  .. -5.500 V ) at %7.4r  %M", $abstime );
        $fwrite(outfile,"phsj2b_16     VGD     leaving   OCA (  .. -5.500 V ) at %7.4r  %M\n", $abstime );
        VGD_retc=-1;
        VGD_cnt=VGD_cnt-1;
        $fclose(outfile);
      end
      if((VGD >= -5.5) &&  (VGD <= 235) && (VGD_retc!=0))
      begin
        outfile=$fopen(errFileName,"a");
        $strobe("phsj2b_16     VGD     entering SOCA ( -5.500 V .. 235.000 V ) at %7.4r  %M", $abstime );
        $fwrite(outfile,"phsj2b_16     VGD     entering SOCA ( -5.500 V .. 235.000 V ) at %7.4r  %M\n", $abstime );
        VGD_retc=0;
        VGD_cnt=VGD_cnt-1;
        $fclose(outfile);
      end
      if((VGD > 235) &&  (VGD_retc!=1))
      begin
        outfile=$fopen(errFileName,"a");
        $strobe("phsj2b_16     VGD     leaving   OCA ( 235.000 V ..  ) at %7.4r  %M", $abstime );
        $fwrite(outfile,"phsj2b_16     VGD     leaving   OCA ( 235.000 V ..  ) at %7.4r  %M\n", $abstime );
        VGD_retc=1;
        VGD_cnt=VGD_cnt-1;
        $fclose(outfile);
      end
   end
   else
   begin
      if(VGD_cnt==0)
      begin
        outfile=$fopen(errFileName,"a");
        $strobe("phsj2b_16     VGD     error limit ( %d ) reached at %7.4r  %M", maxEv, $abstime );
        $fwrite(outfile,"phsj2b_16     VGD     error limit ( %d ) reached at %7.4r  %M\n", maxEv, $abstime );
        VGD_cnt=VGD_cnt-1;
        $fclose(outfile);
      end
   end

//      VDS
   VDS = V_D_S;
   if((VDS_cnt>0) || ( maxEv_flg==0 ))   begin
      if( (VDS < -235) && (VDS_retc!=-1))
      begin
        outfile=$fopen(errFileName,"a");
        $strobe("phsj2b_16     VDS     leaving   OCA (  .. -235.000 V ) at %7.4r  %M", $abstime );
        $fwrite(outfile,"phsj2b_16     VDS     leaving   OCA (  .. -235.000 V ) at %7.4r  %M\n", $abstime );
        VDS_retc=-1;
        VDS_cnt=VDS_cnt-1;
        $fclose(outfile);
      end
      if((VDS >= -235) &&  (VDS <= 1.5) && (VDS_retc!=0))
      begin
        outfile=$fopen(errFileName,"a");
        $strobe("phsj2b_16     VDS     entering SOCA ( -235.000 V .. 1.500 V ) at %7.4r  %M", $abstime );
        $fwrite(outfile,"phsj2b_16     VDS     entering SOCA ( -235.000 V .. 1.500 V ) at %7.4r  %M\n", $abstime );
        VDS_retc=0;
        VDS_cnt=VDS_cnt-1;
        $fclose(outfile);
      end
      if((VDS > 1.5) &&  (VDS_retc!=1))
      begin
        outfile=$fopen(errFileName,"a");
        $strobe("phsj2b_16     VDS     leaving   OCA ( 1.500 V ..  ) at %7.4r  %M", $abstime );
        $fwrite(outfile,"phsj2b_16     VDS     leaving   OCA ( 1.500 V ..  ) at %7.4r  %M\n", $abstime );
        VDS_retc=1;
        VDS_cnt=VDS_cnt-1;
        $fclose(outfile);
      end
   end
   else
   begin
      if(VDS_cnt==0)
      begin
        outfile=$fopen(errFileName,"a");
        $strobe("phsj2b_16     VDS     error limit ( %d ) reached at %7.4r  %M", maxEv, $abstime );
        $fwrite(outfile,"phsj2b_16     VDS     error limit ( %d ) reached at %7.4r  %M\n", maxEv, $abstime );
        VDS_cnt=VDS_cnt-1;
        $fclose(outfile);
      end
   end

//      VDB
   VDB = V_D_B;
   if((VDB_cnt>0) || ( maxEv_flg==0 ))   begin
      if( (VDB < -235) && (VDB_retc!=-1))
      begin
        outfile=$fopen(errFileName,"a");
        $strobe("phsj2b_16     VDB     leaving   OCA (  .. -235.000 V ) at %7.4r  %M", $abstime );
        $fwrite(outfile,"phsj2b_16     VDB     leaving   OCA (  .. -235.000 V ) at %7.4r  %M\n", $abstime );
        VDB_retc=-1;
        VDB_cnt=VDB_cnt-1;
        $fclose(outfile);
      end
      if((VDB >= -235) &&  (VDB <= 1.5) && (VDB_retc!=0))
      begin
        outfile=$fopen(errFileName,"a");
        $strobe("phsj2b_16     VDB     entering SOCA ( -235.000 V .. 1.500 V ) at %7.4r  %M", $abstime );
        $fwrite(outfile,"phsj2b_16     VDB     entering SOCA ( -235.000 V .. 1.500 V ) at %7.4r  %M\n", $abstime );
        VDB_retc=0;
        VDB_cnt=VDB_cnt-1;
        $fclose(outfile);
      end
      if((VDB > 1.5) &&  (VDB_retc!=1))
      begin
        outfile=$fopen(errFileName,"a");
        $strobe("phsj2b_16     VDB     leaving   OCA ( 1.500 V ..  ) at %7.4r  %M", $abstime );
        $fwrite(outfile,"phsj2b_16     VDB     leaving   OCA ( 1.500 V ..  ) at %7.4r  %M\n", $abstime );
        VDB_retc=1;
        VDB_cnt=VDB_cnt-1;
        $fclose(outfile);
      end
   end
   else
   begin
      if(VDB_cnt==0)
      begin
        outfile=$fopen(errFileName,"a");
        $strobe("phsj2b_16     VDB     error limit ( %d ) reached at %7.4r  %M", maxEv, $abstime );
        $fwrite(outfile,"phsj2b_16     VDB     error limit ( %d ) reached at %7.4r  %M\n", maxEv, $abstime );
        VDB_cnt=VDB_cnt-1;
        $fclose(outfile);
      end
   end

//      VBHW
   VBHW = V_B_HW;
   if((VBHW_cnt>0) || ( maxEv_flg==0 ))   begin
      if( (VBHW < -0.1) && (VBHW_retc!=-1))
      begin
        outfile=$fopen(errFileName,"a");
        $strobe("phsj2b_16     VBHW    leaving   OCA (  .. -0.100 V ) at %7.4r  %M", $abstime );
        $fwrite(outfile,"phsj2b_16     VBHW    leaving   OCA (  .. -0.100 V ) at %7.4r  %M\n", $abstime );
        VBHW_retc=-1;
        VBHW_cnt=VBHW_cnt-1;
        $fclose(outfile);
      end
      if((VBHW >= -0.1) &&  (VBHW <= 375) && (VBHW_retc!=0))
      begin
        outfile=$fopen(errFileName,"a");
        $strobe("phsj2b_16     VBHW    entering SOCA ( -0.100 V .. 375.000 V ) at %7.4r  %M", $abstime );
        $fwrite(outfile,"phsj2b_16     VBHW    entering SOCA ( -0.100 V .. 375.000 V ) at %7.4r  %M\n", $abstime );
        VBHW_retc=0;
        VBHW_cnt=VBHW_cnt-1;
        $fclose(outfile);
      end
      if((VBHW > 375) &&  (VBHW_retc!=1))
      begin
        outfile=$fopen(errFileName,"a");
        $strobe("phsj2b_16     VBHW    leaving   OCA ( 375.000 V ..  ) at %7.4r  %M", $abstime );
        $fwrite(outfile,"phsj2b_16     VBHW    leaving   OCA ( 375.000 V ..  ) at %7.4r  %M\n", $abstime );
        VBHW_retc=1;
        VBHW_cnt=VBHW_cnt-1;
        $fclose(outfile);
      end
   end
   else
   begin
      if(VBHW_cnt==0)
      begin
        outfile=$fopen(errFileName,"a");
        $strobe("phsj2b_16     VBHW    error limit ( %d ) reached at %7.4r  %M", maxEv, $abstime );
        $fwrite(outfile,"phsj2b_16     VBHW    error limit ( %d ) reached at %7.4r  %M\n", maxEv, $abstime );
        VBHW_cnt=VBHW_cnt-1;
        $fclose(outfile);
      end
   end

end // analog
endmodule // phsj2b_16

// Verilog-A OC Watch for device phsj1a_20 Parameters  VGS VGD VDS VDB VBHW
module phsj1a_20_ahdl(D,G,S,B,HW);
parameter tstep_occ=100n;
parameter errFileName="./occ.err";
parameter maxEv = 25;
parameter maxEv_flg = 0;
inout D,G,S,B,HW;
electrical D,G,S,B,HW;

integer outfile;
real V_B_HW;
real V_D_B;
real V_D_S;
real V_G_D;
real V_G_S;
real VGS;
integer VGS_retc;
integer VGS_cnt;
real VGD;
integer VGD_retc;
integer VGD_cnt;
real VDS;
integer VDS_retc;
integer VDS_cnt;
real VDB;
integer VDB_retc;
integer VDB_cnt;
real VBHW;
integer VBHW_retc;
integer VBHW_cnt;

analog begin
   $bound_step( tstep_occ );
   @(initial_step) begin
      VGS_retc=0;
      VGS_cnt = maxEv;
      VGD_retc=0;
      VGD_cnt = maxEv;
      VDS_retc=0;
      VDS_cnt = maxEv;
      VDB_retc=0;
      VDB_cnt = maxEv;
      VBHW_retc=0;
      VBHW_cnt = maxEv;
   end
   V_B_HW = V(B,HW);
   V_D_B = V(D,B);
   V_D_S = V(D,S);
   V_G_D = V(G,D);
   V_G_S = V(G,S);

//      VGS
   VGS = V_G_S;
   if((VGS_cnt>0) || ( maxEv_flg==0 ))   begin
      if( (VGS < -5.5) && (VGS_retc!=-1))
      begin
        outfile=$fopen(errFileName,"a");
        $strobe("phsj1a_20     VGS     leaving   OCA (  .. -5.500 V ) at %7.4r  %M", $abstime );
        $fwrite(outfile,"phsj1a_20     VGS     leaving   OCA (  .. -5.500 V ) at %7.4r  %M\n", $abstime );
        VGS_retc=-1;
        VGS_cnt=VGS_cnt-1;
        $fclose(outfile);
      end
      if((VGS >= -5.5) &&  (VGS <= 5.5) && (VGS_retc!=0))
      begin
        outfile=$fopen(errFileName,"a");
        $strobe("phsj1a_20     VGS     entering SOCA ( -5.500 V .. 5.500 V ) at %7.4r  %M", $abstime );
        $fwrite(outfile,"phsj1a_20     VGS     entering SOCA ( -5.500 V .. 5.500 V ) at %7.4r  %M\n", $abstime );
        VGS_retc=0;
        VGS_cnt=VGS_cnt-1;
        $fclose(outfile);
      end
      if((VGS > 5.5) &&  (VGS_retc!=1))
      begin
        outfile=$fopen(errFileName,"a");
        $strobe("phsj1a_20     VGS     leaving   OCA ( 5.500 V ..  ) at %7.4r  %M", $abstime );
        $fwrite(outfile,"phsj1a_20     VGS     leaving   OCA ( 5.500 V ..  ) at %7.4r  %M\n", $abstime );
        VGS_retc=1;
        VGS_cnt=VGS_cnt-1;
        $fclose(outfile);
      end
   end
   else
   begin
      if(VGS_cnt==0)
      begin
        outfile=$fopen(errFileName,"a");
        $strobe("phsj1a_20     VGS     error limit ( %d ) reached at %7.4r  %M", maxEv, $abstime );
        $fwrite(outfile,"phsj1a_20     VGS     error limit ( %d ) reached at %7.4r  %M\n", maxEv, $abstime );
        VGS_cnt=VGS_cnt-1;
        $fclose(outfile);
      end
   end

//      VGD
   VGD = V_G_D;
   if((VGD_cnt>0) || ( maxEv_flg==0 ))   begin
      if( (VGD < -5.5) && (VGD_retc!=-1))
      begin
        outfile=$fopen(errFileName,"a");
        $strobe("phsj1a_20     VGD     leaving   OCA (  .. -5.500 V ) at %7.4r  %M", $abstime );
        $fwrite(outfile,"phsj1a_20     VGD     leaving   OCA (  .. -5.500 V ) at %7.4r  %M\n", $abstime );
        VGD_retc=-1;
        VGD_cnt=VGD_cnt-1;
        $fclose(outfile);
      end
      if((VGD >= -5.5) &&  (VGD <= 290) && (VGD_retc!=0))
      begin
        outfile=$fopen(errFileName,"a");
        $strobe("phsj1a_20     VGD     entering SOCA ( -5.500 V .. 290.000 V ) at %7.4r  %M", $abstime );
        $fwrite(outfile,"phsj1a_20     VGD     entering SOCA ( -5.500 V .. 290.000 V ) at %7.4r  %M\n", $abstime );
        VGD_retc=0;
        VGD_cnt=VGD_cnt-1;
        $fclose(outfile);
      end
      if((VGD > 290) &&  (VGD_retc!=1))
      begin
        outfile=$fopen(errFileName,"a");
        $strobe("phsj1a_20     VGD     leaving   OCA ( 290.000 V ..  ) at %7.4r  %M", $abstime );
        $fwrite(outfile,"phsj1a_20     VGD     leaving   OCA ( 290.000 V ..  ) at %7.4r  %M\n", $abstime );
        VGD_retc=1;
        VGD_cnt=VGD_cnt-1;
        $fclose(outfile);
      end
   end
   else
   begin
      if(VGD_cnt==0)
      begin
        outfile=$fopen(errFileName,"a");
        $strobe("phsj1a_20     VGD     error limit ( %d ) reached at %7.4r  %M", maxEv, $abstime );
        $fwrite(outfile,"phsj1a_20     VGD     error limit ( %d ) reached at %7.4r  %M\n", maxEv, $abstime );
        VGD_cnt=VGD_cnt-1;
        $fclose(outfile);
      end
   end

//      VDS
   VDS = V_D_S;
   if((VDS_cnt>0) || ( maxEv_flg==0 ))   begin
      if( (VDS < -290) && (VDS_retc!=-1))
      begin
        outfile=$fopen(errFileName,"a");
        $strobe("phsj1a_20     VDS     leaving   OCA (  .. -290.000 V ) at %7.4r  %M", $abstime );
        $fwrite(outfile,"phsj1a_20     VDS     leaving   OCA (  .. -290.000 V ) at %7.4r  %M\n", $abstime );
        VDS_retc=-1;
        VDS_cnt=VDS_cnt-1;
        $fclose(outfile);
      end
      if((VDS >= -290) &&  (VDS <= 1.5) && (VDS_retc!=0))
      begin
        outfile=$fopen(errFileName,"a");
        $strobe("phsj1a_20     VDS     entering SOCA ( -290.000 V .. 1.500 V ) at %7.4r  %M", $abstime );
        $fwrite(outfile,"phsj1a_20     VDS     entering SOCA ( -290.000 V .. 1.500 V ) at %7.4r  %M\n", $abstime );
        VDS_retc=0;
        VDS_cnt=VDS_cnt-1;
        $fclose(outfile);
      end
      if((VDS > 1.5) &&  (VDS_retc!=1))
      begin
        outfile=$fopen(errFileName,"a");
        $strobe("phsj1a_20     VDS     leaving   OCA ( 1.500 V ..  ) at %7.4r  %M", $abstime );
        $fwrite(outfile,"phsj1a_20     VDS     leaving   OCA ( 1.500 V ..  ) at %7.4r  %M\n", $abstime );
        VDS_retc=1;
        VDS_cnt=VDS_cnt-1;
        $fclose(outfile);
      end
   end
   else
   begin
      if(VDS_cnt==0)
      begin
        outfile=$fopen(errFileName,"a");
        $strobe("phsj1a_20     VDS     error limit ( %d ) reached at %7.4r  %M", maxEv, $abstime );
        $fwrite(outfile,"phsj1a_20     VDS     error limit ( %d ) reached at %7.4r  %M\n", maxEv, $abstime );
        VDS_cnt=VDS_cnt-1;
        $fclose(outfile);
      end
   end

//      VDB
   VDB = V_D_B;
   if((VDB_cnt>0) || ( maxEv_flg==0 ))   begin
      if( (VDB < -290) && (VDB_retc!=-1))
      begin
        outfile=$fopen(errFileName,"a");
        $strobe("phsj1a_20     VDB     leaving   OCA (  .. -290.000 V ) at %7.4r  %M", $abstime );
        $fwrite(outfile,"phsj1a_20     VDB     leaving   OCA (  .. -290.000 V ) at %7.4r  %M\n", $abstime );
        VDB_retc=-1;
        VDB_cnt=VDB_cnt-1;
        $fclose(outfile);
      end
      if((VDB >= -290) &&  (VDB <= 1.5) && (VDB_retc!=0))
      begin
        outfile=$fopen(errFileName,"a");
        $strobe("phsj1a_20     VDB     entering SOCA ( -290.000 V .. 1.500 V ) at %7.4r  %M", $abstime );
        $fwrite(outfile,"phsj1a_20     VDB     entering SOCA ( -290.000 V .. 1.500 V ) at %7.4r  %M\n", $abstime );
        VDB_retc=0;
        VDB_cnt=VDB_cnt-1;
        $fclose(outfile);
      end
      if((VDB > 1.5) &&  (VDB_retc!=1))
      begin
        outfile=$fopen(errFileName,"a");
        $strobe("phsj1a_20     VDB     leaving   OCA ( 1.500 V ..  ) at %7.4r  %M", $abstime );
        $fwrite(outfile,"phsj1a_20     VDB     leaving   OCA ( 1.500 V ..  ) at %7.4r  %M\n", $abstime );
        VDB_retc=1;
        VDB_cnt=VDB_cnt-1;
        $fclose(outfile);
      end
   end
   else
   begin
      if(VDB_cnt==0)
      begin
        outfile=$fopen(errFileName,"a");
        $strobe("phsj1a_20     VDB     error limit ( %d ) reached at %7.4r  %M", maxEv, $abstime );
        $fwrite(outfile,"phsj1a_20     VDB     error limit ( %d ) reached at %7.4r  %M\n", maxEv, $abstime );
        VDB_cnt=VDB_cnt-1;
        $fclose(outfile);
      end
   end

//      VBHW
   VBHW = V_B_HW;
   if((VBHW_cnt>0) || ( maxEv_flg==0 ))   begin
      if( (VBHW < -0.1) && (VBHW_retc!=-1))
      begin
        outfile=$fopen(errFileName,"a");
        $strobe("phsj1a_20     VBHW    leaving   OCA (  .. -0.100 V ) at %7.4r  %M", $abstime );
        $fwrite(outfile,"phsj1a_20     VBHW    leaving   OCA (  .. -0.100 V ) at %7.4r  %M\n", $abstime );
        VBHW_retc=-1;
        VBHW_cnt=VBHW_cnt-1;
        $fclose(outfile);
      end
      if((VBHW >= -0.1) &&  (VBHW <= 400) && (VBHW_retc!=0))
      begin
        outfile=$fopen(errFileName,"a");
        $strobe("phsj1a_20     VBHW    entering SOCA ( -0.100 V .. 400.000 V ) at %7.4r  %M", $abstime );
        $fwrite(outfile,"phsj1a_20     VBHW    entering SOCA ( -0.100 V .. 400.000 V ) at %7.4r  %M\n", $abstime );
        VBHW_retc=0;
        VBHW_cnt=VBHW_cnt-1;
        $fclose(outfile);
      end
      if((VBHW > 400) &&  (VBHW_retc!=1))
      begin
        outfile=$fopen(errFileName,"a");
        $strobe("phsj1a_20     VBHW    leaving   OCA ( 400.000 V ..  ) at %7.4r  %M", $abstime );
        $fwrite(outfile,"phsj1a_20     VBHW    leaving   OCA ( 400.000 V ..  ) at %7.4r  %M\n", $abstime );
        VBHW_retc=1;
        VBHW_cnt=VBHW_cnt-1;
        $fclose(outfile);
      end
   end
   else
   begin
      if(VBHW_cnt==0)
      begin
        outfile=$fopen(errFileName,"a");
        $strobe("phsj1a_20     VBHW    error limit ( %d ) reached at %7.4r  %M", maxEv, $abstime );
        $fwrite(outfile,"phsj1a_20     VBHW    error limit ( %d ) reached at %7.4r  %M\n", maxEv, $abstime );
        VBHW_cnt=VBHW_cnt-1;
        $fclose(outfile);
      end
   end

end // analog
endmodule // phsj1a_20

// Verilog-A OC Watch for device phsj1a_31 Parameters  VGS VGD VDS VDB VBHW
module phsj1a_31_ahdl(D,G,S,B,HW);
parameter tstep_occ=100n;
parameter errFileName="./occ.err";
parameter maxEv = 25;
parameter maxEv_flg = 0;
inout D,G,S,B,HW;
electrical D,G,S,B,HW;

integer outfile;
real V_B_HW;
real V_D_B;
real V_D_S;
real V_G_D;
real V_G_S;
real VGS;
integer VGS_retc;
integer VGS_cnt;
real VGD;
integer VGD_retc;
integer VGD_cnt;
real VDS;
integer VDS_retc;
integer VDS_cnt;
real VDB;
integer VDB_retc;
integer VDB_cnt;
real VBHW;
integer VBHW_retc;
integer VBHW_cnt;

analog begin
   $bound_step( tstep_occ );
   @(initial_step) begin
      VGS_retc=0;
      VGS_cnt = maxEv;
      VGD_retc=0;
      VGD_cnt = maxEv;
      VDS_retc=0;
      VDS_cnt = maxEv;
      VDB_retc=0;
      VDB_cnt = maxEv;
      VBHW_retc=0;
      VBHW_cnt = maxEv;
   end
   V_B_HW = V(B,HW);
   V_D_B = V(D,B);
   V_D_S = V(D,S);
   V_G_D = V(G,D);
   V_G_S = V(G,S);

//      VGS
   VGS = V_G_S;
   if((VGS_cnt>0) || ( maxEv_flg==0 ))   begin
      if( (VGS < -5.5) && (VGS_retc!=-1))
      begin
        outfile=$fopen(errFileName,"a");
        $strobe("phsj1a_31     VGS     leaving   OCA (  .. -5.500 V ) at %7.4r  %M", $abstime );
        $fwrite(outfile,"phsj1a_31     VGS     leaving   OCA (  .. -5.500 V ) at %7.4r  %M\n", $abstime );
        VGS_retc=-1;
        VGS_cnt=VGS_cnt-1;
        $fclose(outfile);
      end
      if((VGS >= -5.5) &&  (VGS <= 5.5) && (VGS_retc!=0))
      begin
        outfile=$fopen(errFileName,"a");
        $strobe("phsj1a_31     VGS     entering SOCA ( -5.500 V .. 5.500 V ) at %7.4r  %M", $abstime );
        $fwrite(outfile,"phsj1a_31     VGS     entering SOCA ( -5.500 V .. 5.500 V ) at %7.4r  %M\n", $abstime );
        VGS_retc=0;
        VGS_cnt=VGS_cnt-1;
        $fclose(outfile);
      end
      if((VGS > 5.5) &&  (VGS_retc!=1))
      begin
        outfile=$fopen(errFileName,"a");
        $strobe("phsj1a_31     VGS     leaving   OCA ( 5.500 V ..  ) at %7.4r  %M", $abstime );
        $fwrite(outfile,"phsj1a_31     VGS     leaving   OCA ( 5.500 V ..  ) at %7.4r  %M\n", $abstime );
        VGS_retc=1;
        VGS_cnt=VGS_cnt-1;
        $fclose(outfile);
      end
   end
   else
   begin
      if(VGS_cnt==0)
      begin
        outfile=$fopen(errFileName,"a");
        $strobe("phsj1a_31     VGS     error limit ( %d ) reached at %7.4r  %M", maxEv, $abstime );
        $fwrite(outfile,"phsj1a_31     VGS     error limit ( %d ) reached at %7.4r  %M\n", maxEv, $abstime );
        VGS_cnt=VGS_cnt-1;
        $fclose(outfile);
      end
   end

//      VGD
   VGD = V_G_D;
   if((VGD_cnt>0) || ( maxEv_flg==0 ))   begin
      if( (VGD < -5.5) && (VGD_retc!=-1))
      begin
        outfile=$fopen(errFileName,"a");
        $strobe("phsj1a_31     VGD     leaving   OCA (  .. -5.500 V ) at %7.4r  %M", $abstime );
        $fwrite(outfile,"phsj1a_31     VGD     leaving   OCA (  .. -5.500 V ) at %7.4r  %M\n", $abstime );
        VGD_retc=-1;
        VGD_cnt=VGD_cnt-1;
        $fclose(outfile);
      end
      if((VGD >= -5.5) &&  (VGD <= 375) && (VGD_retc!=0))
      begin
        outfile=$fopen(errFileName,"a");
        $strobe("phsj1a_31     VGD     entering SOCA ( -5.500 V .. 375.000 V ) at %7.4r  %M", $abstime );
        $fwrite(outfile,"phsj1a_31     VGD     entering SOCA ( -5.500 V .. 375.000 V ) at %7.4r  %M\n", $abstime );
        VGD_retc=0;
        VGD_cnt=VGD_cnt-1;
        $fclose(outfile);
      end
      if((VGD > 375) &&  (VGD_retc!=1))
      begin
        outfile=$fopen(errFileName,"a");
        $strobe("phsj1a_31     VGD     leaving   OCA ( 375.000 V ..  ) at %7.4r  %M", $abstime );
        $fwrite(outfile,"phsj1a_31     VGD     leaving   OCA ( 375.000 V ..  ) at %7.4r  %M\n", $abstime );
        VGD_retc=1;
        VGD_cnt=VGD_cnt-1;
        $fclose(outfile);
      end
   end
   else
   begin
      if(VGD_cnt==0)
      begin
        outfile=$fopen(errFileName,"a");
        $strobe("phsj1a_31     VGD     error limit ( %d ) reached at %7.4r  %M", maxEv, $abstime );
        $fwrite(outfile,"phsj1a_31     VGD     error limit ( %d ) reached at %7.4r  %M\n", maxEv, $abstime );
        VGD_cnt=VGD_cnt-1;
        $fclose(outfile);
      end
   end

//      VDS
   VDS = V_D_S;
   if((VDS_cnt>0) || ( maxEv_flg==0 ))   begin
      if( (VDS < -375) && (VDS_retc!=-1))
      begin
        outfile=$fopen(errFileName,"a");
        $strobe("phsj1a_31     VDS     leaving   OCA (  .. -375.000 V ) at %7.4r  %M", $abstime );
        $fwrite(outfile,"phsj1a_31     VDS     leaving   OCA (  .. -375.000 V ) at %7.4r  %M\n", $abstime );
        VDS_retc=-1;
        VDS_cnt=VDS_cnt-1;
        $fclose(outfile);
      end
      if((VDS >= -375) &&  (VDS <= 1.5) && (VDS_retc!=0))
      begin
        outfile=$fopen(errFileName,"a");
        $strobe("phsj1a_31     VDS     entering SOCA ( -375.000 V .. 1.500 V ) at %7.4r  %M", $abstime );
        $fwrite(outfile,"phsj1a_31     VDS     entering SOCA ( -375.000 V .. 1.500 V ) at %7.4r  %M\n", $abstime );
        VDS_retc=0;
        VDS_cnt=VDS_cnt-1;
        $fclose(outfile);
      end
      if((VDS > 1.5) &&  (VDS_retc!=1))
      begin
        outfile=$fopen(errFileName,"a");
        $strobe("phsj1a_31     VDS     leaving   OCA ( 1.500 V ..  ) at %7.4r  %M", $abstime );
        $fwrite(outfile,"phsj1a_31     VDS     leaving   OCA ( 1.500 V ..  ) at %7.4r  %M\n", $abstime );
        VDS_retc=1;
        VDS_cnt=VDS_cnt-1;
        $fclose(outfile);
      end
   end
   else
   begin
      if(VDS_cnt==0)
      begin
        outfile=$fopen(errFileName,"a");
        $strobe("phsj1a_31     VDS     error limit ( %d ) reached at %7.4r  %M", maxEv, $abstime );
        $fwrite(outfile,"phsj1a_31     VDS     error limit ( %d ) reached at %7.4r  %M\n", maxEv, $abstime );
        VDS_cnt=VDS_cnt-1;
        $fclose(outfile);
      end
   end

//      VDB
   VDB = V_D_B;
   if((VDB_cnt>0) || ( maxEv_flg==0 ))   begin
      if( (VDB < -375) && (VDB_retc!=-1))
      begin
        outfile=$fopen(errFileName,"a");
        $strobe("phsj1a_31     VDB     leaving   OCA (  .. -375.000 V ) at %7.4r  %M", $abstime );
        $fwrite(outfile,"phsj1a_31     VDB     leaving   OCA (  .. -375.000 V ) at %7.4r  %M\n", $abstime );
        VDB_retc=-1;
        VDB_cnt=VDB_cnt-1;
        $fclose(outfile);
      end
      if((VDB >= -375) &&  (VDB <= 1.5) && (VDB_retc!=0))
      begin
        outfile=$fopen(errFileName,"a");
        $strobe("phsj1a_31     VDB     entering SOCA ( -375.000 V .. 1.500 V ) at %7.4r  %M", $abstime );
        $fwrite(outfile,"phsj1a_31     VDB     entering SOCA ( -375.000 V .. 1.500 V ) at %7.4r  %M\n", $abstime );
        VDB_retc=0;
        VDB_cnt=VDB_cnt-1;
        $fclose(outfile);
      end
      if((VDB > 1.5) &&  (VDB_retc!=1))
      begin
        outfile=$fopen(errFileName,"a");
        $strobe("phsj1a_31     VDB     leaving   OCA ( 1.500 V ..  ) at %7.4r  %M", $abstime );
        $fwrite(outfile,"phsj1a_31     VDB     leaving   OCA ( 1.500 V ..  ) at %7.4r  %M\n", $abstime );
        VDB_retc=1;
        VDB_cnt=VDB_cnt-1;
        $fclose(outfile);
      end
   end
   else
   begin
      if(VDB_cnt==0)
      begin
        outfile=$fopen(errFileName,"a");
        $strobe("phsj1a_31     VDB     error limit ( %d ) reached at %7.4r  %M", maxEv, $abstime );
        $fwrite(outfile,"phsj1a_31     VDB     error limit ( %d ) reached at %7.4r  %M\n", maxEv, $abstime );
        VDB_cnt=VDB_cnt-1;
        $fclose(outfile);
      end
   end

//      VBHW
   VBHW = V_B_HW;
   if((VBHW_cnt>0) || ( maxEv_flg==0 ))   begin
      if( (VBHW < -0.1) && (VBHW_retc!=-1))
      begin
        outfile=$fopen(errFileName,"a");
        $strobe("phsj1a_31     VBHW    leaving   OCA (  .. -0.100 V ) at %7.4r  %M", $abstime );
        $fwrite(outfile,"phsj1a_31     VBHW    leaving   OCA (  .. -0.100 V ) at %7.4r  %M\n", $abstime );
        VBHW_retc=-1;
        VBHW_cnt=VBHW_cnt-1;
        $fclose(outfile);
      end
      if((VBHW >= -0.1) &&  (VBHW <= 400) && (VBHW_retc!=0))
      begin
        outfile=$fopen(errFileName,"a");
        $strobe("phsj1a_31     VBHW    entering SOCA ( -0.100 V .. 400.000 V ) at %7.4r  %M", $abstime );
        $fwrite(outfile,"phsj1a_31     VBHW    entering SOCA ( -0.100 V .. 400.000 V ) at %7.4r  %M\n", $abstime );
        VBHW_retc=0;
        VBHW_cnt=VBHW_cnt-1;
        $fclose(outfile);
      end
      if((VBHW > 400) &&  (VBHW_retc!=1))
      begin
        outfile=$fopen(errFileName,"a");
        $strobe("phsj1a_31     VBHW    leaving   OCA ( 400.000 V ..  ) at %7.4r  %M", $abstime );
        $fwrite(outfile,"phsj1a_31     VBHW    leaving   OCA ( 400.000 V ..  ) at %7.4r  %M\n", $abstime );
        VBHW_retc=1;
        VBHW_cnt=VBHW_cnt-1;
        $fclose(outfile);
      end
   end
   else
   begin
      if(VBHW_cnt==0)
      begin
        outfile=$fopen(errFileName,"a");
        $strobe("phsj1a_31     VBHW    error limit ( %d ) reached at %7.4r  %M", maxEv, $abstime );
        $fwrite(outfile,"phsj1a_31     VBHW    error limit ( %d ) reached at %7.4r  %M\n", maxEv, $abstime );
        VBHW_cnt=VBHW_cnt-1;
        $fclose(outfile);
      end
   end

end // analog
endmodule // phsj1a_31

// Verilog-A OC Watch for device dfwnsj1b_2 Parameters  VAC IA
module dfwnsj1b_2_ahdl(A1,C1,A,C);
parameter tstep_occ=100n;
parameter errFileName="./occ.err";
parameter area = 1u;
parameter maxEv = 25;
parameter maxEv_flg = 0;
inout A1,C1,A,C;
electrical A1,C1,A,C;

integer outfile;
real V_A_C;
real I_C;
real I_A;
real VAC;
integer VAC_retc;
integer VAC_cnt;
real IA;
integer IA_retc;
integer IA_cnt;

analog begin
   $bound_step( tstep_occ );
   @(initial_step) begin
      VAC_retc=0;
      VAC_cnt = maxEv;
      IA_retc=0;
      IA_cnt = maxEv;
   end
   V_A_C = V(A,C);
   I_C = I(C1,C);
   I_A = I(A1,A);

//      VAC
   VAC = V_A_C;
   if((VAC_cnt>0) || ( maxEv_flg==0 ))   begin
      if( (VAC < -45) && (VAC_retc!=-1))
      begin
        outfile=$fopen(errFileName,"a");
        $strobe("dfwnsj1b_2    VAC     leaving   OCA (  .. -45.000 V ) at %7.4r  %M", $abstime );
        $fwrite(outfile,"dfwnsj1b_2    VAC     leaving   OCA (  .. -45.000 V ) at %7.4r  %M\n", $abstime );
        VAC_retc=-1;
        VAC_cnt=VAC_cnt-1;
        $fclose(outfile);
      end
      if((VAC >= -45) &&  (VAC <= 1.5) && (VAC_retc!=0))
      begin
        outfile=$fopen(errFileName,"a");
        $strobe("dfwnsj1b_2    VAC     entering SOCA ( -45.000 V .. 1.500 V ) at %7.4r  %M", $abstime );
        $fwrite(outfile,"dfwnsj1b_2    VAC     entering SOCA ( -45.000 V .. 1.500 V ) at %7.4r  %M\n", $abstime );
        VAC_retc=0;
        VAC_cnt=VAC_cnt-1;
        $fclose(outfile);
      end
      if((VAC > 1.5) &&  (VAC_retc!=1))
      begin
        outfile=$fopen(errFileName,"a");
        $strobe("dfwnsj1b_2    VAC     leaving   OCA ( 1.500 V ..  ) at %7.4r  %M", $abstime );
        $fwrite(outfile,"dfwnsj1b_2    VAC     leaving   OCA ( 1.500 V ..  ) at %7.4r  %M\n", $abstime );
        VAC_retc=1;
        VAC_cnt=VAC_cnt-1;
        $fclose(outfile);
      end
   end
   else
   begin
      if(VAC_cnt==0)
      begin
        outfile=$fopen(errFileName,"a");
        $strobe("dfwnsj1b_2    VAC     error limit ( %d ) reached at %7.4r  %M", maxEv, $abstime );
        $fwrite(outfile,"dfwnsj1b_2    VAC     error limit ( %d ) reached at %7.4r  %M\n", maxEv, $abstime );
        VAC_cnt=VAC_cnt-1;
        $fclose(outfile);
      end
   end

//      IA
   IA = I_A / area / 2.5e-06;
   if((IA_cnt>0) || ( maxEv_flg==0 ))   begin
      if( (IA < -60) && (IA_retc!=-1))
      begin
        outfile=$fopen(errFileName,"a");
        $strobe("dfwnsj1b_2    IA      leaving   OCA (  .. -0.060 mA/um ) at %7.4r  %M", $abstime );
        $fwrite(outfile,"dfwnsj1b_2    IA      leaving   OCA (  .. -0.060 mA/um ) at %7.4r  %M\n", $abstime );
        IA_retc=-1;
        IA_cnt=IA_cnt-1;
        $fclose(outfile);
      end
      if((IA >= -60) &&  (IA <= 60) && (IA_retc!=0))
      begin
        outfile=$fopen(errFileName,"a");
        $strobe("dfwnsj1b_2    IA      entering SOCA ( -0.060 mA/um .. 0.060 mA/um ) at %7.4r  %M", $abstime );
        $fwrite(outfile,"dfwnsj1b_2    IA      entering SOCA ( -0.060 mA/um .. 0.060 mA/um ) at %7.4r  %M\n", $abstime );
        IA_retc=0;
        IA_cnt=IA_cnt-1;
        $fclose(outfile);
      end
      if((IA > 60) &&  (IA_retc!=1))
      begin
        outfile=$fopen(errFileName,"a");
        $strobe("dfwnsj1b_2    IA      leaving   OCA ( 0.060 mA/um ..  ) at %7.4r  %M", $abstime );
        $fwrite(outfile,"dfwnsj1b_2    IA      leaving   OCA ( 0.060 mA/um ..  ) at %7.4r  %M\n", $abstime );
        IA_retc=1;
        IA_cnt=IA_cnt-1;
        $fclose(outfile);
      end
   end
   else
   begin
      if(IA_cnt==0)
      begin
        outfile=$fopen(errFileName,"a");
        $strobe("dfwnsj1b_2    IA      error limit ( %d ) reached at %7.4r  %M", maxEv, $abstime );
        $fwrite(outfile,"dfwnsj1b_2    IA      error limit ( %d ) reached at %7.4r  %M\n", maxEv, $abstime );
        IA_cnt=IA_cnt-1;
        $fclose(outfile);
      end
   end

end // analog
endmodule // dfwnsj1b_2

// Verilog-A OC Watch for device dfwnsj1b_4 Parameters  VAC
module dfwnsj1b_4_ahdl(A,C);
parameter tstep_occ=100n;
parameter errFileName="./occ.err";
parameter maxEv = 25;
parameter maxEv_flg = 0;
inout A,C;
electrical A,C;

integer outfile;
real V_A_C;
real VAC;
integer VAC_retc;
integer VAC_cnt;

analog begin
   $bound_step( tstep_occ );
   @(initial_step) begin
      VAC_retc=0;
      VAC_cnt = maxEv;
   end
   V_A_C = V(A,C);

//      VAC
   VAC = V_A_C;
   if((VAC_cnt>0) || ( maxEv_flg==0 ))   begin
      if( (VAC < -72) && (VAC_retc!=-1))
      begin
        outfile=$fopen(errFileName,"a");
        $strobe("dfwnsj1b_4    VAC     leaving   OCA (  .. -72.000 V ) at %7.4r  %M", $abstime );
        $fwrite(outfile,"dfwnsj1b_4    VAC     leaving   OCA (  .. -72.000 V ) at %7.4r  %M\n", $abstime );
        VAC_retc=-1;
        VAC_cnt=VAC_cnt-1;
        $fclose(outfile);
      end
      if((VAC >= -72) &&  (VAC <= 1.5) && (VAC_retc!=0))
      begin
        outfile=$fopen(errFileName,"a");
        $strobe("dfwnsj1b_4    VAC     entering SOCA ( -72.000 V .. 1.500 V ) at %7.4r  %M", $abstime );
        $fwrite(outfile,"dfwnsj1b_4    VAC     entering SOCA ( -72.000 V .. 1.500 V ) at %7.4r  %M\n", $abstime );
        VAC_retc=0;
        VAC_cnt=VAC_cnt-1;
        $fclose(outfile);
      end
      if((VAC > 1.5) &&  (VAC_retc!=1))
      begin
        outfile=$fopen(errFileName,"a");
        $strobe("dfwnsj1b_4    VAC     leaving   OCA ( 1.500 V ..  ) at %7.4r  %M", $abstime );
        $fwrite(outfile,"dfwnsj1b_4    VAC     leaving   OCA ( 1.500 V ..  ) at %7.4r  %M\n", $abstime );
        VAC_retc=1;
        VAC_cnt=VAC_cnt-1;
        $fclose(outfile);
      end
   end
   else
   begin
      if(VAC_cnt==0)
      begin
        outfile=$fopen(errFileName,"a");
        $strobe("dfwnsj1b_4    VAC     error limit ( %d ) reached at %7.4r  %M", maxEv, $abstime );
        $fwrite(outfile,"dfwnsj1b_4    VAC     error limit ( %d ) reached at %7.4r  %M\n", maxEv, $abstime );
        VAC_cnt=VAC_cnt-1;
        $fclose(outfile);
      end
   end

end // analog
endmodule // dfwnsj1b_4

// Verilog-A OC Watch for device dfwpsj1a_4 Parameters  VAC
module dfwpsj1a_4_ahdl(A,C);
parameter tstep_occ=100n;
parameter errFileName="./occ.err";
parameter maxEv = 25;
parameter maxEv_flg = 0;
inout A,C;
electrical A,C;

integer outfile;
real V_A_C;
real VAC;
integer VAC_retc;
integer VAC_cnt;

analog begin
   $bound_step( tstep_occ );
   @(initial_step) begin
      VAC_retc=0;
      VAC_cnt = maxEv;
   end
   V_A_C = V(A,C);

//      VAC
   VAC = V_A_C;
   if((VAC_cnt>0) || ( maxEv_flg==0 ))   begin
      if( (VAC < -72) && (VAC_retc!=-1))
      begin
        outfile=$fopen(errFileName,"a");
        $strobe("dfwpsj1a_4    VAC     leaving   OCA (  .. -72.000 V ) at %7.4r  %M", $abstime );
        $fwrite(outfile,"dfwpsj1a_4    VAC     leaving   OCA (  .. -72.000 V ) at %7.4r  %M\n", $abstime );
        VAC_retc=-1;
        VAC_cnt=VAC_cnt-1;
        $fclose(outfile);
      end
      if((VAC >= -72) &&  (VAC <= 1.5) && (VAC_retc!=0))
      begin
        outfile=$fopen(errFileName,"a");
        $strobe("dfwpsj1a_4    VAC     entering SOCA ( -72.000 V .. 1.500 V ) at %7.4r  %M", $abstime );
        $fwrite(outfile,"dfwpsj1a_4    VAC     entering SOCA ( -72.000 V .. 1.500 V ) at %7.4r  %M\n", $abstime );
        VAC_retc=0;
        VAC_cnt=VAC_cnt-1;
        $fclose(outfile);
      end
      if((VAC > 1.5) &&  (VAC_retc!=1))
      begin
        outfile=$fopen(errFileName,"a");
        $strobe("dfwpsj1a_4    VAC     leaving   OCA ( 1.500 V ..  ) at %7.4r  %M", $abstime );
        $fwrite(outfile,"dfwpsj1a_4    VAC     leaving   OCA ( 1.500 V ..  ) at %7.4r  %M\n", $abstime );
        VAC_retc=1;
        VAC_cnt=VAC_cnt-1;
        $fclose(outfile);
      end
   end
   else
   begin
      if(VAC_cnt==0)
      begin
        outfile=$fopen(errFileName,"a");
        $strobe("dfwpsj1a_4    VAC     error limit ( %d ) reached at %7.4r  %M", maxEv, $abstime );
        $fwrite(outfile,"dfwpsj1a_4    VAC     error limit ( %d ) reached at %7.4r  %M\n", maxEv, $abstime );
        VAC_cnt=VAC_cnt-1;
        $fclose(outfile);
      end
   end

end // analog
endmodule // dfwpsj1a_4

// Verilog-A OC Watch for device dfwnsj1b_5 Parameters  VAC
module dfwnsj1b_5_ahdl(A,C);
parameter tstep_occ=100n;
parameter errFileName="./occ.err";
parameter maxEv = 25;
parameter maxEv_flg = 0;
inout A,C;
electrical A,C;

integer outfile;
real V_A_C;
real VAC;
integer VAC_retc;
integer VAC_cnt;

analog begin
   $bound_step( tstep_occ );
   @(initial_step) begin
      VAC_retc=0;
      VAC_cnt = maxEv;
   end
   V_A_C = V(A,C);

//      VAC
   VAC = V_A_C;
   if((VAC_cnt>0) || ( maxEv_flg==0 ))   begin
      if( (VAC < -95) && (VAC_retc!=-1))
      begin
        outfile=$fopen(errFileName,"a");
        $strobe("dfwnsj1b_5    VAC     leaving   OCA (  .. -95.000 V ) at %7.4r  %M", $abstime );
        $fwrite(outfile,"dfwnsj1b_5    VAC     leaving   OCA (  .. -95.000 V ) at %7.4r  %M\n", $abstime );
        VAC_retc=-1;
        VAC_cnt=VAC_cnt-1;
        $fclose(outfile);
      end
      if((VAC >= -95) &&  (VAC <= 1.5) && (VAC_retc!=0))
      begin
        outfile=$fopen(errFileName,"a");
        $strobe("dfwnsj1b_5    VAC     entering SOCA ( -95.000 V .. 1.500 V ) at %7.4r  %M", $abstime );
        $fwrite(outfile,"dfwnsj1b_5    VAC     entering SOCA ( -95.000 V .. 1.500 V ) at %7.4r  %M\n", $abstime );
        VAC_retc=0;
        VAC_cnt=VAC_cnt-1;
        $fclose(outfile);
      end
      if((VAC > 1.5) &&  (VAC_retc!=1))
      begin
        outfile=$fopen(errFileName,"a");
        $strobe("dfwnsj1b_5    VAC     leaving   OCA ( 1.500 V ..  ) at %7.4r  %M", $abstime );
        $fwrite(outfile,"dfwnsj1b_5    VAC     leaving   OCA ( 1.500 V ..  ) at %7.4r  %M\n", $abstime );
        VAC_retc=1;
        VAC_cnt=VAC_cnt-1;
        $fclose(outfile);
      end
   end
   else
   begin
      if(VAC_cnt==0)
      begin
        outfile=$fopen(errFileName,"a");
        $strobe("dfwnsj1b_5    VAC     error limit ( %d ) reached at %7.4r  %M", maxEv, $abstime );
        $fwrite(outfile,"dfwnsj1b_5    VAC     error limit ( %d ) reached at %7.4r  %M\n", maxEv, $abstime );
        VAC_cnt=VAC_cnt-1;
        $fclose(outfile);
      end
   end

end // analog
endmodule // dfwnsj1b_5

// Verilog-A OC Watch for device dfwpsj1a_5 Parameters  VAC
module dfwpsj1a_5_ahdl(A,C);
parameter tstep_occ=100n;
parameter errFileName="./occ.err";
parameter maxEv = 25;
parameter maxEv_flg = 0;
inout A,C;
electrical A,C;

integer outfile;
real V_A_C;
real VAC;
integer VAC_retc;
integer VAC_cnt;

analog begin
   $bound_step( tstep_occ );
   @(initial_step) begin
      VAC_retc=0;
      VAC_cnt = maxEv;
   end
   V_A_C = V(A,C);

//      VAC
   VAC = V_A_C;
   if((VAC_cnt>0) || ( maxEv_flg==0 ))   begin
      if( (VAC < -95) && (VAC_retc!=-1))
      begin
        outfile=$fopen(errFileName,"a");
        $strobe("dfwpsj1a_5    VAC     leaving   OCA (  .. -95.000 V ) at %7.4r  %M", $abstime );
        $fwrite(outfile,"dfwpsj1a_5    VAC     leaving   OCA (  .. -95.000 V ) at %7.4r  %M\n", $abstime );
        VAC_retc=-1;
        VAC_cnt=VAC_cnt-1;
        $fclose(outfile);
      end
      if((VAC >= -95) &&  (VAC <= 1.5) && (VAC_retc!=0))
      begin
        outfile=$fopen(errFileName,"a");
        $strobe("dfwpsj1a_5    VAC     entering SOCA ( -95.000 V .. 1.500 V ) at %7.4r  %M", $abstime );
        $fwrite(outfile,"dfwpsj1a_5    VAC     entering SOCA ( -95.000 V .. 1.500 V ) at %7.4r  %M\n", $abstime );
        VAC_retc=0;
        VAC_cnt=VAC_cnt-1;
        $fclose(outfile);
      end
      if((VAC > 1.5) &&  (VAC_retc!=1))
      begin
        outfile=$fopen(errFileName,"a");
        $strobe("dfwpsj1a_5    VAC     leaving   OCA ( 1.500 V ..  ) at %7.4r  %M", $abstime );
        $fwrite(outfile,"dfwpsj1a_5    VAC     leaving   OCA ( 1.500 V ..  ) at %7.4r  %M\n", $abstime );
        VAC_retc=1;
        VAC_cnt=VAC_cnt-1;
        $fclose(outfile);
      end
   end
   else
   begin
      if(VAC_cnt==0)
      begin
        outfile=$fopen(errFileName,"a");
        $strobe("dfwpsj1a_5    VAC     error limit ( %d ) reached at %7.4r  %M", maxEv, $abstime );
        $fwrite(outfile,"dfwpsj1a_5    VAC     error limit ( %d ) reached at %7.4r  %M\n", maxEv, $abstime );
        VAC_cnt=VAC_cnt-1;
        $fclose(outfile);
      end
   end

end // analog
endmodule // dfwpsj1a_5

// Verilog-A OC Watch for device dfwnsj1b_7 Parameters  VAC IA
module dfwnsj1b_7_ahdl(A1,C1,A,C);
parameter tstep_occ=100n;
parameter errFileName="./occ.err";
parameter area = 1u;
parameter maxEv = 25;
parameter maxEv_flg = 0;
inout A1,C1,A,C;
electrical A1,C1,A,C;

integer outfile;
real V_A_C;
real I_C;
real I_A;
real VAC;
integer VAC_retc;
integer VAC_cnt;
real IA;
integer IA_retc;
integer IA_cnt;

analog begin
   $bound_step( tstep_occ );
   @(initial_step) begin
      VAC_retc=0;
      VAC_cnt = maxEv;
      IA_retc=0;
      IA_cnt = maxEv;
   end
   V_A_C = V(A,C);
   I_C = I(C1,C);
   I_A = I(A1,A);

//      VAC
   VAC = V_A_C;
   if((VAC_cnt>0) || ( maxEv_flg==0 ))   begin
      if( (VAC < -115) && (VAC_retc!=-1))
      begin
        outfile=$fopen(errFileName,"a");
        $strobe("dfwnsj1b_7    VAC     leaving   OCA (  .. -115.000 V ) at %7.4r  %M", $abstime );
        $fwrite(outfile,"dfwnsj1b_7    VAC     leaving   OCA (  .. -115.000 V ) at %7.4r  %M\n", $abstime );
        VAC_retc=-1;
        VAC_cnt=VAC_cnt-1;
        $fclose(outfile);
      end
      if((VAC >= -115) &&  (VAC <= 1.5) && (VAC_retc!=0))
      begin
        outfile=$fopen(errFileName,"a");
        $strobe("dfwnsj1b_7    VAC     entering SOCA ( -115.000 V .. 1.500 V ) at %7.4r  %M", $abstime );
        $fwrite(outfile,"dfwnsj1b_7    VAC     entering SOCA ( -115.000 V .. 1.500 V ) at %7.4r  %M\n", $abstime );
        VAC_retc=0;
        VAC_cnt=VAC_cnt-1;
        $fclose(outfile);
      end
      if((VAC > 1.5) &&  (VAC_retc!=1))
      begin
        outfile=$fopen(errFileName,"a");
        $strobe("dfwnsj1b_7    VAC     leaving   OCA ( 1.500 V ..  ) at %7.4r  %M", $abstime );
        $fwrite(outfile,"dfwnsj1b_7    VAC     leaving   OCA ( 1.500 V ..  ) at %7.4r  %M\n", $abstime );
        VAC_retc=1;
        VAC_cnt=VAC_cnt-1;
        $fclose(outfile);
      end
   end
   else
   begin
      if(VAC_cnt==0)
      begin
        outfile=$fopen(errFileName,"a");
        $strobe("dfwnsj1b_7    VAC     error limit ( %d ) reached at %7.4r  %M", maxEv, $abstime );
        $fwrite(outfile,"dfwnsj1b_7    VAC     error limit ( %d ) reached at %7.4r  %M\n", maxEv, $abstime );
        VAC_cnt=VAC_cnt-1;
        $fclose(outfile);
      end
   end

//      IA
   IA = I_A / area / 7e-06;
   if((IA_cnt>0) || ( maxEv_flg==0 ))   begin
      if( (IA < -60) && (IA_retc!=-1))
      begin
        outfile=$fopen(errFileName,"a");
        $strobe("dfwnsj1b_7    IA      leaving   OCA (  .. -0.060 mA/um ) at %7.4r  %M", $abstime );
        $fwrite(outfile,"dfwnsj1b_7    IA      leaving   OCA (  .. -0.060 mA/um ) at %7.4r  %M\n", $abstime );
        IA_retc=-1;
        IA_cnt=IA_cnt-1;
        $fclose(outfile);
      end
      if((IA >= -60) &&  (IA <= 60) && (IA_retc!=0))
      begin
        outfile=$fopen(errFileName,"a");
        $strobe("dfwnsj1b_7    IA      entering SOCA ( -0.060 mA/um .. 0.060 mA/um ) at %7.4r  %M", $abstime );
        $fwrite(outfile,"dfwnsj1b_7    IA      entering SOCA ( -0.060 mA/um .. 0.060 mA/um ) at %7.4r  %M\n", $abstime );
        IA_retc=0;
        IA_cnt=IA_cnt-1;
        $fclose(outfile);
      end
      if((IA > 60) &&  (IA_retc!=1))
      begin
        outfile=$fopen(errFileName,"a");
        $strobe("dfwnsj1b_7    IA      leaving   OCA ( 0.060 mA/um ..  ) at %7.4r  %M", $abstime );
        $fwrite(outfile,"dfwnsj1b_7    IA      leaving   OCA ( 0.060 mA/um ..  ) at %7.4r  %M\n", $abstime );
        IA_retc=1;
        IA_cnt=IA_cnt-1;
        $fclose(outfile);
      end
   end
   else
   begin
      if(IA_cnt==0)
      begin
        outfile=$fopen(errFileName,"a");
        $strobe("dfwnsj1b_7    IA      error limit ( %d ) reached at %7.4r  %M", maxEv, $abstime );
        $fwrite(outfile,"dfwnsj1b_7    IA      error limit ( %d ) reached at %7.4r  %M\n", maxEv, $abstime );
        IA_cnt=IA_cnt-1;
        $fclose(outfile);
      end
   end

end // analog
endmodule // dfwnsj1b_7

// Verilog-A OC Watch for device dfwpsj1a_7 Parameters  VAC IA
module dfwpsj1a_7_ahdl(A1,C1,A,C);
parameter tstep_occ=100n;
parameter errFileName="./occ.err";
parameter area = 1u;
parameter maxEv = 25;
parameter maxEv_flg = 0;
inout A1,C1,A,C;
electrical A1,C1,A,C;

integer outfile;
real V_A_C;
real I_C;
real I_A;
real VAC;
integer VAC_retc;
integer VAC_cnt;
real IA;
integer IA_retc;
integer IA_cnt;

analog begin
   $bound_step( tstep_occ );
   @(initial_step) begin
      VAC_retc=0;
      VAC_cnt = maxEv;
      IA_retc=0;
      IA_cnt = maxEv;
   end
   V_A_C = V(A,C);
   I_C = I(C1,C);
   I_A = I(A1,A);

//      VAC
   VAC = V_A_C;
   if((VAC_cnt>0) || ( maxEv_flg==0 ))   begin
      if( (VAC < -115) && (VAC_retc!=-1))
      begin
        outfile=$fopen(errFileName,"a");
        $strobe("dfwpsj1a_7    VAC     leaving   OCA (  .. -115.000 V ) at %7.4r  %M", $abstime );
        $fwrite(outfile,"dfwpsj1a_7    VAC     leaving   OCA (  .. -115.000 V ) at %7.4r  %M\n", $abstime );
        VAC_retc=-1;
        VAC_cnt=VAC_cnt-1;
        $fclose(outfile);
      end
      if((VAC >= -115) &&  (VAC <= 1.5) && (VAC_retc!=0))
      begin
        outfile=$fopen(errFileName,"a");
        $strobe("dfwpsj1a_7    VAC     entering SOCA ( -115.000 V .. 1.500 V ) at %7.4r  %M", $abstime );
        $fwrite(outfile,"dfwpsj1a_7    VAC     entering SOCA ( -115.000 V .. 1.500 V ) at %7.4r  %M\n", $abstime );
        VAC_retc=0;
        VAC_cnt=VAC_cnt-1;
        $fclose(outfile);
      end
      if((VAC > 1.5) &&  (VAC_retc!=1))
      begin
        outfile=$fopen(errFileName,"a");
        $strobe("dfwpsj1a_7    VAC     leaving   OCA ( 1.500 V ..  ) at %7.4r  %M", $abstime );
        $fwrite(outfile,"dfwpsj1a_7    VAC     leaving   OCA ( 1.500 V ..  ) at %7.4r  %M\n", $abstime );
        VAC_retc=1;
        VAC_cnt=VAC_cnt-1;
        $fclose(outfile);
      end
   end
   else
   begin
      if(VAC_cnt==0)
      begin
        outfile=$fopen(errFileName,"a");
        $strobe("dfwpsj1a_7    VAC     error limit ( %d ) reached at %7.4r  %M", maxEv, $abstime );
        $fwrite(outfile,"dfwpsj1a_7    VAC     error limit ( %d ) reached at %7.4r  %M\n", maxEv, $abstime );
        VAC_cnt=VAC_cnt-1;
        $fclose(outfile);
      end
   end

//      IA
   IA = I_A / area / 7e-06;
   if((IA_cnt>0) || ( maxEv_flg==0 ))   begin
      if( (IA < -60) && (IA_retc!=-1))
      begin
        outfile=$fopen(errFileName,"a");
        $strobe("dfwpsj1a_7    IA      leaving   OCA (  .. -0.060 mA/um ) at %7.4r  %M", $abstime );
        $fwrite(outfile,"dfwpsj1a_7    IA      leaving   OCA (  .. -0.060 mA/um ) at %7.4r  %M\n", $abstime );
        IA_retc=-1;
        IA_cnt=IA_cnt-1;
        $fclose(outfile);
      end
      if((IA >= -60) &&  (IA <= 60) && (IA_retc!=0))
      begin
        outfile=$fopen(errFileName,"a");
        $strobe("dfwpsj1a_7    IA      entering SOCA ( -0.060 mA/um .. 0.060 mA/um ) at %7.4r  %M", $abstime );
        $fwrite(outfile,"dfwpsj1a_7    IA      entering SOCA ( -0.060 mA/um .. 0.060 mA/um ) at %7.4r  %M\n", $abstime );
        IA_retc=0;
        IA_cnt=IA_cnt-1;
        $fclose(outfile);
      end
      if((IA > 60) &&  (IA_retc!=1))
      begin
        outfile=$fopen(errFileName,"a");
        $strobe("dfwpsj1a_7    IA      leaving   OCA ( 0.060 mA/um ..  ) at %7.4r  %M", $abstime );
        $fwrite(outfile,"dfwpsj1a_7    IA      leaving   OCA ( 0.060 mA/um ..  ) at %7.4r  %M\n", $abstime );
        IA_retc=1;
        IA_cnt=IA_cnt-1;
        $fclose(outfile);
      end
   end
   else
   begin
      if(IA_cnt==0)
      begin
        outfile=$fopen(errFileName,"a");
        $strobe("dfwpsj1a_7    IA      error limit ( %d ) reached at %7.4r  %M", maxEv, $abstime );
        $fwrite(outfile,"dfwpsj1a_7    IA      error limit ( %d ) reached at %7.4r  %M\n", maxEv, $abstime );
        IA_cnt=IA_cnt-1;
        $fclose(outfile);
      end
   end

end // analog
endmodule // dfwpsj1a_7

// Verilog-A OC Watch for device dfwpsj2b_7 Parameters  VAC IA
module dfwpsj2b_7_ahdl(A1,C1,A,C);
parameter tstep_occ=100n;
parameter errFileName="./occ.err";
parameter area = 1u;
parameter maxEv = 25;
parameter maxEv_flg = 0;
inout A1,C1,A,C;
electrical A1,C1,A,C;

integer outfile;
real V_A_C;
real I_C;
real I_A;
real VAC;
integer VAC_retc;
integer VAC_cnt;
real IA;
integer IA_retc;
integer IA_cnt;

analog begin
   $bound_step( tstep_occ );
   @(initial_step) begin
      VAC_retc=0;
      VAC_cnt = maxEv;
      IA_retc=0;
      IA_cnt = maxEv;
   end
   V_A_C = V(A,C);
   I_C = I(C1,C);
   I_A = I(A1,A);

//      VAC
   VAC = V_A_C;
   if((VAC_cnt>0) || ( maxEv_flg==0 ))   begin
      if( (VAC < -115) && (VAC_retc!=-1))
      begin
        outfile=$fopen(errFileName,"a");
        $strobe("dfwpsj2b_7    VAC     leaving   OCA (  .. -115.000 V ) at %7.4r  %M", $abstime );
        $fwrite(outfile,"dfwpsj2b_7    VAC     leaving   OCA (  .. -115.000 V ) at %7.4r  %M\n", $abstime );
        VAC_retc=-1;
        VAC_cnt=VAC_cnt-1;
        $fclose(outfile);
      end
      if((VAC >= -115) &&  (VAC <= 1.5) && (VAC_retc!=0))
      begin
        outfile=$fopen(errFileName,"a");
        $strobe("dfwpsj2b_7    VAC     entering SOCA ( -115.000 V .. 1.500 V ) at %7.4r  %M", $abstime );
        $fwrite(outfile,"dfwpsj2b_7    VAC     entering SOCA ( -115.000 V .. 1.500 V ) at %7.4r  %M\n", $abstime );
        VAC_retc=0;
        VAC_cnt=VAC_cnt-1;
        $fclose(outfile);
      end
      if((VAC > 1.5) &&  (VAC_retc!=1))
      begin
        outfile=$fopen(errFileName,"a");
        $strobe("dfwpsj2b_7    VAC     leaving   OCA ( 1.500 V ..  ) at %7.4r  %M", $abstime );
        $fwrite(outfile,"dfwpsj2b_7    VAC     leaving   OCA ( 1.500 V ..  ) at %7.4r  %M\n", $abstime );
        VAC_retc=1;
        VAC_cnt=VAC_cnt-1;
        $fclose(outfile);
      end
   end
   else
   begin
      if(VAC_cnt==0)
      begin
        outfile=$fopen(errFileName,"a");
        $strobe("dfwpsj2b_7    VAC     error limit ( %d ) reached at %7.4r  %M", maxEv, $abstime );
        $fwrite(outfile,"dfwpsj2b_7    VAC     error limit ( %d ) reached at %7.4r  %M\n", maxEv, $abstime );
        VAC_cnt=VAC_cnt-1;
        $fclose(outfile);
      end
   end

//      IA
   IA = I_A / area / 7e-06;
   if((IA_cnt>0) || ( maxEv_flg==0 ))   begin
      if( (IA < -60) && (IA_retc!=-1))
      begin
        outfile=$fopen(errFileName,"a");
        $strobe("dfwpsj2b_7    IA      leaving   OCA (  .. -0.060 mA/um ) at %7.4r  %M", $abstime );
        $fwrite(outfile,"dfwpsj2b_7    IA      leaving   OCA (  .. -0.060 mA/um ) at %7.4r  %M\n", $abstime );
        IA_retc=-1;
        IA_cnt=IA_cnt-1;
        $fclose(outfile);
      end
      if((IA >= -60) &&  (IA <= 60) && (IA_retc!=0))
      begin
        outfile=$fopen(errFileName,"a");
        $strobe("dfwpsj2b_7    IA      entering SOCA ( -0.060 mA/um .. 0.060 mA/um ) at %7.4r  %M", $abstime );
        $fwrite(outfile,"dfwpsj2b_7    IA      entering SOCA ( -0.060 mA/um .. 0.060 mA/um ) at %7.4r  %M\n", $abstime );
        IA_retc=0;
        IA_cnt=IA_cnt-1;
        $fclose(outfile);
      end
      if((IA > 60) &&  (IA_retc!=1))
      begin
        outfile=$fopen(errFileName,"a");
        $strobe("dfwpsj2b_7    IA      leaving   OCA ( 0.060 mA/um ..  ) at %7.4r  %M", $abstime );
        $fwrite(outfile,"dfwpsj2b_7    IA      leaving   OCA ( 0.060 mA/um ..  ) at %7.4r  %M\n", $abstime );
        IA_retc=1;
        IA_cnt=IA_cnt-1;
        $fclose(outfile);
      end
   end
   else
   begin
      if(IA_cnt==0)
      begin
        outfile=$fopen(errFileName,"a");
        $strobe("dfwpsj2b_7    IA      error limit ( %d ) reached at %7.4r  %M", maxEv, $abstime );
        $fwrite(outfile,"dfwpsj2b_7    IA      error limit ( %d ) reached at %7.4r  %M\n", maxEv, $abstime );
        IA_cnt=IA_cnt-1;
        $fclose(outfile);
      end
   end

end // analog
endmodule // dfwpsj2b_7

// Verilog-A OC Watch for device dfwnsj1b_8 Parameters  VAC IA
module dfwnsj1b_8_ahdl(A1,C1,A,C);
parameter tstep_occ=100n;
parameter errFileName="./occ.err";
parameter area = 1u;
parameter maxEv = 25;
parameter maxEv_flg = 0;
inout A1,C1,A,C;
electrical A1,C1,A,C;

integer outfile;
real V_A_C;
real I_C;
real I_A;
real VAC;
integer VAC_retc;
integer VAC_cnt;
real IA;
integer IA_retc;
integer IA_cnt;

analog begin
   $bound_step( tstep_occ );
   @(initial_step) begin
      VAC_retc=0;
      VAC_cnt = maxEv;
      IA_retc=0;
      IA_cnt = maxEv;
   end
   V_A_C = V(A,C);
   I_C = I(C1,C);
   I_A = I(A1,A);

//      VAC
   VAC = V_A_C;
   if((VAC_cnt>0) || ( maxEv_flg==0 ))   begin
      if( (VAC < -140) && (VAC_retc!=-1))
      begin
        outfile=$fopen(errFileName,"a");
        $strobe("dfwnsj1b_8    VAC     leaving   OCA (  .. -140.000 V ) at %7.4r  %M", $abstime );
        $fwrite(outfile,"dfwnsj1b_8    VAC     leaving   OCA (  .. -140.000 V ) at %7.4r  %M\n", $abstime );
        VAC_retc=-1;
        VAC_cnt=VAC_cnt-1;
        $fclose(outfile);
      end
      if((VAC >= -140) &&  (VAC <= 1.5) && (VAC_retc!=0))
      begin
        outfile=$fopen(errFileName,"a");
        $strobe("dfwnsj1b_8    VAC     entering SOCA ( -140.000 V .. 1.500 V ) at %7.4r  %M", $abstime );
        $fwrite(outfile,"dfwnsj1b_8    VAC     entering SOCA ( -140.000 V .. 1.500 V ) at %7.4r  %M\n", $abstime );
        VAC_retc=0;
        VAC_cnt=VAC_cnt-1;
        $fclose(outfile);
      end
      if((VAC > 1.5) &&  (VAC_retc!=1))
      begin
        outfile=$fopen(errFileName,"a");
        $strobe("dfwnsj1b_8    VAC     leaving   OCA ( 1.500 V ..  ) at %7.4r  %M", $abstime );
        $fwrite(outfile,"dfwnsj1b_8    VAC     leaving   OCA ( 1.500 V ..  ) at %7.4r  %M\n", $abstime );
        VAC_retc=1;
        VAC_cnt=VAC_cnt-1;
        $fclose(outfile);
      end
   end
   else
   begin
      if(VAC_cnt==0)
      begin
        outfile=$fopen(errFileName,"a");
        $strobe("dfwnsj1b_8    VAC     error limit ( %d ) reached at %7.4r  %M", maxEv, $abstime );
        $fwrite(outfile,"dfwnsj1b_8    VAC     error limit ( %d ) reached at %7.4r  %M\n", maxEv, $abstime );
        VAC_cnt=VAC_cnt-1;
        $fclose(outfile);
      end
   end

//      IA
   IA = I_A / area / 8.5e-06;
   if((IA_cnt>0) || ( maxEv_flg==0 ))   begin
      if( (IA < -60) && (IA_retc!=-1))
      begin
        outfile=$fopen(errFileName,"a");
        $strobe("dfwnsj1b_8    IA      leaving   OCA (  .. -0.060 mA/um ) at %7.4r  %M", $abstime );
        $fwrite(outfile,"dfwnsj1b_8    IA      leaving   OCA (  .. -0.060 mA/um ) at %7.4r  %M\n", $abstime );
        IA_retc=-1;
        IA_cnt=IA_cnt-1;
        $fclose(outfile);
      end
      if((IA >= -60) &&  (IA <= 60) && (IA_retc!=0))
      begin
        outfile=$fopen(errFileName,"a");
        $strobe("dfwnsj1b_8    IA      entering SOCA ( -0.060 mA/um .. 0.060 mA/um ) at %7.4r  %M", $abstime );
        $fwrite(outfile,"dfwnsj1b_8    IA      entering SOCA ( -0.060 mA/um .. 0.060 mA/um ) at %7.4r  %M\n", $abstime );
        IA_retc=0;
        IA_cnt=IA_cnt-1;
        $fclose(outfile);
      end
      if((IA > 60) &&  (IA_retc!=1))
      begin
        outfile=$fopen(errFileName,"a");
        $strobe("dfwnsj1b_8    IA      leaving   OCA ( 0.060 mA/um ..  ) at %7.4r  %M", $abstime );
        $fwrite(outfile,"dfwnsj1b_8    IA      leaving   OCA ( 0.060 mA/um ..  ) at %7.4r  %M\n", $abstime );
        IA_retc=1;
        IA_cnt=IA_cnt-1;
        $fclose(outfile);
      end
   end
   else
   begin
      if(IA_cnt==0)
      begin
        outfile=$fopen(errFileName,"a");
        $strobe("dfwnsj1b_8    IA      error limit ( %d ) reached at %7.4r  %M", maxEv, $abstime );
        $fwrite(outfile,"dfwnsj1b_8    IA      error limit ( %d ) reached at %7.4r  %M\n", maxEv, $abstime );
        IA_cnt=IA_cnt-1;
        $fclose(outfile);
      end
   end

end // analog
endmodule // dfwnsj1b_8

// Verilog-A OC Watch for device dfwpsj1a_8 Parameters  VAC IA
module dfwpsj1a_8_ahdl(A1,C1,A,C);
parameter tstep_occ=100n;
parameter errFileName="./occ.err";
parameter area = 1u;
parameter maxEv = 25;
parameter maxEv_flg = 0;
inout A1,C1,A,C;
electrical A1,C1,A,C;

integer outfile;
real V_A_C;
real I_C;
real I_A;
real VAC;
integer VAC_retc;
integer VAC_cnt;
real IA;
integer IA_retc;
integer IA_cnt;

analog begin
   $bound_step( tstep_occ );
   @(initial_step) begin
      VAC_retc=0;
      VAC_cnt = maxEv;
      IA_retc=0;
      IA_cnt = maxEv;
   end
   V_A_C = V(A,C);
   I_C = I(C1,C);
   I_A = I(A1,A);

//      VAC
   VAC = V_A_C;
   if((VAC_cnt>0) || ( maxEv_flg==0 ))   begin
      if( (VAC < -140) && (VAC_retc!=-1))
      begin
        outfile=$fopen(errFileName,"a");
        $strobe("dfwpsj1a_8    VAC     leaving   OCA (  .. -140.000 V ) at %7.4r  %M", $abstime );
        $fwrite(outfile,"dfwpsj1a_8    VAC     leaving   OCA (  .. -140.000 V ) at %7.4r  %M\n", $abstime );
        VAC_retc=-1;
        VAC_cnt=VAC_cnt-1;
        $fclose(outfile);
      end
      if((VAC >= -140) &&  (VAC <= 1.5) && (VAC_retc!=0))
      begin
        outfile=$fopen(errFileName,"a");
        $strobe("dfwpsj1a_8    VAC     entering SOCA ( -140.000 V .. 1.500 V ) at %7.4r  %M", $abstime );
        $fwrite(outfile,"dfwpsj1a_8    VAC     entering SOCA ( -140.000 V .. 1.500 V ) at %7.4r  %M\n", $abstime );
        VAC_retc=0;
        VAC_cnt=VAC_cnt-1;
        $fclose(outfile);
      end
      if((VAC > 1.5) &&  (VAC_retc!=1))
      begin
        outfile=$fopen(errFileName,"a");
        $strobe("dfwpsj1a_8    VAC     leaving   OCA ( 1.500 V ..  ) at %7.4r  %M", $abstime );
        $fwrite(outfile,"dfwpsj1a_8    VAC     leaving   OCA ( 1.500 V ..  ) at %7.4r  %M\n", $abstime );
        VAC_retc=1;
        VAC_cnt=VAC_cnt-1;
        $fclose(outfile);
      end
   end
   else
   begin
      if(VAC_cnt==0)
      begin
        outfile=$fopen(errFileName,"a");
        $strobe("dfwpsj1a_8    VAC     error limit ( %d ) reached at %7.4r  %M", maxEv, $abstime );
        $fwrite(outfile,"dfwpsj1a_8    VAC     error limit ( %d ) reached at %7.4r  %M\n", maxEv, $abstime );
        VAC_cnt=VAC_cnt-1;
        $fclose(outfile);
      end
   end

//      IA
   IA = I_A / area / 8.5e-06;
   if((IA_cnt>0) || ( maxEv_flg==0 ))   begin
      if( (IA < -60) && (IA_retc!=-1))
      begin
        outfile=$fopen(errFileName,"a");
        $strobe("dfwpsj1a_8    IA      leaving   OCA (  .. -0.060 mA/um ) at %7.4r  %M", $abstime );
        $fwrite(outfile,"dfwpsj1a_8    IA      leaving   OCA (  .. -0.060 mA/um ) at %7.4r  %M\n", $abstime );
        IA_retc=-1;
        IA_cnt=IA_cnt-1;
        $fclose(outfile);
      end
      if((IA >= -60) &&  (IA <= 60) && (IA_retc!=0))
      begin
        outfile=$fopen(errFileName,"a");
        $strobe("dfwpsj1a_8    IA      entering SOCA ( -0.060 mA/um .. 0.060 mA/um ) at %7.4r  %M", $abstime );
        $fwrite(outfile,"dfwpsj1a_8    IA      entering SOCA ( -0.060 mA/um .. 0.060 mA/um ) at %7.4r  %M\n", $abstime );
        IA_retc=0;
        IA_cnt=IA_cnt-1;
        $fclose(outfile);
      end
      if((IA > 60) &&  (IA_retc!=1))
      begin
        outfile=$fopen(errFileName,"a");
        $strobe("dfwpsj1a_8    IA      leaving   OCA ( 0.060 mA/um ..  ) at %7.4r  %M", $abstime );
        $fwrite(outfile,"dfwpsj1a_8    IA      leaving   OCA ( 0.060 mA/um ..  ) at %7.4r  %M\n", $abstime );
        IA_retc=1;
        IA_cnt=IA_cnt-1;
        $fclose(outfile);
      end
   end
   else
   begin
      if(IA_cnt==0)
      begin
        outfile=$fopen(errFileName,"a");
        $strobe("dfwpsj1a_8    IA      error limit ( %d ) reached at %7.4r  %M", maxEv, $abstime );
        $fwrite(outfile,"dfwpsj1a_8    IA      error limit ( %d ) reached at %7.4r  %M\n", maxEv, $abstime );
        IA_cnt=IA_cnt-1;
        $fclose(outfile);
      end
   end

end // analog
endmodule // dfwpsj1a_8

// Verilog-A OC Watch for device dfwpsj2b_8 Parameters  VAC IA
module dfwpsj2b_8_ahdl(A1,C1,A,C);
parameter tstep_occ=100n;
parameter errFileName="./occ.err";
parameter area = 1u;
parameter maxEv = 25;
parameter maxEv_flg = 0;
inout A1,C1,A,C;
electrical A1,C1,A,C;

integer outfile;
real V_A_C;
real I_C;
real I_A;
real VAC;
integer VAC_retc;
integer VAC_cnt;
real IA;
integer IA_retc;
integer IA_cnt;

analog begin
   $bound_step( tstep_occ );
   @(initial_step) begin
      VAC_retc=0;
      VAC_cnt = maxEv;
      IA_retc=0;
      IA_cnt = maxEv;
   end
   V_A_C = V(A,C);
   I_C = I(C1,C);
   I_A = I(A1,A);

//      VAC
   VAC = V_A_C;
   if((VAC_cnt>0) || ( maxEv_flg==0 ))   begin
      if( (VAC < -140) && (VAC_retc!=-1))
      begin
        outfile=$fopen(errFileName,"a");
        $strobe("dfwpsj2b_8    VAC     leaving   OCA (  .. -140.000 V ) at %7.4r  %M", $abstime );
        $fwrite(outfile,"dfwpsj2b_8    VAC     leaving   OCA (  .. -140.000 V ) at %7.4r  %M\n", $abstime );
        VAC_retc=-1;
        VAC_cnt=VAC_cnt-1;
        $fclose(outfile);
      end
      if((VAC >= -140) &&  (VAC <= 1.5) && (VAC_retc!=0))
      begin
        outfile=$fopen(errFileName,"a");
        $strobe("dfwpsj2b_8    VAC     entering SOCA ( -140.000 V .. 1.500 V ) at %7.4r  %M", $abstime );
        $fwrite(outfile,"dfwpsj2b_8    VAC     entering SOCA ( -140.000 V .. 1.500 V ) at %7.4r  %M\n", $abstime );
        VAC_retc=0;
        VAC_cnt=VAC_cnt-1;
        $fclose(outfile);
      end
      if((VAC > 1.5) &&  (VAC_retc!=1))
      begin
        outfile=$fopen(errFileName,"a");
        $strobe("dfwpsj2b_8    VAC     leaving   OCA ( 1.500 V ..  ) at %7.4r  %M", $abstime );
        $fwrite(outfile,"dfwpsj2b_8    VAC     leaving   OCA ( 1.500 V ..  ) at %7.4r  %M\n", $abstime );
        VAC_retc=1;
        VAC_cnt=VAC_cnt-1;
        $fclose(outfile);
      end
   end
   else
   begin
      if(VAC_cnt==0)
      begin
        outfile=$fopen(errFileName,"a");
        $strobe("dfwpsj2b_8    VAC     error limit ( %d ) reached at %7.4r  %M", maxEv, $abstime );
        $fwrite(outfile,"dfwpsj2b_8    VAC     error limit ( %d ) reached at %7.4r  %M\n", maxEv, $abstime );
        VAC_cnt=VAC_cnt-1;
        $fclose(outfile);
      end
   end

//      IA
   IA = I_A / area / 8.5e-06;
   if((IA_cnt>0) || ( maxEv_flg==0 ))   begin
      if( (IA < -60) && (IA_retc!=-1))
      begin
        outfile=$fopen(errFileName,"a");
        $strobe("dfwpsj2b_8    IA      leaving   OCA (  .. -0.060 mA/um ) at %7.4r  %M", $abstime );
        $fwrite(outfile,"dfwpsj2b_8    IA      leaving   OCA (  .. -0.060 mA/um ) at %7.4r  %M\n", $abstime );
        IA_retc=-1;
        IA_cnt=IA_cnt-1;
        $fclose(outfile);
      end
      if((IA >= -60) &&  (IA <= 60) && (IA_retc!=0))
      begin
        outfile=$fopen(errFileName,"a");
        $strobe("dfwpsj2b_8    IA      entering SOCA ( -0.060 mA/um .. 0.060 mA/um ) at %7.4r  %M", $abstime );
        $fwrite(outfile,"dfwpsj2b_8    IA      entering SOCA ( -0.060 mA/um .. 0.060 mA/um ) at %7.4r  %M\n", $abstime );
        IA_retc=0;
        IA_cnt=IA_cnt-1;
        $fclose(outfile);
      end
      if((IA > 60) &&  (IA_retc!=1))
      begin
        outfile=$fopen(errFileName,"a");
        $strobe("dfwpsj2b_8    IA      leaving   OCA ( 0.060 mA/um ..  ) at %7.4r  %M", $abstime );
        $fwrite(outfile,"dfwpsj2b_8    IA      leaving   OCA ( 0.060 mA/um ..  ) at %7.4r  %M\n", $abstime );
        IA_retc=1;
        IA_cnt=IA_cnt-1;
        $fclose(outfile);
      end
   end
   else
   begin
      if(IA_cnt==0)
      begin
        outfile=$fopen(errFileName,"a");
        $strobe("dfwpsj2b_8    IA      error limit ( %d ) reached at %7.4r  %M", maxEv, $abstime );
        $fwrite(outfile,"dfwpsj2b_8    IA      error limit ( %d ) reached at %7.4r  %M\n", maxEv, $abstime );
        IA_cnt=IA_cnt-1;
        $fclose(outfile);
      end
   end

end // analog
endmodule // dfwpsj2b_8

// Verilog-A OC Watch for device dfwnsj1b_10 Parameters  VAC IA
module dfwnsj1b_10_ahdl(A1,C1,A,C);
parameter tstep_occ=100n;
parameter errFileName="./occ.err";
parameter area = 1u;
parameter maxEv = 25;
parameter maxEv_flg = 0;
inout A1,C1,A,C;
electrical A1,C1,A,C;

integer outfile;
real V_A_C;
real I_C;
real I_A;
real VAC;
integer VAC_retc;
integer VAC_cnt;
real IA;
integer IA_retc;
integer IA_cnt;

analog begin
   $bound_step( tstep_occ );
   @(initial_step) begin
      VAC_retc=0;
      VAC_cnt = maxEv;
      IA_retc=0;
      IA_cnt = maxEv;
   end
   V_A_C = V(A,C);
   I_C = I(C1,C);
   I_A = I(A1,A);

//      VAC
   VAC = V_A_C;
   if((VAC_cnt>0) || ( maxEv_flg==0 ))   begin
      if( (VAC < -155) && (VAC_retc!=-1))
      begin
        outfile=$fopen(errFileName,"a");
        $strobe("dfwnsj1b_10   VAC     leaving   OCA (  .. -155.000 V ) at %7.4r  %M", $abstime );
        $fwrite(outfile,"dfwnsj1b_10   VAC     leaving   OCA (  .. -155.000 V ) at %7.4r  %M\n", $abstime );
        VAC_retc=-1;
        VAC_cnt=VAC_cnt-1;
        $fclose(outfile);
      end
      if((VAC >= -155) &&  (VAC <= 1.5) && (VAC_retc!=0))
      begin
        outfile=$fopen(errFileName,"a");
        $strobe("dfwnsj1b_10   VAC     entering SOCA ( -155.000 V .. 1.500 V ) at %7.4r  %M", $abstime );
        $fwrite(outfile,"dfwnsj1b_10   VAC     entering SOCA ( -155.000 V .. 1.500 V ) at %7.4r  %M\n", $abstime );
        VAC_retc=0;
        VAC_cnt=VAC_cnt-1;
        $fclose(outfile);
      end
      if((VAC > 1.5) &&  (VAC_retc!=1))
      begin
        outfile=$fopen(errFileName,"a");
        $strobe("dfwnsj1b_10   VAC     leaving   OCA ( 1.500 V ..  ) at %7.4r  %M", $abstime );
        $fwrite(outfile,"dfwnsj1b_10   VAC     leaving   OCA ( 1.500 V ..  ) at %7.4r  %M\n", $abstime );
        VAC_retc=1;
        VAC_cnt=VAC_cnt-1;
        $fclose(outfile);
      end
   end
   else
   begin
      if(VAC_cnt==0)
      begin
        outfile=$fopen(errFileName,"a");
        $strobe("dfwnsj1b_10   VAC     error limit ( %d ) reached at %7.4r  %M", maxEv, $abstime );
        $fwrite(outfile,"dfwnsj1b_10   VAC     error limit ( %d ) reached at %7.4r  %M\n", maxEv, $abstime );
        VAC_cnt=VAC_cnt-1;
        $fclose(outfile);
      end
   end

//      IA
   IA = I_A / area / 1e-05;
   if((IA_cnt>0) || ( maxEv_flg==0 ))   begin
      if( (IA < -60) && (IA_retc!=-1))
      begin
        outfile=$fopen(errFileName,"a");
        $strobe("dfwnsj1b_10   IA      leaving   OCA (  .. -0.060 mA/um ) at %7.4r  %M", $abstime );
        $fwrite(outfile,"dfwnsj1b_10   IA      leaving   OCA (  .. -0.060 mA/um ) at %7.4r  %M\n", $abstime );
        IA_retc=-1;
        IA_cnt=IA_cnt-1;
        $fclose(outfile);
      end
      if((IA >= -60) &&  (IA <= 60) && (IA_retc!=0))
      begin
        outfile=$fopen(errFileName,"a");
        $strobe("dfwnsj1b_10   IA      entering SOCA ( -0.060 mA/um .. 0.060 mA/um ) at %7.4r  %M", $abstime );
        $fwrite(outfile,"dfwnsj1b_10   IA      entering SOCA ( -0.060 mA/um .. 0.060 mA/um ) at %7.4r  %M\n", $abstime );
        IA_retc=0;
        IA_cnt=IA_cnt-1;
        $fclose(outfile);
      end
      if((IA > 60) &&  (IA_retc!=1))
      begin
        outfile=$fopen(errFileName,"a");
        $strobe("dfwnsj1b_10   IA      leaving   OCA ( 0.060 mA/um ..  ) at %7.4r  %M", $abstime );
        $fwrite(outfile,"dfwnsj1b_10   IA      leaving   OCA ( 0.060 mA/um ..  ) at %7.4r  %M\n", $abstime );
        IA_retc=1;
        IA_cnt=IA_cnt-1;
        $fclose(outfile);
      end
   end
   else
   begin
      if(IA_cnt==0)
      begin
        outfile=$fopen(errFileName,"a");
        $strobe("dfwnsj1b_10   IA      error limit ( %d ) reached at %7.4r  %M", maxEv, $abstime );
        $fwrite(outfile,"dfwnsj1b_10   IA      error limit ( %d ) reached at %7.4r  %M\n", maxEv, $abstime );
        IA_cnt=IA_cnt-1;
        $fclose(outfile);
      end
   end

end // analog
endmodule // dfwnsj1b_10

// Verilog-A OC Watch for device dfwpsj1a_10 Parameters  VAC IA
module dfwpsj1a_10_ahdl(A1,C1,A,C);
parameter tstep_occ=100n;
parameter errFileName="./occ.err";
parameter area = 1u;
parameter maxEv = 25;
parameter maxEv_flg = 0;
inout A1,C1,A,C;
electrical A1,C1,A,C;

integer outfile;
real V_A_C;
real I_C;
real I_A;
real VAC;
integer VAC_retc;
integer VAC_cnt;
real IA;
integer IA_retc;
integer IA_cnt;

analog begin
   $bound_step( tstep_occ );
   @(initial_step) begin
      VAC_retc=0;
      VAC_cnt = maxEv;
      IA_retc=0;
      IA_cnt = maxEv;
   end
   V_A_C = V(A,C);
   I_C = I(C1,C);
   I_A = I(A1,A);

//      VAC
   VAC = V_A_C;
   if((VAC_cnt>0) || ( maxEv_flg==0 ))   begin
      if( (VAC < -155) && (VAC_retc!=-1))
      begin
        outfile=$fopen(errFileName,"a");
        $strobe("dfwpsj1a_10   VAC     leaving   OCA (  .. -155.000 V ) at %7.4r  %M", $abstime );
        $fwrite(outfile,"dfwpsj1a_10   VAC     leaving   OCA (  .. -155.000 V ) at %7.4r  %M\n", $abstime );
        VAC_retc=-1;
        VAC_cnt=VAC_cnt-1;
        $fclose(outfile);
      end
      if((VAC >= -155) &&  (VAC <= 1.5) && (VAC_retc!=0))
      begin
        outfile=$fopen(errFileName,"a");
        $strobe("dfwpsj1a_10   VAC     entering SOCA ( -155.000 V .. 1.500 V ) at %7.4r  %M", $abstime );
        $fwrite(outfile,"dfwpsj1a_10   VAC     entering SOCA ( -155.000 V .. 1.500 V ) at %7.4r  %M\n", $abstime );
        VAC_retc=0;
        VAC_cnt=VAC_cnt-1;
        $fclose(outfile);
      end
      if((VAC > 1.5) &&  (VAC_retc!=1))
      begin
        outfile=$fopen(errFileName,"a");
        $strobe("dfwpsj1a_10   VAC     leaving   OCA ( 1.500 V ..  ) at %7.4r  %M", $abstime );
        $fwrite(outfile,"dfwpsj1a_10   VAC     leaving   OCA ( 1.500 V ..  ) at %7.4r  %M\n", $abstime );
        VAC_retc=1;
        VAC_cnt=VAC_cnt-1;
        $fclose(outfile);
      end
   end
   else
   begin
      if(VAC_cnt==0)
      begin
        outfile=$fopen(errFileName,"a");
        $strobe("dfwpsj1a_10   VAC     error limit ( %d ) reached at %7.4r  %M", maxEv, $abstime );
        $fwrite(outfile,"dfwpsj1a_10   VAC     error limit ( %d ) reached at %7.4r  %M\n", maxEv, $abstime );
        VAC_cnt=VAC_cnt-1;
        $fclose(outfile);
      end
   end

//      IA
   IA = I_A / area / 1e-05;
   if((IA_cnt>0) || ( maxEv_flg==0 ))   begin
      if( (IA < -60) && (IA_retc!=-1))
      begin
        outfile=$fopen(errFileName,"a");
        $strobe("dfwpsj1a_10   IA      leaving   OCA (  .. -0.060 mA/um ) at %7.4r  %M", $abstime );
        $fwrite(outfile,"dfwpsj1a_10   IA      leaving   OCA (  .. -0.060 mA/um ) at %7.4r  %M\n", $abstime );
        IA_retc=-1;
        IA_cnt=IA_cnt-1;
        $fclose(outfile);
      end
      if((IA >= -60) &&  (IA <= 60) && (IA_retc!=0))
      begin
        outfile=$fopen(errFileName,"a");
        $strobe("dfwpsj1a_10   IA      entering SOCA ( -0.060 mA/um .. 0.060 mA/um ) at %7.4r  %M", $abstime );
        $fwrite(outfile,"dfwpsj1a_10   IA      entering SOCA ( -0.060 mA/um .. 0.060 mA/um ) at %7.4r  %M\n", $abstime );
        IA_retc=0;
        IA_cnt=IA_cnt-1;
        $fclose(outfile);
      end
      if((IA > 60) &&  (IA_retc!=1))
      begin
        outfile=$fopen(errFileName,"a");
        $strobe("dfwpsj1a_10   IA      leaving   OCA ( 0.060 mA/um ..  ) at %7.4r  %M", $abstime );
        $fwrite(outfile,"dfwpsj1a_10   IA      leaving   OCA ( 0.060 mA/um ..  ) at %7.4r  %M\n", $abstime );
        IA_retc=1;
        IA_cnt=IA_cnt-1;
        $fclose(outfile);
      end
   end
   else
   begin
      if(IA_cnt==0)
      begin
        outfile=$fopen(errFileName,"a");
        $strobe("dfwpsj1a_10   IA      error limit ( %d ) reached at %7.4r  %M", maxEv, $abstime );
        $fwrite(outfile,"dfwpsj1a_10   IA      error limit ( %d ) reached at %7.4r  %M\n", maxEv, $abstime );
        IA_cnt=IA_cnt-1;
        $fclose(outfile);
      end
   end

end // analog
endmodule // dfwpsj1a_10

// Verilog-A OC Watch for device dfwpsj2b_10 Parameters  VAC IA
module dfwpsj2b_10_ahdl(A1,C1,A,C);
parameter tstep_occ=100n;
parameter errFileName="./occ.err";
parameter area = 1u;
parameter maxEv = 25;
parameter maxEv_flg = 0;
inout A1,C1,A,C;
electrical A1,C1,A,C;

integer outfile;
real V_A_C;
real I_C;
real I_A;
real VAC;
integer VAC_retc;
integer VAC_cnt;
real IA;
integer IA_retc;
integer IA_cnt;

analog begin
   $bound_step( tstep_occ );
   @(initial_step) begin
      VAC_retc=0;
      VAC_cnt = maxEv;
      IA_retc=0;
      IA_cnt = maxEv;
   end
   V_A_C = V(A,C);
   I_C = I(C1,C);
   I_A = I(A1,A);

//      VAC
   VAC = V_A_C;
   if((VAC_cnt>0) || ( maxEv_flg==0 ))   begin
      if( (VAC < -155) && (VAC_retc!=-1))
      begin
        outfile=$fopen(errFileName,"a");
        $strobe("dfwpsj2b_10   VAC     leaving   OCA (  .. -155.000 V ) at %7.4r  %M", $abstime );
        $fwrite(outfile,"dfwpsj2b_10   VAC     leaving   OCA (  .. -155.000 V ) at %7.4r  %M\n", $abstime );
        VAC_retc=-1;
        VAC_cnt=VAC_cnt-1;
        $fclose(outfile);
      end
      if((VAC >= -155) &&  (VAC <= 1.5) && (VAC_retc!=0))
      begin
        outfile=$fopen(errFileName,"a");
        $strobe("dfwpsj2b_10   VAC     entering SOCA ( -155.000 V .. 1.500 V ) at %7.4r  %M", $abstime );
        $fwrite(outfile,"dfwpsj2b_10   VAC     entering SOCA ( -155.000 V .. 1.500 V ) at %7.4r  %M\n", $abstime );
        VAC_retc=0;
        VAC_cnt=VAC_cnt-1;
        $fclose(outfile);
      end
      if((VAC > 1.5) &&  (VAC_retc!=1))
      begin
        outfile=$fopen(errFileName,"a");
        $strobe("dfwpsj2b_10   VAC     leaving   OCA ( 1.500 V ..  ) at %7.4r  %M", $abstime );
        $fwrite(outfile,"dfwpsj2b_10   VAC     leaving   OCA ( 1.500 V ..  ) at %7.4r  %M\n", $abstime );
        VAC_retc=1;
        VAC_cnt=VAC_cnt-1;
        $fclose(outfile);
      end
   end
   else
   begin
      if(VAC_cnt==0)
      begin
        outfile=$fopen(errFileName,"a");
        $strobe("dfwpsj2b_10   VAC     error limit ( %d ) reached at %7.4r  %M", maxEv, $abstime );
        $fwrite(outfile,"dfwpsj2b_10   VAC     error limit ( %d ) reached at %7.4r  %M\n", maxEv, $abstime );
        VAC_cnt=VAC_cnt-1;
        $fclose(outfile);
      end
   end

//      IA
   IA = I_A / area / 1e-05;
   if((IA_cnt>0) || ( maxEv_flg==0 ))   begin
      if( (IA < -60) && (IA_retc!=-1))
      begin
        outfile=$fopen(errFileName,"a");
        $strobe("dfwpsj2b_10   IA      leaving   OCA (  .. -0.060 mA/um ) at %7.4r  %M", $abstime );
        $fwrite(outfile,"dfwpsj2b_10   IA      leaving   OCA (  .. -0.060 mA/um ) at %7.4r  %M\n", $abstime );
        IA_retc=-1;
        IA_cnt=IA_cnt-1;
        $fclose(outfile);
      end
      if((IA >= -60) &&  (IA <= 60) && (IA_retc!=0))
      begin
        outfile=$fopen(errFileName,"a");
        $strobe("dfwpsj2b_10   IA      entering SOCA ( -0.060 mA/um .. 0.060 mA/um ) at %7.4r  %M", $abstime );
        $fwrite(outfile,"dfwpsj2b_10   IA      entering SOCA ( -0.060 mA/um .. 0.060 mA/um ) at %7.4r  %M\n", $abstime );
        IA_retc=0;
        IA_cnt=IA_cnt-1;
        $fclose(outfile);
      end
      if((IA > 60) &&  (IA_retc!=1))
      begin
        outfile=$fopen(errFileName,"a");
        $strobe("dfwpsj2b_10   IA      leaving   OCA ( 0.060 mA/um ..  ) at %7.4r  %M", $abstime );
        $fwrite(outfile,"dfwpsj2b_10   IA      leaving   OCA ( 0.060 mA/um ..  ) at %7.4r  %M\n", $abstime );
        IA_retc=1;
        IA_cnt=IA_cnt-1;
        $fclose(outfile);
      end
   end
   else
   begin
      if(IA_cnt==0)
      begin
        outfile=$fopen(errFileName,"a");
        $strobe("dfwpsj2b_10   IA      error limit ( %d ) reached at %7.4r  %M", maxEv, $abstime );
        $fwrite(outfile,"dfwpsj2b_10   IA      error limit ( %d ) reached at %7.4r  %M\n", maxEv, $abstime );
        IA_cnt=IA_cnt-1;
        $fclose(outfile);
      end
   end

end // analog
endmodule // dfwpsj2b_10

// Verilog-A OC Watch for device dfwnsj1a_13 Parameters  VAC IA
module dfwnsj1a_13_ahdl(A1,C1,A,C);
parameter tstep_occ=100n;
parameter errFileName="./occ.err";
parameter area = 1u;
parameter maxEv = 25;
parameter maxEv_flg = 0;
inout A1,C1,A,C;
electrical A1,C1,A,C;

integer outfile;
real V_A_C;
real I_C;
real I_A;
real VAC;
integer VAC_retc;
integer VAC_cnt;
real IA;
integer IA_retc;
integer IA_cnt;

analog begin
   $bound_step( tstep_occ );
   @(initial_step) begin
      VAC_retc=0;
      VAC_cnt = maxEv;
      IA_retc=0;
      IA_cnt = maxEv;
   end
   V_A_C = V(A,C);
   I_C = I(C1,C);
   I_A = I(A1,A);

//      VAC
   VAC = V_A_C;
   if((VAC_cnt>0) || ( maxEv_flg==0 ))   begin
      if( (VAC < -195) && (VAC_retc!=-1))
      begin
        outfile=$fopen(errFileName,"a");
        $strobe("dfwnsj1a_13   VAC     leaving   OCA (  .. -195.000 V ) at %7.4r  %M", $abstime );
        $fwrite(outfile,"dfwnsj1a_13   VAC     leaving   OCA (  .. -195.000 V ) at %7.4r  %M\n", $abstime );
        VAC_retc=-1;
        VAC_cnt=VAC_cnt-1;
        $fclose(outfile);
      end
      if((VAC >= -195) &&  (VAC <= 1.5) && (VAC_retc!=0))
      begin
        outfile=$fopen(errFileName,"a");
        $strobe("dfwnsj1a_13   VAC     entering SOCA ( -195.000 V .. 1.500 V ) at %7.4r  %M", $abstime );
        $fwrite(outfile,"dfwnsj1a_13   VAC     entering SOCA ( -195.000 V .. 1.500 V ) at %7.4r  %M\n", $abstime );
        VAC_retc=0;
        VAC_cnt=VAC_cnt-1;
        $fclose(outfile);
      end
      if((VAC > 1.5) &&  (VAC_retc!=1))
      begin
        outfile=$fopen(errFileName,"a");
        $strobe("dfwnsj1a_13   VAC     leaving   OCA ( 1.500 V ..  ) at %7.4r  %M", $abstime );
        $fwrite(outfile,"dfwnsj1a_13   VAC     leaving   OCA ( 1.500 V ..  ) at %7.4r  %M\n", $abstime );
        VAC_retc=1;
        VAC_cnt=VAC_cnt-1;
        $fclose(outfile);
      end
   end
   else
   begin
      if(VAC_cnt==0)
      begin
        outfile=$fopen(errFileName,"a");
        $strobe("dfwnsj1a_13   VAC     error limit ( %d ) reached at %7.4r  %M", maxEv, $abstime );
        $fwrite(outfile,"dfwnsj1a_13   VAC     error limit ( %d ) reached at %7.4r  %M\n", maxEv, $abstime );
        VAC_cnt=VAC_cnt-1;
        $fclose(outfile);
      end
   end

//      IA
   IA = I_A / area / 1.3e-05;
   if((IA_cnt>0) || ( maxEv_flg==0 ))   begin
      if( (IA < -60) && (IA_retc!=-1))
      begin
        outfile=$fopen(errFileName,"a");
        $strobe("dfwnsj1a_13   IA      leaving   OCA (  .. -0.060 mA/um ) at %7.4r  %M", $abstime );
        $fwrite(outfile,"dfwnsj1a_13   IA      leaving   OCA (  .. -0.060 mA/um ) at %7.4r  %M\n", $abstime );
        IA_retc=-1;
        IA_cnt=IA_cnt-1;
        $fclose(outfile);
      end
      if((IA >= -60) &&  (IA <= 60) && (IA_retc!=0))
      begin
        outfile=$fopen(errFileName,"a");
        $strobe("dfwnsj1a_13   IA      entering SOCA ( -0.060 mA/um .. 0.060 mA/um ) at %7.4r  %M", $abstime );
        $fwrite(outfile,"dfwnsj1a_13   IA      entering SOCA ( -0.060 mA/um .. 0.060 mA/um ) at %7.4r  %M\n", $abstime );
        IA_retc=0;
        IA_cnt=IA_cnt-1;
        $fclose(outfile);
      end
      if((IA > 60) &&  (IA_retc!=1))
      begin
        outfile=$fopen(errFileName,"a");
        $strobe("dfwnsj1a_13   IA      leaving   OCA ( 0.060 mA/um ..  ) at %7.4r  %M", $abstime );
        $fwrite(outfile,"dfwnsj1a_13   IA      leaving   OCA ( 0.060 mA/um ..  ) at %7.4r  %M\n", $abstime );
        IA_retc=1;
        IA_cnt=IA_cnt-1;
        $fclose(outfile);
      end
   end
   else
   begin
      if(IA_cnt==0)
      begin
        outfile=$fopen(errFileName,"a");
        $strobe("dfwnsj1a_13   IA      error limit ( %d ) reached at %7.4r  %M", maxEv, $abstime );
        $fwrite(outfile,"dfwnsj1a_13   IA      error limit ( %d ) reached at %7.4r  %M\n", maxEv, $abstime );
        IA_cnt=IA_cnt-1;
        $fclose(outfile);
      end
   end

end // analog
endmodule // dfwnsj1a_13

// Verilog-A OC Watch for device dfwpsj1a_13 Parameters  VAC IA
module dfwpsj1a_13_ahdl(A1,C1,A,C);
parameter tstep_occ=100n;
parameter errFileName="./occ.err";
parameter area = 1u;
parameter maxEv = 25;
parameter maxEv_flg = 0;
inout A1,C1,A,C;
electrical A1,C1,A,C;

integer outfile;
real V_A_C;
real I_C;
real I_A;
real VAC;
integer VAC_retc;
integer VAC_cnt;
real IA;
integer IA_retc;
integer IA_cnt;

analog begin
   $bound_step( tstep_occ );
   @(initial_step) begin
      VAC_retc=0;
      VAC_cnt = maxEv;
      IA_retc=0;
      IA_cnt = maxEv;
   end
   V_A_C = V(A,C);
   I_C = I(C1,C);
   I_A = I(A1,A);

//      VAC
   VAC = V_A_C;
   if((VAC_cnt>0) || ( maxEv_flg==0 ))   begin
      if( (VAC < -195) && (VAC_retc!=-1))
      begin
        outfile=$fopen(errFileName,"a");
        $strobe("dfwpsj1a_13   VAC     leaving   OCA (  .. -195.000 V ) at %7.4r  %M", $abstime );
        $fwrite(outfile,"dfwpsj1a_13   VAC     leaving   OCA (  .. -195.000 V ) at %7.4r  %M\n", $abstime );
        VAC_retc=-1;
        VAC_cnt=VAC_cnt-1;
        $fclose(outfile);
      end
      if((VAC >= -195) &&  (VAC <= 1.5) && (VAC_retc!=0))
      begin
        outfile=$fopen(errFileName,"a");
        $strobe("dfwpsj1a_13   VAC     entering SOCA ( -195.000 V .. 1.500 V ) at %7.4r  %M", $abstime );
        $fwrite(outfile,"dfwpsj1a_13   VAC     entering SOCA ( -195.000 V .. 1.500 V ) at %7.4r  %M\n", $abstime );
        VAC_retc=0;
        VAC_cnt=VAC_cnt-1;
        $fclose(outfile);
      end
      if((VAC > 1.5) &&  (VAC_retc!=1))
      begin
        outfile=$fopen(errFileName,"a");
        $strobe("dfwpsj1a_13   VAC     leaving   OCA ( 1.500 V ..  ) at %7.4r  %M", $abstime );
        $fwrite(outfile,"dfwpsj1a_13   VAC     leaving   OCA ( 1.500 V ..  ) at %7.4r  %M\n", $abstime );
        VAC_retc=1;
        VAC_cnt=VAC_cnt-1;
        $fclose(outfile);
      end
   end
   else
   begin
      if(VAC_cnt==0)
      begin
        outfile=$fopen(errFileName,"a");
        $strobe("dfwpsj1a_13   VAC     error limit ( %d ) reached at %7.4r  %M", maxEv, $abstime );
        $fwrite(outfile,"dfwpsj1a_13   VAC     error limit ( %d ) reached at %7.4r  %M\n", maxEv, $abstime );
        VAC_cnt=VAC_cnt-1;
        $fclose(outfile);
      end
   end

//      IA
   IA = I_A / area / 1.3e-05;
   if((IA_cnt>0) || ( maxEv_flg==0 ))   begin
      if( (IA < -60) && (IA_retc!=-1))
      begin
        outfile=$fopen(errFileName,"a");
        $strobe("dfwpsj1a_13   IA      leaving   OCA (  .. -0.060 mA/um ) at %7.4r  %M", $abstime );
        $fwrite(outfile,"dfwpsj1a_13   IA      leaving   OCA (  .. -0.060 mA/um ) at %7.4r  %M\n", $abstime );
        IA_retc=-1;
        IA_cnt=IA_cnt-1;
        $fclose(outfile);
      end
      if((IA >= -60) &&  (IA <= 60) && (IA_retc!=0))
      begin
        outfile=$fopen(errFileName,"a");
        $strobe("dfwpsj1a_13   IA      entering SOCA ( -0.060 mA/um .. 0.060 mA/um ) at %7.4r  %M", $abstime );
        $fwrite(outfile,"dfwpsj1a_13   IA      entering SOCA ( -0.060 mA/um .. 0.060 mA/um ) at %7.4r  %M\n", $abstime );
        IA_retc=0;
        IA_cnt=IA_cnt-1;
        $fclose(outfile);
      end
      if((IA > 60) &&  (IA_retc!=1))
      begin
        outfile=$fopen(errFileName,"a");
        $strobe("dfwpsj1a_13   IA      leaving   OCA ( 0.060 mA/um ..  ) at %7.4r  %M", $abstime );
        $fwrite(outfile,"dfwpsj1a_13   IA      leaving   OCA ( 0.060 mA/um ..  ) at %7.4r  %M\n", $abstime );
        IA_retc=1;
        IA_cnt=IA_cnt-1;
        $fclose(outfile);
      end
   end
   else
   begin
      if(IA_cnt==0)
      begin
        outfile=$fopen(errFileName,"a");
        $strobe("dfwpsj1a_13   IA      error limit ( %d ) reached at %7.4r  %M", maxEv, $abstime );
        $fwrite(outfile,"dfwpsj1a_13   IA      error limit ( %d ) reached at %7.4r  %M\n", maxEv, $abstime );
        IA_cnt=IA_cnt-1;
        $fclose(outfile);
      end
   end

end // analog
endmodule // dfwpsj1a_13

// Verilog-A OC Watch for device dfwpsj2b_13 Parameters  VAC IA
module dfwpsj2b_13_ahdl(A1,C1,A,C);
parameter tstep_occ=100n;
parameter errFileName="./occ.err";
parameter area = 1u;
parameter maxEv = 25;
parameter maxEv_flg = 0;
inout A1,C1,A,C;
electrical A1,C1,A,C;

integer outfile;
real V_A_C;
real I_C;
real I_A;
real VAC;
integer VAC_retc;
integer VAC_cnt;
real IA;
integer IA_retc;
integer IA_cnt;

analog begin
   $bound_step( tstep_occ );
   @(initial_step) begin
      VAC_retc=0;
      VAC_cnt = maxEv;
      IA_retc=0;
      IA_cnt = maxEv;
   end
   V_A_C = V(A,C);
   I_C = I(C1,C);
   I_A = I(A1,A);

//      VAC
   VAC = V_A_C;
   if((VAC_cnt>0) || ( maxEv_flg==0 ))   begin
      if( (VAC < -195) && (VAC_retc!=-1))
      begin
        outfile=$fopen(errFileName,"a");
        $strobe("dfwpsj2b_13   VAC     leaving   OCA (  .. -195.000 V ) at %7.4r  %M", $abstime );
        $fwrite(outfile,"dfwpsj2b_13   VAC     leaving   OCA (  .. -195.000 V ) at %7.4r  %M\n", $abstime );
        VAC_retc=-1;
        VAC_cnt=VAC_cnt-1;
        $fclose(outfile);
      end
      if((VAC >= -195) &&  (VAC <= 1.5) && (VAC_retc!=0))
      begin
        outfile=$fopen(errFileName,"a");
        $strobe("dfwpsj2b_13   VAC     entering SOCA ( -195.000 V .. 1.500 V ) at %7.4r  %M", $abstime );
        $fwrite(outfile,"dfwpsj2b_13   VAC     entering SOCA ( -195.000 V .. 1.500 V ) at %7.4r  %M\n", $abstime );
        VAC_retc=0;
        VAC_cnt=VAC_cnt-1;
        $fclose(outfile);
      end
      if((VAC > 1.5) &&  (VAC_retc!=1))
      begin
        outfile=$fopen(errFileName,"a");
        $strobe("dfwpsj2b_13   VAC     leaving   OCA ( 1.500 V ..  ) at %7.4r  %M", $abstime );
        $fwrite(outfile,"dfwpsj2b_13   VAC     leaving   OCA ( 1.500 V ..  ) at %7.4r  %M\n", $abstime );
        VAC_retc=1;
        VAC_cnt=VAC_cnt-1;
        $fclose(outfile);
      end
   end
   else
   begin
      if(VAC_cnt==0)
      begin
        outfile=$fopen(errFileName,"a");
        $strobe("dfwpsj2b_13   VAC     error limit ( %d ) reached at %7.4r  %M", maxEv, $abstime );
        $fwrite(outfile,"dfwpsj2b_13   VAC     error limit ( %d ) reached at %7.4r  %M\n", maxEv, $abstime );
        VAC_cnt=VAC_cnt-1;
        $fclose(outfile);
      end
   end

//      IA
   IA = I_A / area / 1.3e-05;
   if((IA_cnt>0) || ( maxEv_flg==0 ))   begin
      if( (IA < -60) && (IA_retc!=-1))
      begin
        outfile=$fopen(errFileName,"a");
        $strobe("dfwpsj2b_13   IA      leaving   OCA (  .. -0.060 mA/um ) at %7.4r  %M", $abstime );
        $fwrite(outfile,"dfwpsj2b_13   IA      leaving   OCA (  .. -0.060 mA/um ) at %7.4r  %M\n", $abstime );
        IA_retc=-1;
        IA_cnt=IA_cnt-1;
        $fclose(outfile);
      end
      if((IA >= -60) &&  (IA <= 60) && (IA_retc!=0))
      begin
        outfile=$fopen(errFileName,"a");
        $strobe("dfwpsj2b_13   IA      entering SOCA ( -0.060 mA/um .. 0.060 mA/um ) at %7.4r  %M", $abstime );
        $fwrite(outfile,"dfwpsj2b_13   IA      entering SOCA ( -0.060 mA/um .. 0.060 mA/um ) at %7.4r  %M\n", $abstime );
        IA_retc=0;
        IA_cnt=IA_cnt-1;
        $fclose(outfile);
      end
      if((IA > 60) &&  (IA_retc!=1))
      begin
        outfile=$fopen(errFileName,"a");
        $strobe("dfwpsj2b_13   IA      leaving   OCA ( 0.060 mA/um ..  ) at %7.4r  %M", $abstime );
        $fwrite(outfile,"dfwpsj2b_13   IA      leaving   OCA ( 0.060 mA/um ..  ) at %7.4r  %M\n", $abstime );
        IA_retc=1;
        IA_cnt=IA_cnt-1;
        $fclose(outfile);
      end
   end
   else
   begin
      if(IA_cnt==0)
      begin
        outfile=$fopen(errFileName,"a");
        $strobe("dfwpsj2b_13   IA      error limit ( %d ) reached at %7.4r  %M", maxEv, $abstime );
        $fwrite(outfile,"dfwpsj2b_13   IA      error limit ( %d ) reached at %7.4r  %M\n", maxEv, $abstime );
        IA_cnt=IA_cnt-1;
        $fclose(outfile);
      end
   end

end // analog
endmodule // dfwpsj2b_13

// Verilog-A OC Watch for device dfwnsj1a_16 Parameters  VAC IA
module dfwnsj1a_16_ahdl(A1,C1,A,C);
parameter tstep_occ=100n;
parameter errFileName="./occ.err";
parameter area = 1u;
parameter maxEv = 25;
parameter maxEv_flg = 0;
inout A1,C1,A,C;
electrical A1,C1,A,C;

integer outfile;
real V_A_C;
real I_C;
real I_A;
real VAC;
integer VAC_retc;
integer VAC_cnt;
real IA;
integer IA_retc;
integer IA_cnt;

analog begin
   $bound_step( tstep_occ );
   @(initial_step) begin
      VAC_retc=0;
      VAC_cnt = maxEv;
      IA_retc=0;
      IA_cnt = maxEv;
   end
   V_A_C = V(A,C);
   I_C = I(C1,C);
   I_A = I(A1,A);

//      VAC
   VAC = V_A_C;
   if((VAC_cnt>0) || ( maxEv_flg==0 ))   begin
      if( (VAC < -235) && (VAC_retc!=-1))
      begin
        outfile=$fopen(errFileName,"a");
        $strobe("dfwnsj1a_16   VAC     leaving   OCA (  .. -235.000 V ) at %7.4r  %M", $abstime );
        $fwrite(outfile,"dfwnsj1a_16   VAC     leaving   OCA (  .. -235.000 V ) at %7.4r  %M\n", $abstime );
        VAC_retc=-1;
        VAC_cnt=VAC_cnt-1;
        $fclose(outfile);
      end
      if((VAC >= -235) &&  (VAC <= 1.5) && (VAC_retc!=0))
      begin
        outfile=$fopen(errFileName,"a");
        $strobe("dfwnsj1a_16   VAC     entering SOCA ( -235.000 V .. 1.500 V ) at %7.4r  %M", $abstime );
        $fwrite(outfile,"dfwnsj1a_16   VAC     entering SOCA ( -235.000 V .. 1.500 V ) at %7.4r  %M\n", $abstime );
        VAC_retc=0;
        VAC_cnt=VAC_cnt-1;
        $fclose(outfile);
      end
      if((VAC > 1.5) &&  (VAC_retc!=1))
      begin
        outfile=$fopen(errFileName,"a");
        $strobe("dfwnsj1a_16   VAC     leaving   OCA ( 1.500 V ..  ) at %7.4r  %M", $abstime );
        $fwrite(outfile,"dfwnsj1a_16   VAC     leaving   OCA ( 1.500 V ..  ) at %7.4r  %M\n", $abstime );
        VAC_retc=1;
        VAC_cnt=VAC_cnt-1;
        $fclose(outfile);
      end
   end
   else
   begin
      if(VAC_cnt==0)
      begin
        outfile=$fopen(errFileName,"a");
        $strobe("dfwnsj1a_16   VAC     error limit ( %d ) reached at %7.4r  %M", maxEv, $abstime );
        $fwrite(outfile,"dfwnsj1a_16   VAC     error limit ( %d ) reached at %7.4r  %M\n", maxEv, $abstime );
        VAC_cnt=VAC_cnt-1;
        $fclose(outfile);
      end
   end

//      IA
   IA = I_A / area / 1.6e-05;
   if((IA_cnt>0) || ( maxEv_flg==0 ))   begin
      if( (IA < -60) && (IA_retc!=-1))
      begin
        outfile=$fopen(errFileName,"a");
        $strobe("dfwnsj1a_16   IA      leaving   OCA (  .. -0.060 mA/um ) at %7.4r  %M", $abstime );
        $fwrite(outfile,"dfwnsj1a_16   IA      leaving   OCA (  .. -0.060 mA/um ) at %7.4r  %M\n", $abstime );
        IA_retc=-1;
        IA_cnt=IA_cnt-1;
        $fclose(outfile);
      end
      if((IA >= -60) &&  (IA <= 60) && (IA_retc!=0))
      begin
        outfile=$fopen(errFileName,"a");
        $strobe("dfwnsj1a_16   IA      entering SOCA ( -0.060 mA/um .. 0.060 mA/um ) at %7.4r  %M", $abstime );
        $fwrite(outfile,"dfwnsj1a_16   IA      entering SOCA ( -0.060 mA/um .. 0.060 mA/um ) at %7.4r  %M\n", $abstime );
        IA_retc=0;
        IA_cnt=IA_cnt-1;
        $fclose(outfile);
      end
      if((IA > 60) &&  (IA_retc!=1))
      begin
        outfile=$fopen(errFileName,"a");
        $strobe("dfwnsj1a_16   IA      leaving   OCA ( 0.060 mA/um ..  ) at %7.4r  %M", $abstime );
        $fwrite(outfile,"dfwnsj1a_16   IA      leaving   OCA ( 0.060 mA/um ..  ) at %7.4r  %M\n", $abstime );
        IA_retc=1;
        IA_cnt=IA_cnt-1;
        $fclose(outfile);
      end
   end
   else
   begin
      if(IA_cnt==0)
      begin
        outfile=$fopen(errFileName,"a");
        $strobe("dfwnsj1a_16   IA      error limit ( %d ) reached at %7.4r  %M", maxEv, $abstime );
        $fwrite(outfile,"dfwnsj1a_16   IA      error limit ( %d ) reached at %7.4r  %M\n", maxEv, $abstime );
        IA_cnt=IA_cnt-1;
        $fclose(outfile);
      end
   end

end // analog
endmodule // dfwnsj1a_16

// Verilog-A OC Watch for device dfwpsj1a_16 Parameters  VAC IA
module dfwpsj1a_16_ahdl(A1,C1,A,C);
parameter tstep_occ=100n;
parameter errFileName="./occ.err";
parameter area = 1u;
parameter maxEv = 25;
parameter maxEv_flg = 0;
inout A1,C1,A,C;
electrical A1,C1,A,C;

integer outfile;
real V_A_C;
real I_C;
real I_A;
real VAC;
integer VAC_retc;
integer VAC_cnt;
real IA;
integer IA_retc;
integer IA_cnt;

analog begin
   $bound_step( tstep_occ );
   @(initial_step) begin
      VAC_retc=0;
      VAC_cnt = maxEv;
      IA_retc=0;
      IA_cnt = maxEv;
   end
   V_A_C = V(A,C);
   I_C = I(C1,C);
   I_A = I(A1,A);

//      VAC
   VAC = V_A_C;
   if((VAC_cnt>0) || ( maxEv_flg==0 ))   begin
      if( (VAC < -235) && (VAC_retc!=-1))
      begin
        outfile=$fopen(errFileName,"a");
        $strobe("dfwpsj1a_16   VAC     leaving   OCA (  .. -235.000 V ) at %7.4r  %M", $abstime );
        $fwrite(outfile,"dfwpsj1a_16   VAC     leaving   OCA (  .. -235.000 V ) at %7.4r  %M\n", $abstime );
        VAC_retc=-1;
        VAC_cnt=VAC_cnt-1;
        $fclose(outfile);
      end
      if((VAC >= -235) &&  (VAC <= 1.5) && (VAC_retc!=0))
      begin
        outfile=$fopen(errFileName,"a");
        $strobe("dfwpsj1a_16   VAC     entering SOCA ( -235.000 V .. 1.500 V ) at %7.4r  %M", $abstime );
        $fwrite(outfile,"dfwpsj1a_16   VAC     entering SOCA ( -235.000 V .. 1.500 V ) at %7.4r  %M\n", $abstime );
        VAC_retc=0;
        VAC_cnt=VAC_cnt-1;
        $fclose(outfile);
      end
      if((VAC > 1.5) &&  (VAC_retc!=1))
      begin
        outfile=$fopen(errFileName,"a");
        $strobe("dfwpsj1a_16   VAC     leaving   OCA ( 1.500 V ..  ) at %7.4r  %M", $abstime );
        $fwrite(outfile,"dfwpsj1a_16   VAC     leaving   OCA ( 1.500 V ..  ) at %7.4r  %M\n", $abstime );
        VAC_retc=1;
        VAC_cnt=VAC_cnt-1;
        $fclose(outfile);
      end
   end
   else
   begin
      if(VAC_cnt==0)
      begin
        outfile=$fopen(errFileName,"a");
        $strobe("dfwpsj1a_16   VAC     error limit ( %d ) reached at %7.4r  %M", maxEv, $abstime );
        $fwrite(outfile,"dfwpsj1a_16   VAC     error limit ( %d ) reached at %7.4r  %M\n", maxEv, $abstime );
        VAC_cnt=VAC_cnt-1;
        $fclose(outfile);
      end
   end

//      IA
   IA = I_A / area / 1.6e-05;
   if((IA_cnt>0) || ( maxEv_flg==0 ))   begin
      if( (IA < -60) && (IA_retc!=-1))
      begin
        outfile=$fopen(errFileName,"a");
        $strobe("dfwpsj1a_16   IA      leaving   OCA (  .. -0.060 mA/um ) at %7.4r  %M", $abstime );
        $fwrite(outfile,"dfwpsj1a_16   IA      leaving   OCA (  .. -0.060 mA/um ) at %7.4r  %M\n", $abstime );
        IA_retc=-1;
        IA_cnt=IA_cnt-1;
        $fclose(outfile);
      end
      if((IA >= -60) &&  (IA <= 60) && (IA_retc!=0))
      begin
        outfile=$fopen(errFileName,"a");
        $strobe("dfwpsj1a_16   IA      entering SOCA ( -0.060 mA/um .. 0.060 mA/um ) at %7.4r  %M", $abstime );
        $fwrite(outfile,"dfwpsj1a_16   IA      entering SOCA ( -0.060 mA/um .. 0.060 mA/um ) at %7.4r  %M\n", $abstime );
        IA_retc=0;
        IA_cnt=IA_cnt-1;
        $fclose(outfile);
      end
      if((IA > 60) &&  (IA_retc!=1))
      begin
        outfile=$fopen(errFileName,"a");
        $strobe("dfwpsj1a_16   IA      leaving   OCA ( 0.060 mA/um ..  ) at %7.4r  %M", $abstime );
        $fwrite(outfile,"dfwpsj1a_16   IA      leaving   OCA ( 0.060 mA/um ..  ) at %7.4r  %M\n", $abstime );
        IA_retc=1;
        IA_cnt=IA_cnt-1;
        $fclose(outfile);
      end
   end
   else
   begin
      if(IA_cnt==0)
      begin
        outfile=$fopen(errFileName,"a");
        $strobe("dfwpsj1a_16   IA      error limit ( %d ) reached at %7.4r  %M", maxEv, $abstime );
        $fwrite(outfile,"dfwpsj1a_16   IA      error limit ( %d ) reached at %7.4r  %M\n", maxEv, $abstime );
        IA_cnt=IA_cnt-1;
        $fclose(outfile);
      end
   end

end // analog
endmodule // dfwpsj1a_16

// Verilog-A OC Watch for device dfwpsj2b_16 Parameters  VAC IA
module dfwpsj2b_16_ahdl(A1,C1,A,C);
parameter tstep_occ=100n;
parameter errFileName="./occ.err";
parameter area = 1u;
parameter maxEv = 25;
parameter maxEv_flg = 0;
inout A1,C1,A,C;
electrical A1,C1,A,C;

integer outfile;
real V_A_C;
real I_C;
real I_A;
real VAC;
integer VAC_retc;
integer VAC_cnt;
real IA;
integer IA_retc;
integer IA_cnt;

analog begin
   $bound_step( tstep_occ );
   @(initial_step) begin
      VAC_retc=0;
      VAC_cnt = maxEv;
      IA_retc=0;
      IA_cnt = maxEv;
   end
   V_A_C = V(A,C);
   I_C = I(C1,C);
   I_A = I(A1,A);

//      VAC
   VAC = V_A_C;
   if((VAC_cnt>0) || ( maxEv_flg==0 ))   begin
      if( (VAC < -235) && (VAC_retc!=-1))
      begin
        outfile=$fopen(errFileName,"a");
        $strobe("dfwpsj2b_16   VAC     leaving   OCA (  .. -235.000 V ) at %7.4r  %M", $abstime );
        $fwrite(outfile,"dfwpsj2b_16   VAC     leaving   OCA (  .. -235.000 V ) at %7.4r  %M\n", $abstime );
        VAC_retc=-1;
        VAC_cnt=VAC_cnt-1;
        $fclose(outfile);
      end
      if((VAC >= -235) &&  (VAC <= 1.5) && (VAC_retc!=0))
      begin
        outfile=$fopen(errFileName,"a");
        $strobe("dfwpsj2b_16   VAC     entering SOCA ( -235.000 V .. 1.500 V ) at %7.4r  %M", $abstime );
        $fwrite(outfile,"dfwpsj2b_16   VAC     entering SOCA ( -235.000 V .. 1.500 V ) at %7.4r  %M\n", $abstime );
        VAC_retc=0;
        VAC_cnt=VAC_cnt-1;
        $fclose(outfile);
      end
      if((VAC > 1.5) &&  (VAC_retc!=1))
      begin
        outfile=$fopen(errFileName,"a");
        $strobe("dfwpsj2b_16   VAC     leaving   OCA ( 1.500 V ..  ) at %7.4r  %M", $abstime );
        $fwrite(outfile,"dfwpsj2b_16   VAC     leaving   OCA ( 1.500 V ..  ) at %7.4r  %M\n", $abstime );
        VAC_retc=1;
        VAC_cnt=VAC_cnt-1;
        $fclose(outfile);
      end
   end
   else
   begin
      if(VAC_cnt==0)
      begin
        outfile=$fopen(errFileName,"a");
        $strobe("dfwpsj2b_16   VAC     error limit ( %d ) reached at %7.4r  %M", maxEv, $abstime );
        $fwrite(outfile,"dfwpsj2b_16   VAC     error limit ( %d ) reached at %7.4r  %M\n", maxEv, $abstime );
        VAC_cnt=VAC_cnt-1;
        $fclose(outfile);
      end
   end

//      IA
   IA = I_A / area / 1.6e-05;
   if((IA_cnt>0) || ( maxEv_flg==0 ))   begin
      if( (IA < -60) && (IA_retc!=-1))
      begin
        outfile=$fopen(errFileName,"a");
        $strobe("dfwpsj2b_16   IA      leaving   OCA (  .. -0.060 mA/um ) at %7.4r  %M", $abstime );
        $fwrite(outfile,"dfwpsj2b_16   IA      leaving   OCA (  .. -0.060 mA/um ) at %7.4r  %M\n", $abstime );
        IA_retc=-1;
        IA_cnt=IA_cnt-1;
        $fclose(outfile);
      end
      if((IA >= -60) &&  (IA <= 60) && (IA_retc!=0))
      begin
        outfile=$fopen(errFileName,"a");
        $strobe("dfwpsj2b_16   IA      entering SOCA ( -0.060 mA/um .. 0.060 mA/um ) at %7.4r  %M", $abstime );
        $fwrite(outfile,"dfwpsj2b_16   IA      entering SOCA ( -0.060 mA/um .. 0.060 mA/um ) at %7.4r  %M\n", $abstime );
        IA_retc=0;
        IA_cnt=IA_cnt-1;
        $fclose(outfile);
      end
      if((IA > 60) &&  (IA_retc!=1))
      begin
        outfile=$fopen(errFileName,"a");
        $strobe("dfwpsj2b_16   IA      leaving   OCA ( 0.060 mA/um ..  ) at %7.4r  %M", $abstime );
        $fwrite(outfile,"dfwpsj2b_16   IA      leaving   OCA ( 0.060 mA/um ..  ) at %7.4r  %M\n", $abstime );
        IA_retc=1;
        IA_cnt=IA_cnt-1;
        $fclose(outfile);
      end
   end
   else
   begin
      if(IA_cnt==0)
      begin
        outfile=$fopen(errFileName,"a");
        $strobe("dfwpsj2b_16   IA      error limit ( %d ) reached at %7.4r  %M", maxEv, $abstime );
        $fwrite(outfile,"dfwpsj2b_16   IA      error limit ( %d ) reached at %7.4r  %M\n", maxEv, $abstime );
        IA_cnt=IA_cnt-1;
        $fclose(outfile);
      end
   end

end // analog
endmodule // dfwpsj2b_16

// Verilog-A OC Watch for device dfwnsj1a_20 Parameters  VAC IA
module dfwnsj1a_20_ahdl(A1,C1,A,C);
parameter tstep_occ=100n;
parameter errFileName="./occ.err";
parameter area = 1u;
parameter maxEv = 25;
parameter maxEv_flg = 0;
inout A1,C1,A,C;
electrical A1,C1,A,C;

integer outfile;
real V_A_C;
real I_C;
real I_A;
real VAC;
integer VAC_retc;
integer VAC_cnt;
real IA;
integer IA_retc;
integer IA_cnt;

analog begin
   $bound_step( tstep_occ );
   @(initial_step) begin
      VAC_retc=0;
      VAC_cnt = maxEv;
      IA_retc=0;
      IA_cnt = maxEv;
   end
   V_A_C = V(A,C);
   I_C = I(C1,C);
   I_A = I(A1,A);

//      VAC
   VAC = V_A_C;
   if((VAC_cnt>0) || ( maxEv_flg==0 ))   begin
      if( (VAC < -290) && (VAC_retc!=-1))
      begin
        outfile=$fopen(errFileName,"a");
        $strobe("dfwnsj1a_20   VAC     leaving   OCA (  .. -290.000 V ) at %7.4r  %M", $abstime );
        $fwrite(outfile,"dfwnsj1a_20   VAC     leaving   OCA (  .. -290.000 V ) at %7.4r  %M\n", $abstime );
        VAC_retc=-1;
        VAC_cnt=VAC_cnt-1;
        $fclose(outfile);
      end
      if((VAC >= -290) &&  (VAC <= 1.5) && (VAC_retc!=0))
      begin
        outfile=$fopen(errFileName,"a");
        $strobe("dfwnsj1a_20   VAC     entering SOCA ( -290.000 V .. 1.500 V ) at %7.4r  %M", $abstime );
        $fwrite(outfile,"dfwnsj1a_20   VAC     entering SOCA ( -290.000 V .. 1.500 V ) at %7.4r  %M\n", $abstime );
        VAC_retc=0;
        VAC_cnt=VAC_cnt-1;
        $fclose(outfile);
      end
      if((VAC > 1.5) &&  (VAC_retc!=1))
      begin
        outfile=$fopen(errFileName,"a");
        $strobe("dfwnsj1a_20   VAC     leaving   OCA ( 1.500 V ..  ) at %7.4r  %M", $abstime );
        $fwrite(outfile,"dfwnsj1a_20   VAC     leaving   OCA ( 1.500 V ..  ) at %7.4r  %M\n", $abstime );
        VAC_retc=1;
        VAC_cnt=VAC_cnt-1;
        $fclose(outfile);
      end
   end
   else
   begin
      if(VAC_cnt==0)
      begin
        outfile=$fopen(errFileName,"a");
        $strobe("dfwnsj1a_20   VAC     error limit ( %d ) reached at %7.4r  %M", maxEv, $abstime );
        $fwrite(outfile,"dfwnsj1a_20   VAC     error limit ( %d ) reached at %7.4r  %M\n", maxEv, $abstime );
        VAC_cnt=VAC_cnt-1;
        $fclose(outfile);
      end
   end

//      IA
   IA = I_A / area / 2e-05;
   if((IA_cnt>0) || ( maxEv_flg==0 ))   begin
      if( (IA < -60) && (IA_retc!=-1))
      begin
        outfile=$fopen(errFileName,"a");
        $strobe("dfwnsj1a_20   IA      leaving   OCA (  .. -0.060 mA/um ) at %7.4r  %M", $abstime );
        $fwrite(outfile,"dfwnsj1a_20   IA      leaving   OCA (  .. -0.060 mA/um ) at %7.4r  %M\n", $abstime );
        IA_retc=-1;
        IA_cnt=IA_cnt-1;
        $fclose(outfile);
      end
      if((IA >= -60) &&  (IA <= 60) && (IA_retc!=0))
      begin
        outfile=$fopen(errFileName,"a");
        $strobe("dfwnsj1a_20   IA      entering SOCA ( -0.060 mA/um .. 0.060 mA/um ) at %7.4r  %M", $abstime );
        $fwrite(outfile,"dfwnsj1a_20   IA      entering SOCA ( -0.060 mA/um .. 0.060 mA/um ) at %7.4r  %M\n", $abstime );
        IA_retc=0;
        IA_cnt=IA_cnt-1;
        $fclose(outfile);
      end
      if((IA > 60) &&  (IA_retc!=1))
      begin
        outfile=$fopen(errFileName,"a");
        $strobe("dfwnsj1a_20   IA      leaving   OCA ( 0.060 mA/um ..  ) at %7.4r  %M", $abstime );
        $fwrite(outfile,"dfwnsj1a_20   IA      leaving   OCA ( 0.060 mA/um ..  ) at %7.4r  %M\n", $abstime );
        IA_retc=1;
        IA_cnt=IA_cnt-1;
        $fclose(outfile);
      end
   end
   else
   begin
      if(IA_cnt==0)
      begin
        outfile=$fopen(errFileName,"a");
        $strobe("dfwnsj1a_20   IA      error limit ( %d ) reached at %7.4r  %M", maxEv, $abstime );
        $fwrite(outfile,"dfwnsj1a_20   IA      error limit ( %d ) reached at %7.4r  %M\n", maxEv, $abstime );
        IA_cnt=IA_cnt-1;
        $fclose(outfile);
      end
   end

end // analog
endmodule // dfwnsj1a_20

// Verilog-A OC Watch for device dfwpsj1a_20 Parameters  VAC IA
module dfwpsj1a_20_ahdl(A1,C1,A,C);
parameter tstep_occ=100n;
parameter errFileName="./occ.err";
parameter area = 1u;
parameter maxEv = 25;
parameter maxEv_flg = 0;
inout A1,C1,A,C;
electrical A1,C1,A,C;

integer outfile;
real V_A_C;
real I_C;
real I_A;
real VAC;
integer VAC_retc;
integer VAC_cnt;
real IA;
integer IA_retc;
integer IA_cnt;

analog begin
   $bound_step( tstep_occ );
   @(initial_step) begin
      VAC_retc=0;
      VAC_cnt = maxEv;
      IA_retc=0;
      IA_cnt = maxEv;
   end
   V_A_C = V(A,C);
   I_C = I(C1,C);
   I_A = I(A1,A);

//      VAC
   VAC = V_A_C;
   if((VAC_cnt>0) || ( maxEv_flg==0 ))   begin
      if( (VAC < -290) && (VAC_retc!=-1))
      begin
        outfile=$fopen(errFileName,"a");
        $strobe("dfwpsj1a_20   VAC     leaving   OCA (  .. -290.000 V ) at %7.4r  %M", $abstime );
        $fwrite(outfile,"dfwpsj1a_20   VAC     leaving   OCA (  .. -290.000 V ) at %7.4r  %M\n", $abstime );
        VAC_retc=-1;
        VAC_cnt=VAC_cnt-1;
        $fclose(outfile);
      end
      if((VAC >= -290) &&  (VAC <= 1.5) && (VAC_retc!=0))
      begin
        outfile=$fopen(errFileName,"a");
        $strobe("dfwpsj1a_20   VAC     entering SOCA ( -290.000 V .. 1.500 V ) at %7.4r  %M", $abstime );
        $fwrite(outfile,"dfwpsj1a_20   VAC     entering SOCA ( -290.000 V .. 1.500 V ) at %7.4r  %M\n", $abstime );
        VAC_retc=0;
        VAC_cnt=VAC_cnt-1;
        $fclose(outfile);
      end
      if((VAC > 1.5) &&  (VAC_retc!=1))
      begin
        outfile=$fopen(errFileName,"a");
        $strobe("dfwpsj1a_20   VAC     leaving   OCA ( 1.500 V ..  ) at %7.4r  %M", $abstime );
        $fwrite(outfile,"dfwpsj1a_20   VAC     leaving   OCA ( 1.500 V ..  ) at %7.4r  %M\n", $abstime );
        VAC_retc=1;
        VAC_cnt=VAC_cnt-1;
        $fclose(outfile);
      end
   end
   else
   begin
      if(VAC_cnt==0)
      begin
        outfile=$fopen(errFileName,"a");
        $strobe("dfwpsj1a_20   VAC     error limit ( %d ) reached at %7.4r  %M", maxEv, $abstime );
        $fwrite(outfile,"dfwpsj1a_20   VAC     error limit ( %d ) reached at %7.4r  %M\n", maxEv, $abstime );
        VAC_cnt=VAC_cnt-1;
        $fclose(outfile);
      end
   end

//      IA
   IA = I_A / area / 2e-05;
   if((IA_cnt>0) || ( maxEv_flg==0 ))   begin
      if( (IA < -60) && (IA_retc!=-1))
      begin
        outfile=$fopen(errFileName,"a");
        $strobe("dfwpsj1a_20   IA      leaving   OCA (  .. -0.060 mA/um ) at %7.4r  %M", $abstime );
        $fwrite(outfile,"dfwpsj1a_20   IA      leaving   OCA (  .. -0.060 mA/um ) at %7.4r  %M\n", $abstime );
        IA_retc=-1;
        IA_cnt=IA_cnt-1;
        $fclose(outfile);
      end
      if((IA >= -60) &&  (IA <= 60) && (IA_retc!=0))
      begin
        outfile=$fopen(errFileName,"a");
        $strobe("dfwpsj1a_20   IA      entering SOCA ( -0.060 mA/um .. 0.060 mA/um ) at %7.4r  %M", $abstime );
        $fwrite(outfile,"dfwpsj1a_20   IA      entering SOCA ( -0.060 mA/um .. 0.060 mA/um ) at %7.4r  %M\n", $abstime );
        IA_retc=0;
        IA_cnt=IA_cnt-1;
        $fclose(outfile);
      end
      if((IA > 60) &&  (IA_retc!=1))
      begin
        outfile=$fopen(errFileName,"a");
        $strobe("dfwpsj1a_20   IA      leaving   OCA ( 0.060 mA/um ..  ) at %7.4r  %M", $abstime );
        $fwrite(outfile,"dfwpsj1a_20   IA      leaving   OCA ( 0.060 mA/um ..  ) at %7.4r  %M\n", $abstime );
        IA_retc=1;
        IA_cnt=IA_cnt-1;
        $fclose(outfile);
      end
   end
   else
   begin
      if(IA_cnt==0)
      begin
        outfile=$fopen(errFileName,"a");
        $strobe("dfwpsj1a_20   IA      error limit ( %d ) reached at %7.4r  %M", maxEv, $abstime );
        $fwrite(outfile,"dfwpsj1a_20   IA      error limit ( %d ) reached at %7.4r  %M\n", maxEv, $abstime );
        IA_cnt=IA_cnt-1;
        $fclose(outfile);
      end
   end

end // analog
endmodule // dfwpsj1a_20

// Verilog-A OC Watch for device dfwnsj1a_28 Parameters  VAC IA
module dfwnsj1a_28_ahdl(A1,C1,A,C);
parameter tstep_occ=100n;
parameter errFileName="./occ.err";
parameter area = 1u;
parameter maxEv = 25;
parameter maxEv_flg = 0;
inout A1,C1,A,C;
electrical A1,C1,A,C;

integer outfile;
real V_A_C;
real I_C;
real I_A;
real VAC;
integer VAC_retc;
integer VAC_cnt;
real IA;
integer IA_retc;
integer IA_cnt;

analog begin
   $bound_step( tstep_occ );
   @(initial_step) begin
      VAC_retc=0;
      VAC_cnt = maxEv;
      IA_retc=0;
      IA_cnt = maxEv;
   end
   V_A_C = V(A,C);
   I_C = I(C1,C);
   I_A = I(A1,A);

//      VAC
   VAC = V_A_C;
   if((VAC_cnt>0) || ( maxEv_flg==0 ))   begin
      if( (VAC < -375) && (VAC_retc!=-1))
      begin
        outfile=$fopen(errFileName,"a");
        $strobe("dfwnsj1a_28   VAC     leaving   OCA (  .. -375.000 V ) at %7.4r  %M", $abstime );
        $fwrite(outfile,"dfwnsj1a_28   VAC     leaving   OCA (  .. -375.000 V ) at %7.4r  %M\n", $abstime );
        VAC_retc=-1;
        VAC_cnt=VAC_cnt-1;
        $fclose(outfile);
      end
      if((VAC >= -375) &&  (VAC <= 1.5) && (VAC_retc!=0))
      begin
        outfile=$fopen(errFileName,"a");
        $strobe("dfwnsj1a_28   VAC     entering SOCA ( -375.000 V .. 1.500 V ) at %7.4r  %M", $abstime );
        $fwrite(outfile,"dfwnsj1a_28   VAC     entering SOCA ( -375.000 V .. 1.500 V ) at %7.4r  %M\n", $abstime );
        VAC_retc=0;
        VAC_cnt=VAC_cnt-1;
        $fclose(outfile);
      end
      if((VAC > 1.5) &&  (VAC_retc!=1))
      begin
        outfile=$fopen(errFileName,"a");
        $strobe("dfwnsj1a_28   VAC     leaving   OCA ( 1.500 V ..  ) at %7.4r  %M", $abstime );
        $fwrite(outfile,"dfwnsj1a_28   VAC     leaving   OCA ( 1.500 V ..  ) at %7.4r  %M\n", $abstime );
        VAC_retc=1;
        VAC_cnt=VAC_cnt-1;
        $fclose(outfile);
      end
   end
   else
   begin
      if(VAC_cnt==0)
      begin
        outfile=$fopen(errFileName,"a");
        $strobe("dfwnsj1a_28   VAC     error limit ( %d ) reached at %7.4r  %M", maxEv, $abstime );
        $fwrite(outfile,"dfwnsj1a_28   VAC     error limit ( %d ) reached at %7.4r  %M\n", maxEv, $abstime );
        VAC_cnt=VAC_cnt-1;
        $fclose(outfile);
      end
   end

//      IA
   IA = I_A / area / 2.8e-05;
   if((IA_cnt>0) || ( maxEv_flg==0 ))   begin
      if( (IA < -60) && (IA_retc!=-1))
      begin
        outfile=$fopen(errFileName,"a");
        $strobe("dfwnsj1a_28   IA      leaving   OCA (  .. -0.060 mA/um ) at %7.4r  %M", $abstime );
        $fwrite(outfile,"dfwnsj1a_28   IA      leaving   OCA (  .. -0.060 mA/um ) at %7.4r  %M\n", $abstime );
        IA_retc=-1;
        IA_cnt=IA_cnt-1;
        $fclose(outfile);
      end
      if((IA >= -60) &&  (IA <= 60) && (IA_retc!=0))
      begin
        outfile=$fopen(errFileName,"a");
        $strobe("dfwnsj1a_28   IA      entering SOCA ( -0.060 mA/um .. 0.060 mA/um ) at %7.4r  %M", $abstime );
        $fwrite(outfile,"dfwnsj1a_28   IA      entering SOCA ( -0.060 mA/um .. 0.060 mA/um ) at %7.4r  %M\n", $abstime );
        IA_retc=0;
        IA_cnt=IA_cnt-1;
        $fclose(outfile);
      end
      if((IA > 60) &&  (IA_retc!=1))
      begin
        outfile=$fopen(errFileName,"a");
        $strobe("dfwnsj1a_28   IA      leaving   OCA ( 0.060 mA/um ..  ) at %7.4r  %M", $abstime );
        $fwrite(outfile,"dfwnsj1a_28   IA      leaving   OCA ( 0.060 mA/um ..  ) at %7.4r  %M\n", $abstime );
        IA_retc=1;
        IA_cnt=IA_cnt-1;
        $fclose(outfile);
      end
   end
   else
   begin
      if(IA_cnt==0)
      begin
        outfile=$fopen(errFileName,"a");
        $strobe("dfwnsj1a_28   IA      error limit ( %d ) reached at %7.4r  %M", maxEv, $abstime );
        $fwrite(outfile,"dfwnsj1a_28   IA      error limit ( %d ) reached at %7.4r  %M\n", maxEv, $abstime );
        IA_cnt=IA_cnt-1;
        $fclose(outfile);
      end
   end

end // analog
endmodule // dfwnsj1a_28

// Verilog-A OC Watch for device dfwpsj1a_31 Parameters  VAC IA
module dfwpsj1a_31_ahdl(A1,C1,A,C);
parameter tstep_occ=100n;
parameter errFileName="./occ.err";
parameter area = 1u;
parameter maxEv = 25;
parameter maxEv_flg = 0;
inout A1,C1,A,C;
electrical A1,C1,A,C;

integer outfile;
real V_A_C;
real I_C;
real I_A;
real VAC;
integer VAC_retc;
integer VAC_cnt;
real IA;
integer IA_retc;
integer IA_cnt;

analog begin
   $bound_step( tstep_occ );
   @(initial_step) begin
      VAC_retc=0;
      VAC_cnt = maxEv;
      IA_retc=0;
      IA_cnt = maxEv;
   end
   V_A_C = V(A,C);
   I_C = I(C1,C);
   I_A = I(A1,A);

//      VAC
   VAC = V_A_C;
   if((VAC_cnt>0) || ( maxEv_flg==0 ))   begin
      if( (VAC < -375) && (VAC_retc!=-1))
      begin
        outfile=$fopen(errFileName,"a");
        $strobe("dfwpsj1a_31   VAC     leaving   OCA (  .. -375.000 V ) at %7.4r  %M", $abstime );
        $fwrite(outfile,"dfwpsj1a_31   VAC     leaving   OCA (  .. -375.000 V ) at %7.4r  %M\n", $abstime );
        VAC_retc=-1;
        VAC_cnt=VAC_cnt-1;
        $fclose(outfile);
      end
      if((VAC >= -375) &&  (VAC <= 1.5) && (VAC_retc!=0))
      begin
        outfile=$fopen(errFileName,"a");
        $strobe("dfwpsj1a_31   VAC     entering SOCA ( -375.000 V .. 1.500 V ) at %7.4r  %M", $abstime );
        $fwrite(outfile,"dfwpsj1a_31   VAC     entering SOCA ( -375.000 V .. 1.500 V ) at %7.4r  %M\n", $abstime );
        VAC_retc=0;
        VAC_cnt=VAC_cnt-1;
        $fclose(outfile);
      end
      if((VAC > 1.5) &&  (VAC_retc!=1))
      begin
        outfile=$fopen(errFileName,"a");
        $strobe("dfwpsj1a_31   VAC     leaving   OCA ( 1.500 V ..  ) at %7.4r  %M", $abstime );
        $fwrite(outfile,"dfwpsj1a_31   VAC     leaving   OCA ( 1.500 V ..  ) at %7.4r  %M\n", $abstime );
        VAC_retc=1;
        VAC_cnt=VAC_cnt-1;
        $fclose(outfile);
      end
   end
   else
   begin
      if(VAC_cnt==0)
      begin
        outfile=$fopen(errFileName,"a");
        $strobe("dfwpsj1a_31   VAC     error limit ( %d ) reached at %7.4r  %M", maxEv, $abstime );
        $fwrite(outfile,"dfwpsj1a_31   VAC     error limit ( %d ) reached at %7.4r  %M\n", maxEv, $abstime );
        VAC_cnt=VAC_cnt-1;
        $fclose(outfile);
      end
   end

//      IA
   IA = I_A / area / 2.8e-05;
   if((IA_cnt>0) || ( maxEv_flg==0 ))   begin
      if( (IA < -60) && (IA_retc!=-1))
      begin
        outfile=$fopen(errFileName,"a");
        $strobe("dfwpsj1a_31   IA      leaving   OCA (  .. -0.060 mA/um ) at %7.4r  %M", $abstime );
        $fwrite(outfile,"dfwpsj1a_31   IA      leaving   OCA (  .. -0.060 mA/um ) at %7.4r  %M\n", $abstime );
        IA_retc=-1;
        IA_cnt=IA_cnt-1;
        $fclose(outfile);
      end
      if((IA >= -60) &&  (IA <= 60) && (IA_retc!=0))
      begin
        outfile=$fopen(errFileName,"a");
        $strobe("dfwpsj1a_31   IA      entering SOCA ( -0.060 mA/um .. 0.060 mA/um ) at %7.4r  %M", $abstime );
        $fwrite(outfile,"dfwpsj1a_31   IA      entering SOCA ( -0.060 mA/um .. 0.060 mA/um ) at %7.4r  %M\n", $abstime );
        IA_retc=0;
        IA_cnt=IA_cnt-1;
        $fclose(outfile);
      end
      if((IA > 60) &&  (IA_retc!=1))
      begin
        outfile=$fopen(errFileName,"a");
        $strobe("dfwpsj1a_31   IA      leaving   OCA ( 0.060 mA/um ..  ) at %7.4r  %M", $abstime );
        $fwrite(outfile,"dfwpsj1a_31   IA      leaving   OCA ( 0.060 mA/um ..  ) at %7.4r  %M\n", $abstime );
        IA_retc=1;
        IA_cnt=IA_cnt-1;
        $fclose(outfile);
      end
   end
   else
   begin
      if(IA_cnt==0)
      begin
        outfile=$fopen(errFileName,"a");
        $strobe("dfwpsj1a_31   IA      error limit ( %d ) reached at %7.4r  %M", maxEv, $abstime );
        $fwrite(outfile,"dfwpsj1a_31   IA      error limit ( %d ) reached at %7.4r  %M\n", maxEv, $abstime );
        IA_cnt=IA_cnt-1;
        $fclose(outfile);
      end
   end

end // analog
endmodule // dfwpsj1a_31
